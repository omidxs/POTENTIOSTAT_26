// Point Netlist Generated on: May 26 21:03:44 2026
// Generated for: spectre
// Design Netlist Generated on: May 26 21:03:40 2026
// Design library name: FBIAS
// Design cell name: fecg_bandgap_tb
// Design view name: config
simulator lang=spectre
global 0
include "/opt/pdk/ams/410/spectre/c35/soac/soac.scs"
parameters temperature=27 VDD=3.3 VDD_PULSE=0 VDD_RISE=1u
include "/opt/pdk/ams/410/spectre/c35/processOption.scs"
include "/opt/pdk/ams/410/spectre/c35/cmos53.scs" section=cmostm
include "/opt/pdk/ams/410/spectre/c35/res.scs" section=restm
include "/opt/pdk/ams/410/spectre/c35/cap.scs" section=captm
include "/opt/pdk/ams/410/spectre/c35/bip.scs" section=biptm
include "/opt/pdk/ams/410/spectre/c35/ind.scs" section=indtm
include "/opt/pdk/ams/410/spectre/c35/esddiode.scs" section=esddiodetm

// Library name: PRIMLIB
// Cell name: rpolyhc
// View name: schematic
// Inherited view list: verilogams veriloga behavioral functional module
// schematic spectre symbol
subckt PRIMLIB_rpolyhc_schematic PLUS MINUS REF
parameters w=10u l=10u mult=1 mmw=0 cap=14.34f
    R1 (PLUS net9) rpolyh w=w l=(0.5 * l) m=mult mmw=mmw
    R2 (net9 MINUS) rpolyh w=w l=(0.5*l) m=mult mmw=mmw
    CS0 (PLUS REF) capacitor c=(1-0.5*(1+tanh(l/200/w)))*cap/2 m=mult
    CS1 (MINUS REF) capacitor c=(1-0.5*(1+tanh(l/200/w)))*cap/2 m=mult
    CM (net9 REF) capacitor c=(0.5*(1+tanh(l/200/w))*cap) m=mult
ends PRIMLIB_rpolyhc_schematic
// End of subcircuit definition.

// Library name: analogLib
// Cell name: presistor
// View name: schematic
// Inherited view list: verilogams veriloga behavioral functional module
// schematic spectre symbol
subckt analogLib_presistor_schematic PLUS MINUS
parameters c=0 r=1K a_tc1=0 a_tc2=0
    C1 (PLUS 0) capacitor c=c/2
    C2 (MINUS 0) capacitor c=c/2
    R0 (PLUS MINUS) resistor r=r tc1=a_tc1 tc2=a_tc2
ends analogLib_presistor_schematic
// End of subcircuit definition.

// Inherited view list: verilogams veriloga behavioral functional module
// schematic spectre symbol
// Library name: FBIAS
// Cell name: fecg_bandgap3_layout
// View name: av_extracted
// View type: maskLayout
subckt fecg_bandgap3_layout_av_extracted BG_REF BIAS GNDA VDDA
    c2 (\49\:Vo1 \1251\:GNDA) capacitor c=7.38939e-16
    c3 (\29\:D1 \102\:S) capacitor c=7.27323e-16
    c4 (\119\:VDDA \26\:BG_REF) capacitor c=5.18673e-16
    c5 (\1500\:GNDA \1486\:GNDA) capacitor c=1.22173e-15
    c6 (\66\:VDDA \279\:VDDA) capacitor c=5.66413e-15
    c7 (\704\:GNDA \835\:GNDA) capacitor c=3.41129e-16
    c8 (\287\:Vm1 \503\:VDDA) capacitor c=3.19444e-16
    c9 (\226\:S \534\:VDDA) capacitor c=1.62425e-17
    c10 (\1300\:GNDA \1274\:GNDA) capacitor c=5.35597e-17
    c11 (\100\:BG_REF \17\:vv) capacitor c=5.24906e-16
    c12 (\56\:Vo1 \102\:S) capacitor c=9.63938e-16
    c13 (\983\:GNDA \1040\:GNDA) capacitor c=3.18022e-16
    c14 (\116\:GNDA \230\:GNDA) capacitor c=1.6043e-17
    c15 (\148\:VDDA \279\:VDDA) capacitor c=3.29352e-16
    c16 (\29\:BG_REF \226\:S) capacitor c=6.32027e-16
    c17 (\505\:VDDA \279\:VDDA) capacitor c=3.77935e-16
    c18 (\1175\:GNDA \1251\:GNDA) capacitor c=3.41343e-17
    c19 (\62\:U \1394\:GNDA) capacitor c=6.075e-17
    c20 (\24\:vv \121\:VDDA) capacitor c=3.31616e-17
    c21 (\255\:VDDA \426\:VDDA) capacitor c=5.42665e-16
    c22 (\222\:S \509\:VDDA) capacitor c=1.06321e-17
    c23 (\249\:Vm1 \279\:VDDA) capacitor c=1.14752e-15
    c24 (VDDA \1251\:GNDA) capacitor c=8.30366e-16
    c25 (\35\:D1 \149\:S) capacitor c=6.79167e-17
    c26 (\85\:U \1486\:GNDA) capacitor c=6.18734e-17
    c27 (\178\:Vm1 \279\:VDDA) capacitor c=3.13687e-16
    c28 (\154\:VDDA \36\:BG_REF) capacitor c=3.8451e-17
    c29 (\205\:GNDA \183\:GNDA) capacitor c=3.22597e-17
    c30 (\14\:U \106\:GNDA) capacitor c=1.11651e-15
    c31 (\13\:VDDA \279\:VDDA) capacitor c=5.71111e-15
    c32 (\374\:VDDA \69\:BG_REF) capacitor c=5.36988e-16
    c33 (\1032\:GNDA \1029\:GNDA) capacitor c=8.23837e-17
    c34 (\38\:S2 \4\:vv) capacitor c=1.47495e-17
    c35 (\105\:U \366\:GNDA) capacitor c=1.132e-16
    c36 (\75\:U \798\:GNDA) capacitor c=1.14364e-16
    c37 (\236\:S \65\:VDDA) capacitor c=1.03845e-17
    c38 (\95\:U \1221\:GNDA) capacitor c=5.13367e-17
    c39 (\1355\:GNDA \1274\:GNDA) capacitor c=9.29257e-17
    c40 (\44\:S2 \716\:GNDA) capacitor c=2.42178e-16
    c41 (\27\:U \154\:GNDA) capacitor c=1.03999e-16
    c42 (\1401\:GNDA \1398\:GNDA) capacitor c=8.23837e-17
    c43 (\164\:VDDA \279\:VDDA) capacitor c=3.93776e-16
    c44 (\81\:BG_REF \236\:S) capacitor c=1.1267e-15
    c45 (\284\:VDDA \166\:Vm1) capacitor c=4.68211e-16
    c46 (\549\:GNDA \7\:Vo1) capacitor c=2.62252e-16
    c47 (\553\:VDDA \44\:S2) capacitor c=9.65359e-17
    c48 (\39\:U \488\:GNDA) capacitor c=5.82324e-17
    c49 (\550\:VDDA \534\:VDDA) capacitor c=6.28335e-16
    c50 (\28\:X \1133\:GNDA) capacitor c=1.00069e-16
    c51 (\142\:Vm1 \216\:VDDA) capacitor c=4.89293e-16
    c52 (\111\:BG_REF \279\:VDDA) capacitor c=9.52457e-16
    c53 (\1314\:GNDA \107\:U) capacitor c=3.63621e-17
    c54 (\315\:VDDA \279\:VDDA) capacitor c=3.35043e-16
    c55 (\167\:GNDA \1251\:GNDA) capacitor c=3.11265e-17
    c56 (\495\:VDDA \117\:BG_REF) capacitor c=1.98136e-16
    c57 (\117\:U \634\:GNDA) capacitor c=2.87509e-15
    c58 (\28\:vv \231\:VDDA) capacitor c=3.31616e-17
    c59 (\87\:U \1201\:GNDA) capacitor c=3.83457e-17
    c60 (\138\:VDDA \35\:BG_REF) capacitor c=2.50306e-17
    c61 (\69\:S2 \491\:VDDA) capacitor c=1.23137e-17
    c62 (\60\:BG_REF \279\:VDDA) capacitor c=1.15424e-16
    c63 (\732\:GNDA \419\:GNDA) capacitor c=4.6967e-17
    c64 (\338\:VDDA \62\:BG_REF) capacitor c=5.28947e-16
    c65 (\271\:Vm1 \133\:BG_REF) capacitor c=5.9016e-15
    c66 (\11\:S \279\:VDDA) capacitor c=1.24821e-15
    c67 (\102\:S2 \534\:VDDA) capacitor c=2.6018e-17
    c68 (\207\:GNDA \26\:U) capacitor c=3.38399e-16
    c69 (\59\:D1 \102\:S) capacitor c=4.16545e-16
    c70 (\702\:GNDA \230\:GNDA) capacitor c=5.49666e-16
    c71 (\15\:BG_REF \28\:GNDA) capacitor c=2.85382e-15
    c72 (\327\:GNDA \218\:GNDA) capacitor c=3.0491e-16
    c73 (\610\:GNDA \379\:GNDA) capacitor c=4.6967e-17
    c74 (\896\:GNDA \1006\:GNDA) capacitor c=3.40225e-17
    c75 (\81\:S \79\:S) capacitor c=1.24201e-15
    c76 (\84\:S2 \136\:BG_REF) capacitor c=1.32651e-16
    c77 (\2\:net25 \66\:GNDA) capacitor c=3.24163e-15
    c78 (\2\:net32 \85\:GNDA) capacitor c=3.81232e-16
    c79 (\110\:Vm1 \104\:VDDA) capacitor c=4.39105e-16
    c80 (\25\:U \1251\:GNDA) capacitor c=7.1556e-17
    c81 (\123\:S \134\:S) capacitor c=2.28495e-15
    c82 (\198\:S \534\:VDDA) capacitor c=1.30309e-16
    c83 (\152\:Vm1 \247\:VDDA) capacitor c=4.78212e-16
    c84 (\222\:S \279\:VDDA) capacitor c=1.28081e-15
    c85 (\544\:VDDA \535\:GNDA) capacitor c=4.09757e-17
    c86 (\339\:VDDA \279\:VDDA) capacitor c=4.01072e-16
    c87 (\44\:U \192\:GNDA) capacitor c=8.51404e-16
    c88 (\106\:U \1218\:GNDA) capacitor c=7.79155e-17
    c89 (\458\:VDDA \75\:BG_REF) capacitor c=2.34161e-16
    c90 (\65\:S2 \204\:S) capacitor c=1.34596e-15
    c91 (\19\:Vm1 \279\:VDDA) capacitor c=3.96062e-15
    c92 (\18\:S2 \15\:S2) capacitor c=5.34881e-16
    c93 (\43\:D1 \812\:GNDA) capacitor c=5.36984e-16
    c94 (\2\:net41 \63\:GNDA) capacitor c=2.44751e-17
    c95 (\716\:GNDA \1251\:GNDA) capacitor c=2.74282e-16
    c96 (\158\:VDDA \38\:BG_REF) capacitor c=3.8451e-17
    c97 (\1012\:GNDA \1251\:GNDA) capacitor c=4.19575e-17
    c98 (\115\:GNDA \218\:GNDA) capacitor c=6.77221e-15
    c99 (\14\:BIAS \7\:BIAS) capacitor c=6.32471e-16
    c100 (\128\:Vm1 \279\:VDDA) capacitor c=3.70454e-16
    c101 (\468\:VDDA \426\:VDDA) capacitor c=2.77714e-16
    c102 (\112\:VDDA \11\:VDDA) capacitor c=8.50684e-16
    c103 (\736\:GNDA \1251\:GNDA) capacitor c=6.54598e-16
    c104 (\46\:U \183\:GNDA) capacitor c=3.77148e-17
    c105 (\126\:Vm1 \177\:VDDA) capacitor c=4.76167e-16
    c106 (\73\:BG_REF \349\:VDDA) capacitor c=1.1294e-17
    c107 (\192\:GNDA \163\:GNDA) capacitor c=3.74703e-15
    c108 (\47\:U \180\:GNDA) capacitor c=4.6967e-17
    c109 (\13\:S \68\:S2) capacitor c=7.37279e-16
    c110 (\58\:U \968\:GNDA) capacitor c=1.29529e-15
    c111 (\653\:VDDA \612\:VDDA) capacitor c=5.74206e-16
    c112 (\89\:BG_REF \102\:VDDA) capacitor c=1.62207e-17
    c113 (\72\:S2 \279\:VDDA) capacitor c=2.75863e-15
    c114 (\28\:S2 \12\:D2) capacitor c=3.70858e-16
    c115 (\723\:VDDA \101\:BG_REF) capacitor c=1.10524e-15
    c116 (\348\:VDDA \63\:BG_REF) capacitor c=1.48876e-17
    c117 (\52\:U \968\:GNDA) capacitor c=2.6568e-16
    c118 (\43\:S \279\:VDDA) capacitor c=8.29648e-16
    c119 (\35\:D1 \111\:S) capacitor c=3.34655e-16
    c120 (\59\:U \1049\:GNDA) capacitor c=3.73689e-17
    c121 (\29\:Vm1 \279\:VDDA) capacitor c=3.95899e-15
    c122 (\110\:S2 \24\:Vs) capacitor c=8.25053e-16
    c123 (\267\:VDDA \31\:BG_REF) capacitor c=3.15714e-16
    c124 (\197\:VDDA \20\:S) capacitor c=1.22542e-16
    c125 (\122\:Vm1 \14\:Vm1) capacitor c=8.78761e-16
    c126 (\341\:VDDA \271\:Vm1) capacitor c=2.18118e-16
    c127 (\78\:S2 \44\:S2) capacitor c=3.67299e-16
    c128 (\31\:U \41\:U) capacitor c=1.69405e-17
    c129 (\1226\:GNDA \1320\:GNDA) capacitor c=7.85215e-17
    c130 (\1068\:GNDA \1203\:GNDA) capacitor c=7.83443e-17
    c131 (\905\:GNDA \1284\:GNDA) capacitor c=4.76307e-15
    c132 (\489\:VDDA \73\:BG_REF) capacitor c=1.89197e-16
    c133 (\11\:U \1374\:GNDA) capacitor c=3.73689e-17
    c134 (\67\:U \800\:GNDA) capacitor c=5.50084e-17
    c135 (\230\:GNDA \40\:GNDA) capacitor c=1.35943e-16
    c136 (\896\:GNDA \1403\:GNDA) capacitor c=3.77756e-15
    c137 (\175\:VDDA \279\:VDDA) capacitor c=3.3347e-16
    c138 (\550\:VDDA \279\:VDDA) capacitor c=3.32853e-16
    c139 (\248\:Vm1 \73\:S2) capacitor c=5.08078e-16
    c140 (\66\:U \1265\:GNDA) capacitor c=1.3611e-15
    c141 (\51\:GNDA \2\:net9) capacitor c=7.64638e-17
    c142 (\1557\:GNDA \898\:GNDA) capacitor c=2.92139e-16
    c143 (\101\:BG_REF \57\:VDDA) capacitor c=1.33555e-17
    c144 (\905\:GNDA \168\:GNDA) capacitor c=2.28867e-16
    c145 (\204\:S \612\:VDDA) capacitor c=5.94424e-17
    c146 (\132\:Vm1 \183\:VDDA) capacitor c=4.76167e-16
    c147 (\409\:VDDA \82\:BG_REF) capacitor c=3.89918e-17
    c148 (\21\:GNDA \218\:GNDA) capacitor c=1.20053e-15
    c149 (\54\:U \205\:GNDA) capacitor c=1.19432e-15
    c150 (\953\:GNDA \1251\:GNDA) capacitor c=3.11265e-17
    c151 (\18\:vv \279\:VDDA) capacitor c=4.82322e-15
    c152 (\2\:net36 \218\:GNDA) capacitor c=4.03862e-16
    c153 (\585\:VDDA \534\:VDDA) capacitor c=5.76859e-16
    c154 (\19\:Vs \675\:GNDA) capacitor c=1.11011e-15
    c155 (\192\:Vm1 \279\:VDDA) capacitor c=3.7428e-16
    c156 (\26\:S2 \44\:S2) capacitor c=1.54797e-16
    c157 (\222\:S \22\:vv) capacitor c=5.1104e-16
    c158 (\125\:VDDA \32\:BG_REF) capacitor c=5.18673e-16
    c159 (\39\:Vm1 \279\:VDDA) capacitor c=3.95779e-15
    c160 (\297\:Vm1 \100\:BG_REF) capacitor c=1.85761e-15
    c161 (\233\:VDDA \50\:BG_REF) capacitor c=5.28406e-16
    c162 (\89\:S \29\:Vo1) capacitor c=3.34161e-16
    c163 (\272\:Vm1 \279\:VDDA) capacitor c=2.48301e-15
    c164 (\376\:VDDA \271\:Vm1) capacitor c=2.18118e-16
    c165 (\162\:VDDA \12\:S) capacitor c=1.22557e-16
    c166 (\1362\:GNDA \449\:GNDA) capacitor c=1.33732e-17
    c167 (\202\:Vm1 \89\:Vm1) capacitor c=1.06438e-15
    c168 (\201\:VDDA \279\:VDDA) capacitor c=3.71677e-16
    c169 (\269\:VDDA \54\:BG_REF) capacitor c=3.8451e-17
    c170 (\83\:U \1259\:GNDA) capacitor c=5.82324e-17
    c171 (\34\:X \18\:Y) capacitor c=6.13116e-17
    c172 (\76\:U \1251\:GNDA) capacitor c=5.06676e-17
    c173 (\12\:Vo1 \7\:Vo1) capacitor c=1.66916e-15
    c174 (\18\:Vs \57\:S2) capacitor c=6.71138e-16
    c175 (\225\:Vm1 \105\:BG_REF) capacitor c=1.52034e-15
    c176 (\1389\:GNDA \1345\:GNDA) capacitor c=9.29257e-17
    c177 (\1553\:GNDA \21\:Vs) capacitor c=1.01493e-16
    c178 (\166\:S \684\:GNDA) capacitor c=1.79743e-16
    c179 (\31\:X \1114\:GNDA) capacitor c=1.14364e-16
    c180 (\2\:net27 \100\:GNDA) capacitor c=4.60908e-17
    c181 (\350\:VDDA \279\:VDDA) capacitor c=3.33877e-16
    c182 (\16\:vv \594\:VDDA) capacitor c=6.1755e-17
    c183 (\686\:GNDA \1251\:GNDA) capacitor c=1.49753e-15
    c184 (\51\:Vm1 \279\:VDDA) capacitor c=3.95136e-15
    c185 (\1513\:GNDA \684\:GNDA) capacitor c=4.99521e-16
    c186 (\35\:X \1117\:GNDA) capacitor c=1.61655e-16
    c187 (\860\:VDDA \131\:BG_REF) capacitor c=7.24715e-16
    c188 (\27\:Vs \535\:GNDA) capacitor c=1.93248e-16
    c189 (\222\:S \74\:S2) capacitor c=1.31551e-16
    c190 (\61\:BG_REF \236\:S) capacitor c=6.30961e-16
    c191 (\716\:GNDA \13\:vv) capacitor c=3.51933e-16
    c192 (\77\:S2 \242\:S) capacitor c=1.5671e-15
    c193 (\895\:GNDA \207\:GNDA) capacitor c=2.48266e-16
    c194 (\131\:BG_REF \279\:VDDA) capacitor c=7.30306e-16
    c195 (\1362\:GNDA \103\:U) capacitor c=3.38399e-16
    c196 (\657\:GNDA \230\:GNDA) capacitor c=1.02989e-15
    c197 (\249\:S \183\:S) capacitor c=5.54911e-16
    c198 (\9\:S \175\:VDDA) capacitor c=1.64607e-17
    c199 (\79\:BG_REF \355\:VDDA) capacitor c=1.1294e-17
    c200 (\32\:U \177\:GNDA) capacitor c=3.54052e-16
    c201 (\104\:BG_REF \534\:VDDA) capacitor c=4.88844e-17
    c202 (\914\:VDDA \594\:VDDA) capacitor c=6.41913e-15
    c203 (\1274\:GNDA \603\:GNDA) capacitor c=3.24909e-17
    c204 (\1068\:GNDA \1181\:GNDA) capacitor c=3.18334e-16
    c205 (\537\:GNDA \44\:S2) capacitor c=6.20493e-17
    c206 (\205\:GNDA \56\:U) capacitor c=3.38399e-16
    c207 (\100\:S2 \78\:S2) capacitor c=1.37305e-16
    c208 (\905\:GNDA \1415\:GNDA) capacitor c=3.64003e-15
    c209 (\276\:Vm1 \1251\:GNDA) capacitor c=3.30888e-16
    c210 (\110\:S2 \80\:S2) capacitor c=1.33054e-16
    c211 (\81\:S \23\:D1) capacitor c=2.06229e-15
    c212 (\7\:D2 \12\:BG_REF) capacitor c=8.44e-17
    c213 (\4\:U \1294\:GNDA) capacitor c=1.52412e-16
    c214 (\109\:U \373\:GNDA) capacitor c=4.10562e-17
    c215 (\58\:D1 \56\:Vo1) capacitor c=1.89017e-15
    c216 (\2\:net31 \28\:GNDA) capacitor c=6.92992e-16
    c217 (\120\:GNDA \124\:GNDA) capacitor c=1.56371e-17
    c218 (\368\:VDDA \279\:VDDA) capacitor c=3.97994e-16
    c219 (\11\:S \181\:VDDA) capacitor c=1.64607e-17
    c220 (\482\:GNDA \1251\:GNDA) capacitor c=3.22349e-17
    c221 (\1345\:GNDA \49\:U) capacitor c=3.71928e-17
    c222 (\48\:Vo1 \124\:GNDA) capacitor c=4.38793e-16
    c223 (\905\:GNDA \160\:GNDA) capacitor c=1.36307e-17
    c224 (\63\:Vm1 \279\:VDDA) capacitor c=3.9572e-15
    c225 (\240\:S \149\:S) capacitor c=2.65598e-16
    c226 (\18\:U \975\:GNDA) capacitor c=5.22083e-17
    c227 (\12\:U \1374\:GNDA) capacitor c=1.14364e-16
    c228 (\1432\:GNDA \188\:GNDA) capacitor c=3.33147e-17
    c229 (\237\:S \279\:VDDA) capacitor c=2.78755e-15
    c230 (\207\:GNDA \1374\:GNDA) capacitor c=3.77756e-15
    c231 (\897\:VDDA \272\:Vm1) capacitor c=8.64468e-16
    c232 (\35\:X \93\:U) capacitor c=8.48268e-17
    c233 (\53\:U \205\:GNDA) capacitor c=1.64726e-15
    c234 (\57\:BG_REF \322\:VDDA) capacitor c=1.36315e-17
    c235 (\27\:S2 \44\:S2) capacitor c=2.8631e-17
    c236 (\2\:net28 \2\:net13) capacitor c=4.51223e-17
    c237 (\1362\:GNDA \1472\:GNDA) capacitor c=3.39687e-17
    c238 (\1555\:GNDA \12\:Vs) capacitor c=3.90512e-16
    c239 (\124\:U \1251\:GNDA) capacitor c=4.2285e-15
    c240 (\36\:Vs \1251\:GNDA) capacitor c=3.25145e-17
    c241 (\655\:VDDA \559\:VDDA) capacitor c=5.5623e-16
    c242 (\243\:S \71\:Vo1) capacitor c=2.09937e-16
    c243 (\800\:GNDA \659\:GNDA) capacitor c=1.57532e-16
    c244 (\339\:VDDA \62\:BG_REF) capacitor c=3.8451e-17
    c245 (\529\:VDDA \528\:VDDA) capacitor c=2.09715e-16
    c246 (\29\:BIAS \6\:BIAS) capacitor c=1.04512e-15
    c247 (\745\:GNDA \1251\:GNDA) capacitor c=3.11265e-17
    c248 (\133\:BG_REF \240\:S) capacitor c=2.04489e-16
    c249 (\25\:vv \32\:D2) capacitor c=2.14966e-17
    c250 (\25\:Vo1 \149\:S) capacitor c=4.95789e-16
    c251 (\35\:X \896\:GNDA) capacitor c=4.56636e-16
    c252 (\50\:U \203\:GNDA) capacitor c=5.87952e-16
    c253 (\58\:Vo1 \193\:S) capacitor c=1.77844e-16
    c254 (\192\:GNDA \41\:U) capacitor c=3.38399e-16
    c255 (\140\:S \148\:S) capacitor c=3.31039e-16
    c256 (\87\:BG_REF \14\:S2) capacitor c=3.03957e-17
    c257 (\65\:BG_REF \279\:VDDA) capacitor c=1.50261e-15
    c258 (\399\:VDDA \72\:BG_REF) capacitor c=3.89918e-17
    c259 (\218\:Vm1 \105\:Vm1) capacitor c=1.83024e-16
    c260 (\55\:BG_REF \206\:S) capacitor c=6.30475e-16
    c261 (\88\:S2 \42\:S2) capacitor c=5.65676e-16
    c262 (\73\:Vm1 \279\:VDDA) capacitor c=3.96003e-15
    c263 (\50\:U \827\:GNDA) capacitor c=5.53929e-17
    c264 (\7\:vv \192\:VDDA) capacitor c=3.31616e-17
    c265 (\224\:VDDA \47\:BG_REF) capacitor c=5.30343e-16
    c266 (\85\:GNDA \2\:net25) capacitor c=4.97753e-17
    c267 (\162\:VDDA \31\:BG_REF) capacitor c=3.23813e-16
    c268 (\896\:GNDA \78\:U) capacitor c=7.93593e-17
    c269 (\2\:D1 \1251\:GNDA) capacitor c=1.28139e-15
    c270 (\75\:S2 \279\:VDDA) capacitor c=2.97666e-15
    c271 (\372\:VDDA \48\:S) capacitor c=1.22461e-16
    c272 (\110\:BG_REF \71\:S2) capacitor c=4.62525e-16
    c273 (\641\:GNDA \455\:GNDA) capacitor c=1.60178e-15
    c274 (\10\:D1 \48\:Vo1) capacitor c=6.66792e-16
    c275 (\210\:VDDA \279\:VDDA) capacitor c=3.32577e-16
    c276 (\627\:GNDA \431\:GNDA) capacitor c=1.59012e-15
    c277 (\52\:U \928\:GNDA) capacitor c=1.71879e-16
    c278 (\96\:U \1251\:GNDA) capacitor c=7.1556e-17
    c279 (\146\:S \131\:S) capacitor c=4.04951e-16
    c280 (\105\:BG_REF \222\:S) capacitor c=1.31405e-16
    c281 (\58\:U \954\:GNDA) capacitor c=1.09512e-16
    c282 (\71\:S2 \7\:VDDA) capacitor c=1.34744e-17
    c283 (\254\:S \58\:Vo1) capacitor c=8.66098e-16
    c284 (\1403\:GNDA \1314\:GNDA) capacitor c=9.29257e-17
    c285 (\896\:GNDA \81\:U) capacitor c=3.87469e-16
    c286 (\31\:U \172\:GNDA) capacitor c=3.54052e-16
    c287 (\756\:GNDA \753\:GNDA) capacitor c=8.23837e-17
    c288 (\222\:S \534\:VDDA) capacitor c=1.81333e-17
    c289 (\26\:vv \40\:BG_REF) capacitor c=3.40015e-17
    c290 (\34\:BG_REF \279\:VDDA) capacitor c=1.15121e-16
    c291 (\2\:Vo2 \3\:Vo1) capacitor c=9.76809e-18
    c292 (\426\:VDDA \185\:VDDA) capacitor c=5.79076e-16
    c293 (\73\:U \1313\:GNDA) capacitor c=4.09597e-16
    c294 (\438\:VDDA \437\:VDDA) capacitor c=1.82419e-16
    c295 (\80\:S2 \87\:BG_REF) capacitor c=8.89202e-17
    c296 (\99\:S \30\:D1) capacitor c=6.24816e-16
    c297 (\2\:net30 \218\:GNDA) capacitor c=3.96268e-16
    c298 (\204\:Vm1 \279\:VDDA) capacitor c=3.71744e-16
    c299 (\205\:GNDA \66\:U) capacitor c=3.38399e-16
    c300 (\33\:U \64\:U) capacitor c=1.23677e-15
    c301 (\216\:Vm1 \493\:VDDA) capacitor c=2.88285e-16
    c302 (\45\:VDDA \279\:VDDA) capacitor c=4.14238e-15
    c303 (\218\:GNDA \1251\:GNDA) capacitor c=1.62948e-14
    c304 (\187\:GNDA \188\:GNDA) capacitor c=4.12292e-16
    c305 (\720\:VDDA \100\:BG_REF) capacitor c=7.24715e-16
    c306 (\106\:GNDA \2\:net14) capacitor c=4.98168e-17
    c307 (\488\:GNDA \170\:GNDA) capacitor c=8.23837e-17
    c308 (\75\:BG_REF \442\:VDDA) capacitor c=3.13598e-16
    c309 (\87\:S \29\:Vo1) capacitor c=2.90655e-16
    c310 (\21\:vv \279\:VDDA) capacitor c=5.41559e-15
    c311 (\37\:Vo1 \35\:Vo1) capacitor c=1.24139e-15
    c312 (\98\:VDDA \33\:BG_REF) capacitor c=2.22142e-16
    c313 (\236\:S \304\:VDDA) capacitor c=1.0082e-17
    c314 (\17\:X \32\:GNDA) capacitor c=2.60269e-16
    c315 (\238\:VDDA \279\:VDDA) capacitor c=3.48994e-16
    c316 (\52\:S2 \25\:D2) capacitor c=1.41096e-16
    c317 (\21\:vv \534\:VDDA) capacitor c=4.51962e-17
    c318 (\684\:GNDA \230\:GNDA) capacitor c=3.27004e-15
    c319 (\13\:Vs \2\:Vs) capacitor c=3.96849e-16
    c320 (\902\:GNDA \1251\:GNDA) capacitor c=3.91277e-16
    c321 (\118\:U \419\:GNDA) capacitor c=2.90323e-17
    c322 (\23\:S \247\:VDDA) capacitor c=1.88243e-17
    c323 (\10\:Vm1 \279\:VDDA) capacitor c=3.92678e-15
    c324 (\63\:BG_REF \206\:S) capacitor c=6.30961e-16
    c325 (\35\:BG_REF \172\:VDDA) capacitor c=1.23738e-17
    c326 (\1159\:GNDA \6\:U) capacitor c=3.72052e-17
    c327 (\327\:VDDA \39\:VDDA) capacitor c=1.0554e-15
    c328 (\826\:GNDA \1251\:GNDA) capacitor c=4.19575e-17
    c329 (\1268\:GNDA \1265\:GNDA) capacitor c=8.23837e-17
    c330 (\385\:VDDA \279\:VDDA) capacitor c=3.34901e-16
    c331 (\37\:U \170\:GNDA) capacitor c=4.6967e-17
    c332 (\8\:Y \10\:X) capacitor c=1.63839e-17
    c333 (\63\:Vo1 \149\:S) capacitor c=6.018e-17
    c334 (\1206\:GNDA \1215\:GNDA) capacitor c=3.70876e-17
    c335 (\56\:U \826\:GNDA) capacitor c=5.82324e-17
    c336 (\203\:GNDA \449\:GNDA) capacitor c=4.40354e-15
    c337 (\32\:D2 \535\:GNDA) capacitor c=4.23017e-16
    c338 (\485\:VDDA \53\:VDDA) capacitor c=1.07205e-15
    c339 (\49\:U \512\:GNDA) capacitor c=5.82324e-17
    c340 (\804\:VDDA \279\:VDDA) capacitor c=4.15198e-16
    c341 (\117\:U \431\:GNDA) capacitor c=6.0497e-17
    c342 (\1013\:GNDA \1040\:GNDA) capacitor c=4.6967e-17
    c343 (\895\:GNDA \535\:GNDA) capacitor c=6.54836e-16
    c344 (\239\:S \19\:VDDA) capacitor c=1.34744e-17
    c345 (\2\:net38 \94\:GNDA) capacitor c=2.14043e-15
    c346 (\983\:GNDA \35\:U) capacitor c=3.71849e-17
    c347 (\136\:BG_REF \44\:S2) capacitor c=6.33604e-16
    c348 (\73\:BG_REF \45\:S) capacitor c=1.67359e-15
    c349 (\203\:GNDA \455\:GNDA) capacitor c=2.41191e-15
    c350 (\43\:Vo1 \13\:Y) capacitor c=2.39723e-17
    c351 (\100\:GNDA \218\:GNDA) capacitor c=1.2623e-14
    c352 (\111\:BG_REF \72\:S2) capacitor c=4.62525e-16
    c353 (\842\:GNDA \839\:GNDA) capacitor c=8.23837e-17
    c354 (\2\:net23 \80\:GNDA) capacitor c=1.94936e-15
    c355 (\40\:BG_REF \279\:VDDA) capacitor c=1.15424e-16
    c356 (\54\:U \207\:GNDA) capacitor c=2.38723e-15
    c357 (\497\:VDDA \66\:VDDA) capacitor c=6.64563e-16
    c358 (\238\:S \77\:S2) capacitor c=2.22721e-16
    c359 (\21\:vv \295\:VDDA) capacitor c=3.31616e-17
    c360 (\163\:S \149\:S) capacitor c=3.05549e-16
    c361 (\21\:vv \28\:S) capacitor c=2.91892e-17
    c362 (\101\:U \1117\:GNDA) capacitor c=4.6967e-17
    c363 (\28\:U \158\:GNDA) capacitor c=1.63679e-16
    c364 (\1063\:GNDA \158\:GNDA) capacitor c=3.33271e-17
    c365 (\29\:D1 \95\:S) capacitor c=3.34655e-16
    c366 (\39\:BG_REF \17\:S) capacitor c=1.96803e-15
    c367 (\69\:S \102\:S) capacitor c=5.2083e-16
    c368 (\2\:net28 \66\:GNDA) capacitor c=7.66e-16
    c369 (\86\:U \1332\:GNDA) capacitor c=7.79155e-17
    c370 (\72\:U \896\:GNDA) capacitor c=5.47526e-16
    c371 (\405\:VDDA \279\:VDDA) capacitor c=3.96231e-16
    c372 (\216\:S \71\:S2) capacitor c=1.31478e-16
    c373 (\61\:VDDA \279\:VDDA) capacitor c=5.71423e-15
    c374 (\90\:S2 \535\:GNDA) capacitor c=1.36521e-17
    c375 (\65\:BG_REF \387\:VDDA) capacitor c=3.01353e-16
    c376 (\112\:S2 \137\:BG_REF) capacitor c=4.95786e-16
    c377 (\572\:VDDA \534\:VDDA) capacitor c=2.33196e-16
    c378 (\207\:GNDA \784\:GNDA) capacitor c=3.39571e-17
    c379 (\58\:U \971\:GNDA) capacitor c=5.64553e-17
    c380 (\120\:Vm1 \164\:VDDA) capacitor c=3.38176e-16
    c381 (\407\:VDDA \79\:BG_REF) capacitor c=5.37491e-16
    c382 (\49\:GNDA \3\:GNDA) capacitor c=1.85343e-16
    c383 (\206\:Vm1 \93\:Vm1) capacitor c=1.82422e-16
    c384 (\629\:VDDA \279\:VDDA) capacitor c=3.0138e-16
    c385 (\1136\:GNDA \1114\:GNDA) capacitor c=4.02771e-17
    c386 (\804\:VDDA \29\:BG_REF) capacitor c=1.43076e-16
    c387 (\65\:S2 \594\:VDDA) capacitor c=6.1755e-17
    c388 (\397\:GNDA \413\:GNDA) capacitor c=9.29257e-17
    c389 (\182\:Vm1 \69\:Vm1) capacitor c=1.07025e-15
    c390 (\37\:S2 \7\:Vs) capacitor c=1.20319e-16
    c391 (\27\:GNDA \218\:GNDA) capacitor c=4.83288e-15
    c392 (\26\:BG_REF \5\:VDDA) capacitor c=2.14804e-17
    c393 (\102\:S2 \28\:vv) capacitor c=2.26154e-16
    c394 (\10\:X \102\:S) capacitor c=2.13084e-15
    c395 (\32\:D2 \1543\:GNDA) capacitor c=1.04322e-15
    c396 (\23\:S \9\:S2) capacitor c=1.56667e-15
    c397 (\53\:U \1215\:GNDA) capacitor c=9.7986e-17
    c398 (\1537\:GNDA \1251\:GNDA) capacitor c=1.60456e-16
    c399 (\27\:U \149\:GNDA) capacitor c=1.10121e-16
    c400 (\2\:net28 \2\:net8) capacitor c=9.78959e-16
    c401 (\120\:GNDA \1251\:GNDA) capacitor c=2.867e-16
    c402 (\581\:VDDA \279\:VDDA) capacitor c=3.30453e-16
    c403 (\14\:D1 \17\:Vo1) capacitor c=1.30498e-15
    c404 (\86\:S2 \44\:S2) capacitor c=3.72981e-16
    c405 (\131\:U \1099\:GNDA) capacitor c=1.22624e-16
    c406 (\75\:BG_REF \441\:VDDA) capacitor c=1.36071e-17
    c407 (\22\:Vo1 \20\:Vo1) capacitor c=1.24583e-15
    c408 (\69\:GNDA \49\:GNDA) capacitor c=1.23734e-17
    c409 (\79\:BG_REF \279\:VDDA) capacitor c=1.97732e-15
    c410 (\1362\:GNDA \1297\:GNDA) capacitor c=2.31665e-15
    c411 (\503\:VDDA \90\:BG_REF) capacitor c=2.22142e-16
    c412 (\2\:net10 \218\:GNDA) capacitor c=4.04366e-16
    c413 (\798\:GNDA \704\:GNDA) capacitor c=9.29257e-17
    c414 (\95\:Vm1 \96\:Vm1) capacitor c=6.44996e-16
    c415 (\192\:GNDA \178\:GNDA) capacitor c=3.76911e-15
    c416 (\44\:Vo1 \539\:GNDA) capacitor c=5.00148e-16
    c417 (\53\:D1 \18\:X) capacitor c=3.19723e-16
    c418 (\748\:VDDA \286\:Vm1) capacitor c=6.7809e-16
    c419 (\22\:Vo1 \20\:D1) capacitor c=9.03678e-16
    c420 (\8\:Vs \8\:D2) capacitor c=1.04654e-15
    c421 (\79\:BG_REF \43\:S) capacitor c=7.23054e-16
    c422 (\270\:VDDA \275\:VDDA) capacitor c=4.75166e-16
    c423 (\230\:GNDA \550\:GNDA) capacitor c=1.93881e-15
    c424 (\30\:U \167\:GNDA) capacitor c=3.54052e-16
    c425 (\604\:VDDA \279\:VDDA) capacitor c=3.16189e-15
    c426 (\1095\:GNDA \1096\:GNDA) capacitor c=4.12292e-16
    c427 (\1559\:GNDA \895\:GNDA) capacitor c=4.17871e-17
    c428 (\794\:GNDA \791\:GNDA) capacitor c=8.23837e-17
    c429 (\4\:vv \31\:S2) capacitor c=5.12641e-17
    c430 (\34\:D2 \1251\:GNDA) capacitor c=5.23974e-16
    c431 (\12\:D2 \24\:S2) capacitor c=3.03206e-17
    c432 (\78\:VDDA \77\:VDDA) capacitor c=2.01543e-16
    c433 (\14\:S \279\:VDDA) capacitor c=1.67398e-16
    c434 (\43\:Vo1 \102\:S) capacitor c=1.19021e-15
    c435 (\33\:S2 \44\:S2) capacitor c=3.60563e-16
    c436 (\178\:Vm1 \65\:Vm1) capacitor c=1.06625e-15
    c437 (\18\:vv \540\:VDDA) capacitor c=9.9614e-17
    c438 (\297\:Vm1 \534\:VDDA) capacitor c=2.38003e-16
    c439 (\218\:Vm1 \462\:VDDA) capacitor c=3.537e-16
    c440 (\298\:VDDA \164\:Vm1) capacitor c=2.19717e-16
    c441 (\126\:VDDA \31\:BG_REF) capacitor c=4.80342e-16
    c442 (\9\:S \68\:S2) capacitor c=1.53949e-15
    c443 (\237\:S \28\:vv) capacitor c=5.23282e-16
    c444 (\569\:VDDA \279\:VDDA) capacitor c=3.04763e-16
    c445 (\896\:GNDA \704\:GNDA) capacitor c=4.16716e-15
    c446 (\118\:U \95\:U) capacitor c=4.16842e-16
    c447 (\88\:S2 \34\:S2) capacitor c=8.356e-17
    c448 (\205\:GNDA \59\:U) capacitor c=7.93593e-17
    c449 (\4\:GNDA \2\:net35) capacitor c=5.94204e-17
    c450 (\216\:Vm1 \279\:VDDA) capacitor c=4.52787e-16
    c451 (\1355\:GNDA \1377\:GNDA) capacitor c=3.44242e-16
    c452 (\329\:VDDA \59\:BG_REF) capacitor c=5.38637e-16
    c453 (\25\:Vs \19\:D2) capacitor c=4.88661e-16
    c454 (\190\:VDDA \14\:S) capacitor c=5.28947e-16
    c455 (\105\:U \1405\:GNDA) capacitor c=5.74858e-17
    c456 (\1543\:GNDA \1251\:GNDA) capacitor c=7.56855e-16
    c457 (\19\:Y \183\:S) capacitor c=1.23844e-15
    c458 (\154\:GNDA \874\:GNDA) capacitor c=3.71984e-17
    c459 (\41\:BG_REF \182\:VDDA) capacitor c=1.23738e-17
    c460 (\114\:Vm1 \7\:VDDA) capacitor c=4.55576e-16
    c461 (\27\:Vs \28\:D2) capacitor c=2.0517e-15
    c462 (\1405\:GNDA \1297\:GNDA) capacitor c=4.6967e-17
    c463 (\116\:U \748\:GNDA) capacitor c=5.69047e-17
    c464 (\61\:U \1324\:GNDA) capacitor c=5.25176e-17
    c465 (\25\:Vs \1553\:GNDA) capacitor c=1.64995e-15
    c466 (\149\:GNDA \776\:GNDA) capacitor c=3.60606e-17
    c467 (\17\:vv \169\:VDDA) capacitor c=3.31616e-17
    c468 (\174\:Vm1 \61\:Vm1) capacitor c=1.06919e-15
    c469 (\131\:U \594\:VDDA) capacitor c=1.59618e-15
    c470 (\1088\:GNDA \620\:GNDA) capacitor c=3.58119e-17
    c471 (\50\:Vm1 \279\:VDDA) capacitor c=3.92623e-15
    c472 (\21\:vv \15\:S) capacitor c=1.3147e-17
    c473 (\28\:vv \32\:BG_REF) capacitor c=3.40015e-17
    c474 (\97\:S \29\:D1) capacitor c=2.05727e-15
    c475 (\73\:U \107\:U) capacitor c=1.23987e-15
    c476 (\1033\:GNDA \1034\:GNDA) capacitor c=4.12292e-16
    c477 (\116\:U \110\:GNDA) capacitor c=1.87462e-16
    c478 (\16\:U \786\:GNDA) capacitor c=6.17759e-17
    c479 (\444\:VDDA \279\:VDDA) capacitor c=3.30986e-16
    c480 (\1140\:GNDA \413\:GNDA) capacitor c=3.64551e-17
    c481 (\133\:BG_REF \466\:VDDA) capacitor c=1.03669e-17
    c482 (\319\:VDDA \318\:VDDA) capacitor c=1.82943e-16
    c483 (\2\:net40 \218\:GNDA) capacitor c=4.24473e-16
    c484 (\94\:U \1362\:GNDA) capacitor c=1.07395e-15
    c485 (\910\:VDDA \901\:VDDA) capacitor c=1.70805e-15
    c486 (\49\:Vo1 \149\:S) capacitor c=6.72229e-17
    c487 (\33\:vv \137\:BG_REF) capacitor c=7.04249e-16
    c488 (\29\:U \163\:GNDA) capacitor c=1.33964e-16
    c489 (\13\:Vs \718\:GNDA) capacitor c=3.07603e-16
    c490 (\7\:Vs \3\:vv) capacitor c=1.4005e-16
    c491 (\1095\:GNDA \1122\:GNDA) capacitor c=1.62672e-16
    c492 (\9\:vv \35\:S2) capacitor c=1.43879e-17
    c493 (\998\:GNDA \1013\:GNDA) capacitor c=3.97087e-16
    c494 (\65\:S2 \16\:vv) capacitor c=7.18058e-15
    c495 (\75\:S2 \26\:vv) capacitor c=6.88182e-15
    c496 (\826\:GNDA \823\:GNDA) capacitor c=8.23837e-17
    c497 (\12\:U \1309\:GNDA) capacitor c=4.6967e-17
    c498 (\207\:GNDA \1133\:GNDA) capacitor c=2.26367e-15
    c499 (\83\:S \26\:D1) capacitor c=1.65903e-15
    c500 (\117\:U \98\:U) capacitor c=1.13692e-16
    c501 (\243\:S \131\:S) capacitor c=2.64959e-16
    c502 (\27\:S \279\:VDDA) capacitor c=8.29028e-16
    c503 (\539\:GNDA \716\:GNDA) capacitor c=1.41065e-15
    c504 (\156\:VDDA \25\:BG_REF) capacitor c=3.23813e-16
    c505 (\116\:BG_REF \235\:S) capacitor c=1.31478e-16
    c506 (\896\:GNDA \1088\:GNDA) capacitor c=1.29434e-17
    c507 (\905\:GNDA \515\:GNDA) capacitor c=1.27072e-17
    c508 (\27\:vv \527\:VDDA) capacitor c=2.01108e-17
    c509 (\237\:Vm1 \72\:S2) capacitor c=5.23191e-16
    c510 (\205\:GNDA \746\:GNDA) capacitor c=1.33732e-17
    c511 (\48\:BG_REF \279\:VDDA) capacitor c=1.15424e-16
    c512 (\41\:U \175\:GNDA) capacitor c=1.3611e-15
    c513 (\68\:U \712\:GNDA) capacitor c=1.98382e-16
    c514 (\105\:S \102\:S) capacitor c=5.50334e-16
    c515 (\37\:Vm1 \38\:Vm1) capacitor c=6.45e-16
    c516 (\237\:Vm1 \509\:VDDA) capacitor c=3.22227e-16
    c517 (\86\:VDDA \279\:VDDA) capacitor c=4.21191e-16
    c518 (\375\:VDDA \380\:VDDA) capacitor c=4.75166e-16
    c519 (\101\:BG_REF \534\:VDDA) capacitor c=3.31255e-17
    c520 (\63\:Vo1 \102\:S) capacitor c=1.01361e-15
    c521 (\134\:GNDA \133\:GNDA) capacitor c=1.85501e-16
    c522 (\60\:U \1074\:GNDA) capacitor c=4.6967e-17
    c523 (\1262\:GNDA \1302\:GNDA) capacitor c=4.6967e-17
    c524 (\2\:net39 \2\:GNDA) capacitor c=7.83298e-17
    c525 (\460\:VDDA \279\:VDDA) capacitor c=3.86901e-16
    c526 (\29\:vv \15\:vv) capacitor c=1.12113e-16
    c527 (\17\:U \746\:GNDA) capacitor c=1.63679e-16
    c528 (\643\:VDDA \523\:VDDA) capacitor c=2.29184e-16
    c529 (\286\:Vm1 \21\:vv) capacitor c=3.1837e-16
    c530 (\103\:U \1096\:GNDA) capacitor c=1.14364e-16
    c531 (\248\:Vm1 \581\:VDDA) capacitor c=7.30256e-16
    c532 (\13\:Vo1 \7\:Vo1) capacitor c=7.00649e-15
    c533 (\174\:Vm1 \329\:VDDA) capacitor c=3.49531e-16
    c534 (\24\:vv \776\:VDDA) capacitor c=6.78444e-17
    c535 (\12\:Vo1 \13\:Vo1) capacitor c=1.75587e-16
    c536 (\160\:Vm1 \279\:VDDA) capacitor c=3.70428e-16
    c537 (\34\:vv \635\:VDDA) capacitor c=1.98007e-16
    c538 (\92\:U \938\:GNDA) capacitor c=5.13367e-17
    c539 (\961\:GNDA \975\:GNDA) capacitor c=3.13925e-16
    c540 (\1024\:GNDA \26\:U) capacitor c=3.71778e-17
    c541 (\135\:BG_REF \218\:GNDA) capacitor c=5.90947e-16
    c542 (\6\:U \1309\:GNDA) capacitor c=4.6967e-17
    c543 (\45\:U \192\:GNDA) capacitor c=1.62282e-15
    c544 (\79\:S \21\:D1) capacitor c=2.90655e-16
    c545 (\238\:S \553\:VDDA) capacitor c=1.97196e-16
    c546 (\117\:U \203\:GNDA) capacitor c=4.69366e-15
    c547 (\71\:S2 \534\:VDDA) capacitor c=4.5184e-17
    c548 (\1195\:GNDA \1167\:GNDA) capacitor c=4.83033e-17
    c549 (\1105\:GNDA \1006\:GNDA) capacitor c=3.58918e-17
    c550 (\54\:Vo1 \50\:S) capacitor c=4.82638e-17
    c551 (\288\:VDDA \287\:VDDA) capacitor c=1.82419e-16
    c552 (\408\:VDDA \82\:BG_REF) capacitor c=5.28406e-16
    c553 (\540\:VDDA \90\:BG_REF) capacitor c=4.32184e-16
    c554 (\74\:S2 \548\:VDDA) capacitor c=2.34834e-16
    c555 (\444\:VDDA \443\:VDDA) capacitor c=1.82419e-16
    c556 (\480\:VDDA \279\:VDDA) capacitor c=2.65004e-16
    c557 (\207\:S \17\:vv) capacitor c=5.23619e-16
    c558 (\58\:U \823\:GNDA) capacitor c=4.6967e-17
    c559 (\476\:GNDA \160\:GNDA) capacitor c=8.23837e-17
    c560 (\2\:net30 \2\:net9) capacitor c=9.4841e-16
    c561 (\21\:D2 \1251\:GNDA) capacitor c=5.12898e-16
    c562 (\207\:GNDA \1472\:GNDA) capacitor c=3.34186e-17
    c563 (\454\:VDDA \71\:BG_REF) capacitor c=2.34161e-16
    c564 (\237\:S \577\:VDDA) capacitor c=1.68174e-16
    c565 (\32\:D2 \548\:VDDA) capacitor c=5.42485e-17
    c566 (\32\:U \178\:GNDA) capacitor c=1.63679e-16
    c567 (\278\:VDDA \279\:VDDA) capacitor c=3.29407e-16
    c568 (\192\:GNDA \49\:U) capacitor c=3.38399e-16
    c569 (\112\:S2 \553\:VDDA) capacitor c=3.07905e-16
    c570 (\65\:S2 \63\:BG_REF) capacitor c=1.11867e-17
    c571 (\81\:BG_REF \447\:VDDA) capacitor c=1.36071e-17
    c572 (\35\:vv \44\:S2) capacitor c=1.05577e-17
    c573 (\12\:BG_REF \12\:vv) capacitor c=1.62569e-16
    c574 (\2\:net1 \2\:net8) capacitor c=3.82704e-17
    c575 (\52\:BG_REF \279\:VDDA) capacitor c=1.15424e-16
    c576 (\2\:net35 \80\:GNDA) capacitor c=1.80631e-16
    c577 (\114\:Vm1 \158\:VDDA) capacitor c=3.38176e-16
    c578 (\34\:vv \58\:BG_REF) capacitor c=3.31616e-17
    c579 (\397\:VDDA \47\:VDDA) capacitor c=1.0554e-15
    c580 (\97\:U \935\:GNDA) capacitor c=4.6967e-17
    c581 (\133\:VDDA \279\:VDDA) capacitor c=3.35606e-16
    c582 (\287\:Vm1 \540\:VDDA) capacitor c=2.80411e-16
    c583 (\29\:D1 \105\:S) capacitor c=4.91647e-16
    c584 (\155\:VDDA \10\:S) capacitor c=5.28947e-16
    c585 (\84\:U \1430\:GNDA) capacitor c=6.78232e-17
    c586 (\33\:S \72\:S2) capacitor c=6.20026e-16
    c587 (\905\:GNDA \983\:GNDA) capacitor c=4.79507e-15
    c588 (\497\:VDDA \279\:VDDA) capacitor c=2.51763e-16
    c589 (\88\:BG_REF \417\:VDDA) capacitor c=2.23856e-16
    c590 (\366\:VDDA \73\:BG_REF) capacitor c=3.23795e-16
    c591 (\205\:GNDA \1374\:GNDA) capacitor c=1.33732e-17
    c592 (\425\:GNDA \437\:GNDA) capacitor c=9.29257e-17
    c593 (\69\:S \28\:Vo1) capacitor c=7.39624e-17
    c594 (\37\:BG_REF \23\:S) capacitor c=1.03344e-15
    c595 (\2\:net23 \218\:GNDA) capacitor c=4.04064e-16
    c596 (\35\:X \1\:GNDA) capacitor c=4.1933e-16
    c597 (\738\:GNDA \786\:GNDA) capacitor c=3.40165e-16
    c598 (\452\:VDDA \51\:VDDA) capacitor c=1.0554e-15
    c599 (\751\:VDDA \279\:VDDA) capacitor c=4.20519e-16
    c600 (\24\:Vs \12\:vv) capacitor c=2.72377e-16
    c601 (\183\:GNDA \185\:GNDA) capacitor c=3.14499e-16
    c602 (\134\:BG_REF \257\:VDDA) capacitor c=2.04887e-17
    c603 (\669\:GNDA \905\:GNDA) capacitor c=8.02575e-17
    c604 (\33\:vv \553\:VDDA) capacitor c=4.36583e-16
    c605 (\103\:S2 \45\:BG_REF) capacitor c=1.11867e-17
    c606 (\43\:Vo1 \119\:S) capacitor c=3.34161e-16
    c607 (\34\:vv \97\:VDDA) capacitor c=3.48772e-17
    c608 (\275\:Vm1 \1251\:GNDA) capacitor c=1.3109e-15
    c609 (\389\:VDDA \77\:BG_REF) capacitor c=1.48876e-17
    c610 (\15\:Vs \1251\:GNDA) capacitor c=1.64628e-16
    c611 (\1362\:GNDA \71\:U) capacitor c=1.10922e-15
    c612 (\126\:GNDA \1251\:GNDA) capacitor c=3.6078e-16
    c613 (\225\:Vm1 \22\:vv) capacitor c=3.18761e-16
    c614 (\203\:GNDA \425\:GNDA) capacitor c=4.40624e-15
    c615 (\534\:GNDA \535\:GNDA) capacitor c=5.88613e-16
    c616 (\66\:S2 \665\:VDDA) capacitor c=5.0707e-16
    c617 (\98\:Vm1 \279\:VDDA) capacitor c=3.92678e-15
    c618 (\158\:Vm1 \269\:VDDA) capacitor c=3.46264e-16
    c619 (\22\:vv \534\:VDDA) capacitor c=1.60912e-16
    c620 (\75\:S2 \832\:VDDA) capacitor c=4.32694e-16
    c621 (\641\:GNDA \467\:GNDA) capacitor c=4.6967e-17
    c622 (\39\:S \352\:VDDA) capacitor c=1.85729e-17
    c623 (\390\:GNDA \385\:GNDA) capacitor c=5.4539e-17
    c624 (\120\:Vm1 \279\:VDDA) capacitor c=6.11746e-16
    c625 (\102\:S2 \497\:VDDA) capacitor c=1.23137e-17
    c626 (\19\:Vo1 \131\:GNDA) capacitor c=1.00678e-17
    c627 (\203\:GNDA \401\:GNDA) capacitor c=3.58533e-15
    c628 (\25\:D2 \87\:BG_REF) capacitor c=1.07199e-16
    c629 (\1432\:GNDA \1447\:GNDA) capacitor c=4.6967e-17
    c630 (\19\:GNDA \218\:GNDA) capacitor c=5.36383e-17
    c631 (\299\:VDDA \34\:S) capacitor c=5.29488e-16
    c632 (\2\:net26 \218\:GNDA) capacitor c=3.88535e-16
    c633 (\274\:VDDA \272\:VDDA) capacitor c=4.84335e-16
    c634 (\105\:U \534\:GNDA) capacitor c=1.44126e-16
    c635 (\1553\:GNDA \1251\:GNDA) capacitor c=7.34458e-16
    c636 (\21\:Vs \134\:GNDA) capacitor c=1.46716e-16
    c637 (\2\:net29 \1\:GNDA) capacitor c=3.99807e-17
    c638 (\645\:VDDA \279\:VDDA) capacitor c=3.03423e-16
    c639 (\512\:GNDA \190\:GNDA) capacitor c=8.23837e-17
    c640 (\2\:net27 \2\:net14) capacitor c=1.16606e-15
    c641 (\330\:VDDA \38\:S) capacitor c=5.28947e-16
    c642 (\7\:BIAS \1251\:GNDA) capacitor c=9.75164e-16
    c643 (\31\:S \279\:VDDA) capacitor c=8.29179e-16
    c644 (\16\:BG_REF \28\:GNDA) capacitor c=1.40632e-15
    c645 (\51\:Vo1 \117\:GNDA) capacitor c=3.02746e-17
    c646 (\12\:D2 \6\:S2) capacitor c=2.28029e-17
    c647 (\20\:GNDA \19\:GNDA) capacitor c=7.67775e-17
    c648 (BG_REF \279\:VDDA) capacitor c=1.46336e-17
    c649 (\56\:BG_REF \279\:VDDA) capacitor c=1.15424e-16
    c650 (\9\:U \1309\:GNDA) capacitor c=7.79155e-17
    c651 (\12\:vv \3\:Vs) capacitor c=2.85522e-17
    c652 (\100\:U \996\:GNDA) capacitor c=3.73689e-17
    c653 (\8\:D2 \44\:S2) capacitor c=9.47082e-16
    c654 (\7\:D2 \29\:S2) capacitor c=7.15865e-16
    c655 (\144\:VDDA \279\:VDDA) capacitor c=3.29352e-16
    c656 (\397\:GNDA \401\:GNDA) capacitor c=3.31504e-16
    c657 (\220\:Vm1 \66\:VDDA) capacitor c=2.90616e-16
    c658 (\6\:D1 \1251\:GNDA) capacitor c=2.02234e-15
    c659 (\40\:U \173\:GNDA) capacitor c=3.73689e-17
    c660 (\31\:Vo1 \230\:GNDA) capacitor c=1.39458e-16
    c661 (\501\:VDDA \279\:VDDA) capacitor c=4.12385e-16
    c662 (\1557\:GNDA \1251\:GNDA) capacitor c=1.78693e-16
    c663 (\83\:U \1256\:GNDA) capacitor c=1.3611e-15
    c664 (\20\:U \1006\:GNDA) capacitor c=4.51543e-17
    c665 (\225\:Vm1 \279\:VDDA) capacitor c=1.14754e-15
    c666 (\93\:U \101\:U) capacitor c=1.69405e-17
    c667 (\7\:U \1403\:GNDA) capacitor c=1.98382e-16
    c668 (\1430\:GNDA \1403\:GNDA) capacitor c=5.35597e-17
    c669 (\174\:Vm1 \279\:VDDA) capacitor c=3.71141e-16
    c670 (\19\:vv \44\:BG_REF) capacitor c=3.40015e-17
    c671 (\21\:S2 \25\:S2) capacitor c=4.55374e-17
    c672 (\1362\:GNDA \101\:U) capacitor c=3.38399e-16
    c673 (\9\:VDDA \279\:VDDA) capacitor c=5.71111e-15
    c674 (\1114\:GNDA \1133\:GNDA) capacitor c=3.15482e-16
    c675 (\896\:GNDA \1486\:GNDA) capacitor c=2.75915e-15
    c676 (\5\:BIAS \4\:BIAS) capacitor c=3.872e-16
    c677 (\3\:BIAS \1251\:GNDA) capacitor c=1.47088e-15
    c678 (\617\:VDDA \66\:S2) capacitor c=9.64943e-17
    c679 (\74\:S2 \25\:vv) capacitor c=6.22643e-15
    c680 (\35\:X \1251\:GNDA) capacitor c=5.72215e-16
    c681 (\105\:S \37\:Vo1) capacitor c=1.6989e-15
    c682 (\92\:U \437\:GNDA) capacitor c=1.88438e-16
    c683 (\30\:U \39\:U) capacitor c=1.69405e-17
    c684 (\230\:GNDA \7\:Vo1) capacitor c=8.41745e-17
    c685 (\29\:BIAS \1251\:GNDA) capacitor c=8.02793e-16
    c686 (\30\:S2 \8\:D2) capacitor c=4.39348e-17
    c687 (\34\:Vo1 \32\:D1) capacitor c=5.30583e-16
    c688 (\85\:U \203\:GNDA) capacitor c=2.19463e-17
    c689 (\160\:VDDA \279\:VDDA) capacitor c=3.93776e-16
    c690 (\319\:VDDA \67\:BG_REF) capacitor c=2.84294e-16
    c691 (\26\:D2 \12\:Vs) capacitor c=1.15887e-16
    c692 (\896\:GNDA \19\:U) capacitor c=8.47677e-16
    c693 (\237\:S \860\:VDDA) capacitor c=3.90385e-16
    c694 (\2\:net23 \94\:GNDA) capacitor c=9.40575e-17
    c695 (\905\:GNDA \1251\:GNDA) capacitor c=2.84245e-14
    c696 (\207\:GNDA \928\:GNDA) capacitor c=3.74074e-15
    c697 (\8\:U \1472\:GNDA) capacitor c=1.3699e-16
    c698 (\896\:GNDA \28\:X) capacitor c=6.4088e-16
    c699 (\212\:Vm1 \489\:VDDA) capacitor c=2.88285e-16
    c700 (\35\:U \476\:GNDA) capacitor c=5.82324e-17
    c701 (\2\:net2 \51\:GNDA) capacitor c=7.22945e-16
    c702 (\158\:Vm1 \253\:VDDA) capacitor c=4.66304e-16
    c703 (\101\:BG_REF \279\:VDDA) capacitor c=9.52457e-16
    c704 (\3\:Vo1 \1251\:GNDA) capacitor c=7.83004e-17
    c705 (\17\:D2 \146\:GNDA) capacitor c=9.17149e-16
    c706 (\923\:VDDA \594\:VDDA) capacitor c=6.09207e-15
    c707 (\550\:GNDA \9\:Vo1) capacitor c=4.23933e-17
    c708 (\140\:GNDA \1251\:GNDA) capacitor c=3.83649e-16
    c709 (\38\:U \488\:GNDA) capacitor c=1.60051e-16
    c710 (\102\:U \1125\:GNDA) capacitor c=1.60051e-16
    c711 (\1362\:GNDA \1314\:GNDA) capacitor c=3.22597e-17
    c712 (\2\:Vo2 \149\:S) capacitor c=2.85387e-17
    c713 (\5\:Vm1 \279\:VDDA) capacitor c=3.95631e-15
    c714 (\2\:net14 \93\:GNDA) capacitor c=2.15344e-15
    c715 (\889\:GNDA \935\:GNDA) capacitor c=1.59916e-16
    c716 (\205\:GNDA \1079\:GNDA) capacitor c=2.31665e-15
    c717 (\134\:BG_REF \27\:VDDA) capacitor c=1.03845e-17
    c718 (\33\:X \539\:GNDA) capacitor c=1.11936e-15
    c719 (\728\:GNDA \539\:GNDA) capacitor c=3.29039e-16
    c720 (\91\:S \32\:Vo1) capacitor c=6.24816e-16
    c721 (\192\:GNDA \193\:GNDA) capacitor c=4.19864e-15
    c722 (\8\:Vs \21\:S2) capacitor c=2.99339e-16
    c723 (\4\:Vo2 \718\:GNDA) capacitor c=7.54018e-16
    c724 (\539\:GNDA \16\:BG_REF) capacitor c=3.59232e-16
    c725 (\247\:VDDA \37\:BG_REF) capacitor c=2.8742e-16
    c726 (\37\:BG_REF \279\:VDDA) capacitor c=1.34745e-15
    c727 (\18\:BG_REF \230\:GNDA) capacitor c=1.79853e-16
    c728 (\1374\:GNDA \1398\:GNDA) capacitor c=3.15482e-16
    c729 (\104\:U \1273\:GNDA) capacitor c=3.54052e-16
    c730 (\138\:GNDA \5\:Vs) capacitor c=2.0458e-16
    c731 (\400\:VDDA \74\:BG_REF) capacitor c=5.28406e-16
    c732 (\218\:Vm1 \446\:VDDA) capacitor c=4.6299e-16
    c733 (\176\:Vm1 \315\:VDDA) capacitor c=4.74167e-16
    c734 (\2\:net33 \51\:GNDA) capacitor c=2.5288e-15
    c735 (\62\:U \535\:GNDA) capacitor c=4.41005e-16
    c736 (\28\:Vo1 \26\:Vo1) capacitor c=1.24459e-15
    c737 (\207\:S \720\:VDDA) capacitor c=3.90385e-16
    c738 (\11\:D2 \44\:S2) capacitor c=7.76378e-17
    c739 (\1237\:GNDA \1256\:GNDA) capacitor c=1.62672e-16
    c740 (\2\:net8 \218\:GNDA) capacitor c=3.93861e-16
    c741 (\19\:vv \117\:VDDA) capacitor c=3.31616e-17
    c742 (\208\:S \279\:VDDA) capacitor c=1.09416e-15
    c743 (\205\:GNDA \1024\:GNDA) capacitor c=4.23791e-15
    c744 (\590\:VDDA \230\:GNDA) capacitor c=3.0463e-16
    c745 (\38\:S2 \7\:S2) capacitor c=9.97089e-17
    c746 (\52\:U \24\:U) capacitor c=1.23524e-15
    c747 (\335\:VDDA \279\:VDDA) capacitor c=4.00809e-16
    c748 (\16\:vv \204\:S) capacitor c=4.72092e-16
    c749 (\6\:U \1236\:GNDA) capacitor c=5.82324e-17
    c750 (\192\:GNDA \776\:GNDA) capacitor c=3.60058e-17
    c751 (\1557\:GNDA \534\:GNDA) capacitor c=1.11005e-17
    c752 (\103\:S2 \41\:BG_REF) capacitor c=1.11867e-17
    c753 (\15\:Vm1 \279\:VDDA) capacitor c=3.95901e-15
    c754 (\92\:VDDA \27\:BG_REF) capacitor c=2.22142e-16
    c755 (\53\:D1 \149\:S) capacitor c=1.00944e-16
    c756 (\12\:vv \15\:S2) capacitor c=2.85522e-17
    c757 (\70\:BG_REF \279\:VDDA) capacitor c=1.15424e-16
    c758 (\9\:vv \4\:vv) capacitor c=3.0021e-16
    c759 (\360\:VDDA \426\:VDDA) capacitor c=5.50843e-16
    c760 (\216\:S \585\:VDDA) capacitor c=1.2299e-16
    c761 (\20\:GNDA \2\:net22) capacitor c=1.30117e-17
    c762 (\34\:X \2\:net11) capacitor c=2.78498e-16
    c763 (BG_REF \550\:GNDA) capacitor c=5.04199e-16
    c764 (\583\:VDDA \230\:GNDA) capacitor c=2.77463e-16
    c765 (BG_REF \534\:VDDA) capacitor c=1.42529e-16
    c766 (\124\:Vm1 \279\:VDDA) capacitor c=3.73738e-16
    c767 (\1068\:GNDA \1018\:GNDA) capacitor c=9.29257e-17
    c768 (\2\:net35 \10\:GNDA) capacitor c=1.57189e-16
    c769 (\37\:U \165\:GNDA) capacitor c=1.29529e-15
    c770 (\216\:S \534\:VDDA) capacitor c=4.5184e-17
    c771 (\49\:Vm1 \50\:Vm1) capacitor c=6.46758e-16
    c772 (\69\:BG_REF \392\:VDDA) capacitor c=1.35815e-17
    c773 (\1362\:GNDA \100\:U) capacitor c=7.93593e-17
    c774 (\237\:S \114\:VDDA) capacitor c=2.04887e-17
    c775 (\27\:Vs \537\:GNDA) capacitor c=9.70667e-17
    c776 (\1273\:GNDA \1251\:GNDA) capacitor c=3.11265e-17
    c777 (\961\:GNDA \99\:U) capacitor c=3.59294e-17
    c778 (\17\:D1 \60\:S) capacitor c=3.34828e-16
    c779 (\27\:X \1251\:GNDA) capacitor c=1.76526e-16
    c780 (\184\:Vm1 \339\:VDDA) capacitor c=3.49531e-16
    c781 (\120\:Vm1 \11\:Vm1) capacitor c=1.79353e-16
    c782 (\577\:VDDA \230\:GNDA) capacitor c=2.71458e-16
    c783 (\37\:Vo1 \113\:S) capacitor c=2.23582e-16
    c784 (\108\:U \1297\:GNDA) capacitor c=8.85297e-17
    c785 (\34\:Vo1 \149\:S) capacitor c=5.20567e-17
    c786 (\4\:U \10\:U) capacitor c=1.31814e-15
    c787 (\67\:S2 \279\:VDDA) capacitor c=2.75117e-15
    c788 (\82\:U \1259\:GNDA) capacitor c=1.60051e-16
    c789 (\77\:U \890\:GNDA) capacitor c=3.88004e-17
    c790 (\39\:S \279\:VDDA) capacitor c=1.93828e-15
    c791 (\49\:BG_REF \237\:S) capacitor c=6.28056e-16
    c792 (\19\:U \26\:U) capacitor c=1.63745e-17
    c793 (\117\:U \455\:GNDA) capacitor c=4.77968e-17
    c794 (\627\:VDDA \103\:S2) capacitor c=9.64943e-17
    c795 (\482\:VDDA \81\:BG_REF) capacitor c=1.56999e-16
    c796 (\216\:S \106\:VDDA) capacitor c=1.00279e-17
    c797 (\69\:Vo1 \279\:S) capacitor c=8.43541e-16
    c798 (\35\:D1 \105\:S) capacitor c=7.35313e-17
    c799 (\80\:S2 \7\:D2) capacitor c=2.61585e-17
    c800 (\14\:D1 \1251\:GNDA) capacitor c=1.03302e-15
    c801 (\72\:S2 \67\:BG_REF) capacitor c=1.11867e-17
    c802 (\572\:VDDA \230\:GNDA) capacitor c=2.66206e-16
    c803 (\43\:BG_REF \207\:S) capacitor c=6.30485e-16
    c804 (\954\:GNDA \784\:GNDA) capacitor c=9.29257e-17
    c805 (\192\:GNDA \34\:U) capacitor c=7.93593e-17
    c806 (\313\:VDDA \312\:VDDA) capacitor c=1.82943e-16
    c807 (\37\:U \482\:GNDA) capacitor c=5.64553e-17
    c808 (\120\:VDDA \25\:BG_REF) capacitor c=4.80342e-16
    c809 (\2\:net6 \28\:GNDA) capacitor c=8.05193e-16
    c810 (\47\:S2 \539\:GNDA) capacitor c=2.23334e-16
    c811 (\30\:U \1251\:GNDA) capacitor c=9.18807e-16
    c812 (\103\:U \1117\:GNDA) capacitor c=4.6967e-17
    c813 (\896\:GNDA \29\:X) capacitor c=1.69154e-16
    c814 (\546\:VDDA \279\:VDDA) capacitor c=3.53208e-16
    c815 (\65\:BG_REF \386\:VDDA) capacitor c=1.35815e-17
    c816 (\35\:X \1175\:GNDA) capacitor c=5.19237e-17
    c817 (\208\:VDDA \47\:BG_REF) capacitor c=2.2657e-17
    c818 (\619\:VDDA \72\:VDDA) capacitor c=7.65078e-16
    c819 (\65\:BG_REF \39\:S) capacitor c=1.96858e-15
    c820 (\35\:BG_REF \207\:S) capacitor c=6.30485e-16
    c821 (\71\:BG_REF \438\:VDDA) capacitor c=3.13598e-16
    c822 (\113\:S \11\:X) capacitor c=1.63729e-16
    c823 (\198\:S \52\:D1) capacitor c=5.40833e-16
    c824 (\546\:VDDA \534\:VDDA) capacitor c=3.57433e-16
    c825 (\2\:net21 \100\:GNDA) capacitor c=2.66933e-16
    c826 (\53\:U \1049\:GNDA) capacitor c=1.63679e-16
    c827 (\188\:Vm1 \279\:VDDA) capacitor c=3.7428e-16
    c828 (\221\:Vm1 \1251\:GNDA) capacitor c=2.99216e-16
    c829 (\149\:S \718\:GNDA) capacitor c=1.85335e-16
    c830 (\53\:D1 \7\:S) capacitor c=8.0976e-17
    c831 (\65\:U \1251\:GNDA) capacitor c=1.08925e-16
    c832 (\29\:VDDA \279\:VDDA) capacitor c=4.1387e-15
    c833 (\13\:Vs \10\:Vs) capacitor c=2.48861e-16
    c834 (\325\:VDDA \426\:VDDA) capacitor c=5.73521e-16
    c835 (\896\:GNDA \1215\:GNDA) capacitor c=3.40739e-17
    c836 (\203\:GNDA \1324\:GNDA) capacitor c=1.15778e-16
    c837 (\53\:U \1251\:GNDA) capacitor c=1.77826e-15
    c838 (\1495\:GNDA \1481\:GNDA) capacitor c=1.2226e-15
    c839 (\82\:BG_REF \279\:VDDA) capacitor c=1.15424e-16
    c840 (\34\:vv \198\:VDDA) capacitor c=3.31616e-17
    c841 (\370\:VDDA \67\:BG_REF) capacitor c=5.36988e-16
    c842 (\275\:Vm1 \809\:GNDA) capacitor c=3.03246e-17
    c843 (\259\:Vm1 \279\:VDDA) capacitor c=1.01334e-15
    c844 (\25\:Vo1 \230\:GNDA) capacitor c=1.77223e-16
    c845 (\26\:vv \25\:S) capacitor c=1.3147e-17
    c846 (\203\:GNDA \659\:GNDA) capacitor c=1.34848e-16
    c847 (\69\:U \960\:GNDA) capacitor c=4.06727e-16
    c848 (\896\:GNDA \839\:GNDA) capacitor c=2.31665e-15
    c849 (\288\:VDDA \57\:BG_REF) capacitor c=1.35399e-17
    c850 (\643\:VDDA \22\:vv) capacitor c=3.68092e-16
    c851 (\50\:S2 \23\:D2) capacitor c=1.35031e-16
    c852 (\1515\:GNDA \1513\:GNDA) capacitor c=1.20786e-17
    c853 (\8\:U \207\:GNDA) capacitor c=1.1604e-15
    c854 (\25\:U \1032\:GNDA) capacitor c=1.60051e-16
    c855 (\5\:U \1236\:GNDA) capacitor c=1.60051e-16
    c856 (\29\:BG_REF \144\:VDDA) capacitor c=2.89826e-16
    c857 (\272\:Vm1 \134\:BG_REF) capacitor c=5.42306e-15
    c858 (\72\:S2 \534\:VDDA) capacitor c=7.20441e-17
    c859 (\20\:BG_REF \550\:GNDA) capacitor c=2.46439e-15
    c860 (\18\:BG_REF \20\:BG_REF) capacitor c=3.40884e-16
    c861 (\17\:vv \309\:VDDA) capacitor c=3.31616e-17
    c862 (\206\:S \65\:S2) capacitor c=6.45019e-15
    c863 (\960\:GNDA \975\:GNDA) capacitor c=1.59891e-16
    c864 (\1430\:GNDA \1251\:GNDA) capacitor c=4.19575e-17
    c865 (\116\:U \467\:GNDA) capacitor c=1.37364e-16
    c866 (\145\:GNDA \144\:GNDA) capacitor c=1.26822e-17
    c867 (\758\:GNDA \535\:GNDA) capacitor c=7.85134e-16
    c868 (\489\:VDDA \57\:VDDA) capacitor c=1.86343e-16
    c869 (\72\:U \1251\:GNDA) capacitor c=9.05963e-16
    c870 (\751\:VDDA \69\:S2) capacitor c=1.74428e-16
    c871 (\591\:GNDA \1251\:GNDA) capacitor c=8.75764e-16
    c872 (\113\:S \35\:D1) capacitor c=2.06354e-15
    c873 (\222\:S \61\:VDDA) capacitor c=1.03845e-17
    c874 (\905\:GNDA \1320\:GNDA) capacitor c=5.60043e-15
    c875 (\33\:VDDA \279\:VDDA) capacitor c=4.14673e-15
    c876 (\35\:X \80\:U) capacitor c=4.74859e-17
    c877 (\40\:Vo1 \32\:D1) capacitor c=5.31661e-16
    c878 (\73\:U \86\:U) capacitor c=1.12841e-16
    c879 (\108\:VDDA \7\:VDDA) capacitor c=8.50684e-16
    c880 (\172\:Vm1 \298\:VDDA) capacitor c=3.00854e-16
    c881 (\31\:U \175\:GNDA) capacitor c=1.54869e-17
    c882 (\107\:U \1297\:GNDA) capacitor c=4.6967e-17
    c883 (\120\:Vm1 \128\:VDDA) capacitor c=3.44656e-16
    c884 (\116\:BG_REF \279\:VDDA) capacitor c=7.30306e-16
    c885 (\29\:GNDA \218\:GNDA) capacitor c=9.12889e-15
    c886 (\222\:VDDA \279\:VDDA) capacitor c=2.75667e-16
    c887 (\194\:Vm1 \372\:VDDA) capacitor c=3.47479e-16
    c888 (\94\:U \1125\:GNDA) capacitor c=6.78232e-17
    c889 (\1383\:GNDA \1302\:GNDA) capacitor c=4.6967e-17
    c890 (\670\:GNDA \1251\:GNDA) capacitor c=9.39656e-16
    c891 (\3\:U \1214\:GNDA) capacitor c=1.54324e-16
    c892 (\217\:S \491\:VDDA) capacitor c=2.04858e-17
    c893 (\9\:vv \7\:Vs) capacitor c=1.36995e-17
    c894 (\276\:Vm1 \535\:GNDA) capacitor c=1.56366e-17
    c895 (\261\:VDDA \27\:S) capacitor c=1.28262e-16
    c896 (\207\:GNDA \12\:U) capacitor c=3.38399e-16
    c897 (\17\:vv \272\:VDDA) capacitor c=3.40015e-17
    c898 (\2\:net8 \66\:GNDA) capacitor c=2.58328e-15
    c899 (\1362\:GNDA \1009\:GNDA) capacitor c=2.31665e-15
    c900 (\129\:S \102\:S) capacitor c=4.86275e-16
    c901 (\104\:U \1251\:GNDA) capacitor c=1.1743e-15
    c902 (\455\:VDDA \475\:VDDA) capacitor c=5.18716e-16
    c903 (\118\:U \106\:U) capacitor c=1.12841e-16
    c904 (\65\:VDDA \66\:VDDA) capacitor c=6.69821e-16
    c905 (\68\:U \704\:GNDA) capacitor c=5.64952e-17
    c906 (\73\:BG_REF \57\:VDDA) capacitor c=1.33555e-17
    c907 (\203\:GNDA \397\:GNDA) capacitor c=4.50862e-15
    c908 (\2\:net27 \218\:GNDA) capacitor c=6.17569e-16
    c909 (\116\:U \2\:net10) capacitor c=5.81355e-17
    c910 (\364\:VDDA \279\:VDDA) capacitor c=3.97994e-16
    c911 (\302\:VDDA \35\:S) capacitor c=1.28247e-16
    c912 (\25\:Vs \895\:GNDA) capacitor c=1.29749e-16
    c913 (\37\:X \28\:X) capacitor c=1.4378e-16
    c914 (\39\:S \69\:S2) capacitor c=5.80839e-16
    c915 (\73\:BG_REF \31\:S) capacitor c=7.23815e-16
    c916 (\37\:VDDA \279\:VDDA) capacitor c=4.1449e-15
    c917 (\21\:D2 \90\:S2) capacitor c=1.2828e-17
    c918 (\161\:VDDA \12\:S) capacitor c=5.28947e-16
    c919 (\51\:U \746\:GNDA) capacitor c=1.98382e-16
    c920 (\78\:U \1057\:GNDA) capacitor c=1.60051e-16
    c921 (\11\:Vs \1251\:GNDA) capacitor c=1.9705e-16
    c922 (\196\:VDDA \20\:S) capacitor c=5.28947e-16
    c923 (\247\:S \149\:S) capacitor c=3.12121e-16
    c924 (\138\:BG_REF \427\:VDDA) capacitor c=8.80912e-17
    c925 (\627\:GNDA \443\:GNDA) capacitor c=4.6967e-17
    c926 (\214\:Vm1 \458\:VDDA) capacitor c=3.537e-16
    c927 (\182\:GNDA \1251\:GNDA) capacitor c=3.11265e-17
    c928 (\226\:S \279\:VDDA) capacitor c=1.14863e-15
    c929 (\339\:VDDA \61\:BG_REF) capacitor c=5.38637e-16
    c930 (\69\:U \961\:GNDA) capacitor c=1.50519e-16
    c931 (\8\:S2 \44\:S2) capacitor c=5.4199e-16
    c932 (\183\:VDDA \45\:BG_REF) capacitor c=2.32098e-17
    c933 (\221\:S \92\:VDDA) capacitor c=1.06321e-17
    c934 (\55\:GNDA \2\:net12) capacitor c=4.43637e-16
    c935 (\97\:U \753\:GNDA) capacitor c=1.3611e-15
    c936 (\627\:VDDA \80\:VDDA) capacitor c=2.28853e-16
    c937 (\1082\:GNDA \1049\:GNDA) capacitor c=5.35597e-17
    c938 (\367\:VDDA \66\:BG_REF) capacitor c=5.28947e-16
    c939 (\35\:X \1137\:GNDA) capacitor c=3.43193e-17
    c940 (\1518\:GNDA \44\:D1) capacitor c=1.92093e-15
    c941 (\4\:U \1309\:GNDA) capacitor c=2.63098e-16
    c942 (\67\:S2 \19\:vv) capacitor c=2.18056e-16
    c943 (\12\:X \102\:S) capacitor c=1.27624e-15
    c944 (\8\:U \896\:GNDA) capacitor c=2.66468e-15
    c945 (\71\:S2 \108\:VDDA) capacitor c=1.23137e-17
    c946 (\204\:S \417\:VDDA) capacitor c=9.16107e-17
    c947 (\3\:GNDA \218\:GNDA) capacitor c=3.53079e-16
    c948 (\63\:U \1192\:GNDA) capacitor c=7.79155e-17
    c949 (\863\:VDDA \271\:Vm1) capacitor c=1.74798e-15
    c950 (\10\:Vs \718\:GNDA) capacitor c=3.54534e-16
    c951 (\35\:D1 \121\:S) capacitor c=5.70862e-16
    c952 (\46\:Vo1 \1527\:GNDA) capacitor c=1.84369e-16
    c953 (\728\:GNDA \1251\:GNDA) capacitor c=7.02394e-17
    c954 (\9\:U \1251\:GNDA) capacitor c=5.09198e-17
    c955 (\63\:BG_REF \279\:VDDA) capacitor c=7.1068e-16
    c956 (\101\:U \996\:GNDA) capacitor c=1.14364e-16
    c957 (\296\:VDDA \31\:S) capacitor c=1.28247e-16
    c958 (\62\:S2 \44\:S2) capacitor c=6.49464e-16
    c959 (\3\:S \17\:D1) capacitor c=1.41156e-16
    c960 (\47\:VDDA \279\:VDDA) capacitor c=3.79387e-15
    c961 (\57\:Vo1 \46\:Vo1) capacitor c=1.99234e-17
    c962 (\590\:VDDA \534\:VDDA) capacitor c=6.51733e-16
    c963 (\485\:VDDA \658\:VDDA) capacitor c=3.15296e-16
    c964 (\71\:S2 \279\:VDDA) capacitor c=1.61208e-15
    c965 (\164\:VDDA \41\:BG_REF) capacitor c=5.39428e-16
    c966 (\29\:U \37\:U) capacitor c=2.54497e-15
    c967 (\302\:VDDA \36\:S) capacitor c=1.21882e-16
    c968 (\771\:GNDA \149\:S) capacitor c=9.7527e-17
    c969 (\234\:VDDA \279\:VDDA) capacitor c=3.91553e-16
    c970 (\24\:S2 \3\:Vs) capacitor c=1.86576e-16
    c971 (\60\:S \15\:D1) capacitor c=2.90655e-16
    c972 (\905\:GNDA \1244\:GNDA) capacitor c=3.62455e-15
    c973 (\845\:GNDA \1251\:GNDA) capacitor c=4.95605e-16
    c974 (\50\:S \49\:S) capacitor c=1.71522e-15
    c975 (\134\:BG_REF \34\:vv) capacitor c=5.24645e-16
    c976 (\49\:U \190\:GNDA) capacitor c=1.3611e-15
    c977 (\192\:GNDA \36\:U) capacitor c=6.66184e-17
    c978 (\102\:S2 \61\:BG_REF) capacitor c=1.11867e-17
    c979 (\30\:BG_REF \279\:VDDA) capacitor c=1.15121e-16
    c980 (\1221\:GNDA \1251\:GNDA) capacitor c=3.1724e-17
    c981 (\227\:S \74\:S2) capacitor c=3.27206e-15
    c982 (\133\:BG_REF \67\:VDDA) capacitor c=1.03845e-17
    c983 (\221\:S \71\:S2) capacitor c=3.37597e-15
    c984 (\42\:U \500\:GNDA) capacitor c=1.60051e-16
    c985 (\100\:U \1012\:GNDA) capacitor c=1.60051e-16
    c986 (\18\:Y \218\:GNDA) capacitor c=3.6353e-16
    c987 (\21\:vv \10\:S) capacitor c=3.40015e-17
    c988 (\26\:S2 \8\:D2) capacitor c=2.5307e-17
    c989 (\120\:BG_REF \579\:VDDA) capacitor c=6.67142e-16
    c990 (\200\:Vm1 \279\:VDDA) capacitor c=3.75029e-16
    c991 (\22\:U \746\:GNDA) capacitor c=1.14364e-16
    c992 (\61\:D1 \686\:GNDA) capacitor c=7.3475e-16
    c993 (\22\:Vo1 \102\:S) capacitor c=8.07844e-16
    c994 (\73\:U \1218\:GNDA) capacitor c=5.24739e-17
    c995 (\17\:S2 \4\:Vs) capacitor c=2.38244e-17
    c996 (\187\:VDDA \23\:VDDA) capacitor c=1.0554e-15
    c997 (\1355\:GNDA \597\:GNDA) capacitor c=3.24909e-17
    c998 (\509\:VDDA \111\:BG_REF) capacitor c=2.22142e-16
    c999 (\28\:X \20\:U) capacitor c=3.83033e-17
    c1000 (\944\:GNDA \550\:GNDA) capacitor c=1.7209e-16
    c1001 (\463\:VDDA \483\:VDDA) capacitor c=5.18716e-16
    c1002 (\771\:GNDA \1251\:GNDA) capacitor c=3.99177e-16
    c1003 (\18\:D2 \1251\:GNDA) capacitor c=1.05042e-15
    c1004 (\86\:S2 \29\:S2) capacitor c=2.61774e-17
    c1005 (\403\:VDDA \75\:BG_REF) capacitor c=5.37491e-16
    c1006 (\17\:vv \279\:VDDA) capacitor c=5.48437e-15
    c1007 (\101\:U \1009\:GNDA) capacitor c=1.3611e-15
    c1008 (\927\:GNDA \956\:GNDA) capacitor c=1.59865e-16
    c1009 (\57\:BG_REF \323\:VDDA) capacitor c=3.01441e-16
    c1010 (\1005\:GNDA \1006\:GNDA) capacitor c=4.12292e-16
    c1011 (\1405\:GNDA \363\:GNDA) capacitor c=3.67302e-17
    c1012 (\49\:BG_REF \279\:VDDA) capacitor c=7.09559e-16
    c1013 (\21\:Vm1 \22\:Vm1) capacitor c=6.39719e-16
    c1014 (\51\:Vo1 \684\:GNDA) capacitor c=6.34926e-16
    c1015 (\88\:BG_REF \53\:VDDA) capacitor c=1.39504e-17
    c1016 (\205\:GNDA \178\:GNDA) capacitor c=3.39571e-17
    c1017 (\358\:VDDA \69\:BG_REF) capacitor c=1.48876e-17
    c1018 (\186\:S \149\:S) capacitor c=3.62225e-16
    c1019 (\1214\:GNDA \1233\:GNDA) capacitor c=1.62672e-16
    c1020 (\89\:BG_REF \534\:VDDA) capacitor c=1.8557e-16
    c1021 (\71\:S \23\:Vo1) capacitor c=2.90655e-16
    c1022 (\137\:BG_REF \240\:S) capacitor c=3.97639e-15
    c1023 (\1114\:GNDA \1006\:GNDA) capacitor c=9.29257e-17
    c1024 (\85\:GNDA \2\:net8) capacitor c=7.59242e-17
    c1025 (\948\:GNDA \203\:GNDA) capacitor c=1.01852e-16
    c1026 (\193\:S \718\:GNDA) capacitor c=1.14786e-16
    c1027 (\1130\:GNDA \1181\:GNDA) capacitor c=4.6967e-17
    c1028 (\18\:U \207\:GNDA) capacitor c=6.43973e-16
    c1029 (\122\:Vm1 \189\:VDDA) capacitor c=3.39738e-16
    c1030 (\212\:GNDA \1251\:GNDA) capacitor c=2.52252e-15
    c1031 (\31\:GNDA \16\:BG_REF) capacitor c=2.89102e-16
    c1032 (\515\:VDDA \271\:Vm1) capacitor c=2.25333e-16
    c1033 (\207\:GNDA \61\:U) capacitor c=1.46276e-15
    c1034 (\774\:GNDA \203\:GNDA) capacitor c=2.85637e-16
    c1035 (\748\:VDDA \279\:VDDA) capacitor c=4.18257e-16
    c1036 (\208\:Vm1 \393\:VDDA) capacitor c=4.65703e-16
    c1037 (\88\:BG_REF \204\:S) capacitor c=7.59749e-15
    c1038 (\257\:VDDA \279\:VDDA) capacitor c=2.75667e-16
    c1039 (\52\:GNDA \218\:GNDA) capacitor c=3.40298e-14
    c1040 (\192\:GNDA \948\:GNDA) capacitor c=3.40393e-17
    c1041 (\1\:BG_REF \550\:GNDA) capacitor c=2.02946e-15
    c1042 (\33\:X \218\:GNDA) capacitor c=3.15676e-16
    c1043 (\331\:GNDA \218\:GNDA) capacitor c=2.90369e-16
    c1044 (\207\:GNDA \1034\:GNDA) capacitor c=1.32877e-17
    c1045 (\29\:BG_REF \143\:VDDA) capacitor c=1.23404e-17
    c1046 (\10\:S \279\:VDDA) capacitor c=1.67411e-16
    c1047 (\111\:BG_REF \222\:S) capacitor c=2.92617e-15
    c1048 (\45\:U \1251\:GNDA) capacitor c=2.64138e-15
    c1049 (\863\:VDDA \238\:S) capacitor c=4.17089e-16
    c1050 (\132\:Vm1 \24\:Vm1) capacitor c=8.78761e-16
    c1051 (\23\:D1 \89\:S) capacitor c=4.92381e-16
    c1052 (\65\:S2 \88\:BG_REF) capacitor c=5.12323e-16
    c1053 (\118\:Vm1 \146\:VDDA) capacitor c=4.73118e-16
    c1054 (\82\:U \1251\:GNDA) capacitor c=7.1556e-17
    c1055 (\1237\:GNDA \1238\:GNDA) capacitor c=4.12292e-16
    c1056 (\37\:Vo1 \102\:S) capacitor c=1.01006e-15
    c1057 (\158\:VDDA \37\:BG_REF) capacitor c=5.39428e-16
    c1058 (\27\:vv \32\:D2) capacitor c=1.26952e-16
    c1059 (\1167\:GNDA \1159\:GNDA) capacitor c=9.29257e-17
    c1060 (\245\:S \53\:D1) capacitor c=1.1363e-15
    c1061 (\279\:S \102\:S) capacitor c=5.2072e-16
    c1062 (\401\:VDDA \279\:VDDA) capacitor c=3.96231e-16
    c1063 (\10\:GNDA \2\:net23) capacitor c=2.50282e-16
    c1064 (\58\:S \63\:Vo1) capacitor c=4.72025e-17
    c1065 (\77\:S2 \574\:VDDA) capacitor c=4.5184e-17
    c1066 (\896\:GNDA \87\:U) capacitor c=3.36974e-16
    c1067 (\649\:VDDA \529\:VDDA) capacitor c=2.29187e-16
    c1068 (\1226\:GNDA \1152\:GNDA) capacitor c=9.29257e-17
    c1069 (\14\:U \114\:GNDA) capacitor c=1.51607e-17
    c1070 (\243\:S \47\:D1) capacitor c=1.13782e-15
    c1071 (\625\:VDDA \279\:VDDA) capacitor c=3.0356e-16
    c1072 (\31\:S \68\:S2) capacitor c=1.17194e-16
    c1073 (\35\:X \419\:GNDA) capacitor c=1.61441e-16
    c1074 (\110\:VDDA \29\:BG_REF) capacitor c=3.86661e-16
    c1075 (\2\:net4 \93\:GNDA) capacitor c=2.84241e-15
    c1076 (\251\:VDDA \279\:VDDA) capacitor c=3.34076e-16
    c1077 (\54\:U \1251\:GNDA) capacitor c=1.45671e-15
    c1078 (\282\:VDDA \281\:VDDA) capacitor c=1.82419e-16
    c1079 (\105\:S2 \22\:Vs) capacitor c=1.6909e-15
    c1080 (\177\:S \102\:S) capacitor c=3.02101e-16
    c1081 (\282\:VDDA \9\:S2) capacitor c=1.00574e-17
    c1082 (\192\:GNDA \1024\:GNDA) capacitor c=1.33732e-17
    c1083 (\809\:GNDA \535\:GNDA) capacitor c=4.6509e-16
    c1084 (\22\:BIAS \221\:Vm1) capacitor c=1.35637e-16
    c1085 (\26\:Vm1 \279\:VDDA) capacitor c=3.92629e-15
    c1086 (\18\:Vs \44\:S2) capacitor c=1.51501e-15
    c1087 (\44\:U \49\:U) capacitor c=1.69405e-17
    c1088 (\26\:vv \78\:VDDA) capacitor c=2.9074e-17
    c1089 (\120\:BG_REF \235\:S) capacitor c=2.56266e-15
    c1090 (\320\:GNDA \332\:GNDA) capacitor c=2.69114e-17
    c1091 (\79\:U \1172\:GNDA) capacitor c=4.6967e-17
    c1092 (\75\:S2 \28\:vv) capacitor c=1.22457e-16
    c1093 (\26\:vv \34\:S) capacitor c=3.40015e-17
    c1094 (\237\:Vm1 \222\:S) capacitor c=5.22878e-16
    c1095 (\208\:S \534\:VDDA) capacitor c=3.64161e-17
    c1096 (\585\:VDDA \279\:VDDA) capacitor c=3.30453e-16
    c1097 (\45\:U \205\:GNDA) capacitor c=2.52002e-15
    c1098 (\2\:net19 \218\:GNDA) capacitor c=3.9033e-16
    c1099 (\75\:BG_REF \279\:VDDA) capacitor c=1.00128e-15
    c1100 (\186\:S \534\:VDDA) capacitor c=5.59798e-17
    c1101 (\48\:Vo1 \1251\:GNDA) capacitor c=1.35628e-15
    c1102 (\31\:U \173\:GNDA) capacitor c=1.63679e-16
    c1103 (\17\:vv \70\:VDDA) capacitor c=9.72541e-17
    c1104 (\9\:S2 \20\:vv) capacitor c=1.94417e-15
    c1105 (\26\:D1 \91\:S) capacitor c=2.28667e-16
    c1106 (\92\:U \1251\:GNDA) capacitor c=8.99646e-16
    c1107 (\500\:GNDA \1251\:GNDA) capacitor c=4.19575e-17
    c1108 (\2\:Y \2\:X) capacitor c=6.7594e-16
    c1109 (\88\:S2 \4\:vv) capacitor c=2.31101e-17
    c1110 (\128\:Vm1 \195\:VDDA) capacitor c=3.39738e-16
    c1111 (\1495\:GNDA \1452\:GNDA) capacitor c=1.60548e-16
    c1112 (\62\:S2 \535\:GNDA) capacitor c=6.91811e-17
    c1113 (\23\:BG_REF \138\:VDDA) capacitor c=2.89826e-16
    c1114 (\539\:GNDA \3\:Vo1) capacitor c=1.20161e-17
    c1115 (\426\:VDDA \417\:VDDA) capacitor c=1.345e-14
    c1116 (\1362\:GNDA \1274\:GNDA) capacitor c=3.77756e-15
    c1117 (\27\:U \815\:GNDA) capacitor c=6.93867e-16
    c1118 (\138\:BG_REF \436\:VDDA) capacitor c=1.47448e-16
    c1119 (\151\:S \102\:S) capacitor c=3.96802e-16
    c1120 (\17\:vv \534\:VDDA) capacitor c=4.5184e-17
    c1121 (\238\:S \47\:VDDA) capacitor c=1.34744e-17
    c1122 (\47\:U \183\:GNDA) capacitor c=1.08835e-16
    c1123 (\63\:BG_REF \383\:VDDA) capacitor c=3.01353e-16
    c1124 (\1523\:GNDA \1251\:GNDA) capacitor c=8.65181e-16
    c1125 (\88\:U \1427\:GNDA) capacitor c=8.85297e-17
    c1126 (\953\:GNDA \968\:GNDA) capacitor c=1.59891e-16
    c1127 (\203\:GNDA \890\:GNDA) capacitor c=3.1596e-17
    c1128 (\17\:GNDA \218\:GNDA) capacitor c=5.6172e-17
    c1129 (\241\:S \900\:VDDA) capacitor c=2.68741e-17
    c1130 (\192\:GNDA \38\:U) capacitor c=7.93593e-17
    c1131 (\17\:vv \594\:VDDA) capacitor c=6.1755e-17
    c1132 (\238\:S \43\:VDDA) capacitor c=1.34744e-17
    c1133 (\57\:Vo1 \149\:S) capacitor c=2.71455e-16
    c1134 (\212\:Vm1 \279\:VDDA) capacitor c=4.52787e-16
    c1135 (\53\:BG_REF \236\:S) capacitor c=7.56755e-17
    c1136 (\1113\:GNDA \1251\:GNDA) capacitor c=3.11265e-17
    c1137 (\236\:Vm1 \21\:vv) capacitor c=2.66552e-16
    c1138 (\238\:S \39\:VDDA) capacitor c=1.34744e-17
    c1139 (\297\:Vm1 \591\:VDDA) capacitor c=6.4143e-16
    c1140 (\24\:vv \804\:VDDA) capacitor c=7.11614e-16
    c1141 (\31\:GNDA \2\:net6) capacitor c=4.98168e-17
    c1142 (\391\:GNDA \610\:GNDA) capacitor c=4.2752e-16
    c1143 (\103\:S2 \13\:VDDA) capacitor c=1.34744e-17
    c1144 (\28\:Vo1 \20\:D1) capacitor c=5.3018e-16
    c1145 (\329\:VDDA \60\:BG_REF) capacitor c=3.8451e-17
    c1146 (\273\:VDDA \279\:VDDA) capacitor c=3.49923e-16
    c1147 (\1513\:GNDA \1251\:GNDA) capacitor c=1.20173e-16
    c1148 (\5\:GNDA \114\:GNDA) capacitor c=1.0245e-16
    c1149 (\905\:GNDA \1389\:GNDA) capacitor c=4.77777e-15
    c1150 (\67\:U \1251\:GNDA) capacitor c=1.67703e-15
    c1151 (\207\:GNDA \1029\:GNDA) capacitor c=2.31665e-15
    c1152 (\19\:Vo1 \124\:GNDA) capacitor c=6.32939e-17
    c1153 (\71\:U \1172\:GNDA) capacitor c=1.20051e-17
    c1154 (\110\:Vm1 \3\:VDDA) capacitor c=4.55576e-16
    c1155 (\413\:VDDA \426\:VDDA) capacitor c=3.83556e-16
    c1156 (\100\:VDDA \279\:VDDA) capacitor c=4.24257e-16
    c1157 (\50\:U \736\:GNDA) capacitor c=6.26513e-16
    c1158 (\104\:BG_REF \19\:vv) capacitor c=5.24628e-16
    c1159 (\2\:net16 \56\:GNDA) capacitor c=2.82929e-15
    c1160 (\440\:VDDA \279\:VDDA) capacitor c=3.30986e-16
    c1161 (\11\:D2 \34\:S2) capacitor c=6.68897e-16
    c1162 (\905\:GNDA \178\:GNDA) capacitor c=2.29623e-16
    c1163 (\78\:U \1034\:GNDA) capacitor c=3.73689e-17
    c1164 (\1362\:GNDA \97\:U) capacitor c=3.38399e-16
    c1165 (\30\:S2 \44\:S2) capacitor c=1.99716e-16
    c1166 (\111\:BG_REF \22\:vv) capacitor c=5.14497e-16
    c1167 (\46\:D1 \51\:Vo1) capacitor c=2.93801e-15
    c1168 (\39\:D1 \1251\:GNDA) capacitor c=9.78381e-16
    c1169 (\203\:GNDA \373\:GNDA) capacitor c=4.40895e-15
    c1170 (\35\:X \31\:X) capacitor c=1.13758e-16
    c1171 (\247\:S \136\:BG_REF) capacitor c=3.02026e-16
    c1172 (\2\:vv \18\:S2) capacitor c=5.15583e-17
    c1173 (\574\:VDDA \534\:VDDA) capacitor c=9.31637e-16
    c1174 (\53\:D1 \183\:S) capacitor c=1.00945e-16
    c1175 (\612\:VDDA \614\:VDDA) capacitor c=2.91288e-16
    c1176 (\704\:GNDA \883\:GNDA) capacitor c=1.03412e-16
    c1177 (\625\:VDDA \26\:vv) capacitor c=1.05255e-15
    c1178 (\205\:GNDA \30\:U) capacitor c=1.13496e-15
    c1179 (\1507\:GNDA \61\:D1) capacitor c=6.74351e-16
    c1180 (\44\:U \512\:GNDA) capacitor c=6.78232e-17
    c1181 (\3\:U \6\:U) capacitor c=1.63745e-17
    c1182 (\32\:D2 \6\:Vs) capacitor c=5.33988e-16
    c1183 (\344\:GNDA \218\:GNDA) capacitor c=5.93139e-16
    c1184 (\15\:Vs \64\:S2) capacitor c=5.48466e-17
    c1185 (\1561\:GNDA \212\:GNDA) capacitor c=1.3007e-15
    c1186 (\22\:Vo1 \149\:S) capacitor c=5.66781e-17
    c1187 (\506\:GNDA \183\:GNDA) capacitor c=4.83033e-17
    c1188 (BG_REF \1251\:GNDA) capacitor c=3.44902e-16
    c1189 (\114\:VDDA \279\:VDDA) capacitor c=2.52177e-16
    c1190 (\241\:S \137\:BG_REF) capacitor c=5.15535e-15
    c1191 (\57\:Vo1 \1251\:GNDA) capacitor c=8.69453e-16
    c1192 (\456\:VDDA \279\:VDDA) capacitor c=3.86901e-16
    c1193 (\88\:BG_REF \485\:VDDA) capacitor c=1.62184e-17
    c1194 (\43\:BG_REF \208\:VDDA) capacitor c=2.98055e-16
    c1195 (\230\:GNDA \1251\:GNDA) capacitor c=1.53506e-13
    c1196 (\205\:GNDA \874\:GNDA) capacitor c=3.66009e-16
    c1197 (\896\:GNDA \76\:U) capacitor c=6.66184e-17
    c1198 (\1389\:GNDA \664\:GNDA) capacitor c=3.72052e-17
    c1199 (\30\:S2 \7\:Vs) capacitor c=1.49612e-16
    c1200 (\1362\:GNDA \1138\:GNDA) capacitor c=3.21511e-17
    c1201 (\1082\:GNDA \1251\:GNDA) capacitor c=4.19575e-17
    c1202 (\1362\:GNDA \106\:U) capacitor c=6.66184e-17
    c1203 (\2\:vv \14\:BG_REF) capacitor c=1.07356e-16
    c1204 (\85\:Vm1 \86\:Vm1) capacitor c=6.44996e-16
    c1205 (\117\:U \591\:GNDA) capacitor c=1.40221e-16
    c1206 (\207\:GNDA \1159\:GNDA) capacitor c=3.39571e-17
    c1207 (\75\:BG_REF \39\:S) capacitor c=6.35844e-16
    c1208 (\1294\:GNDA \87\:U) capacitor c=3.63621e-17
    c1209 (\65\:S2 \71\:BG_REF) capacitor c=1.11867e-17
    c1210 (\751\:VDDA \225\:Vm1) capacitor c=1.72222e-15
    c1211 (\1466\:GNDA \193\:GNDA) capacitor c=3.3337e-17
    c1212 (\896\:GNDA \961\:GNDA) capacitor c=3.74074e-15
    c1213 (\24\:vv \28\:BG_REF) capacitor c=3.40015e-17
    c1214 (\35\:D1 \129\:S) capacitor c=2.60492e-16
    c1215 (\37\:U \160\:GNDA) capacitor c=4.6967e-17
    c1216 (\66\:S2 \692\:VDDA) capacitor c=2.98223e-16
    c1217 (\100\:BG_REF \587\:VDDA) capacitor c=6.7514e-16
    c1218 (\46\:U \185\:GNDA) capacitor c=7.79155e-17
    c1219 (\8\:GNDA \218\:GNDA) capacitor c=7.24696e-15
    c1220 (\751\:VDDA \217\:S) capacitor c=3.82852e-16
    c1221 (\10\:U \1314\:GNDA) capacitor c=3.83457e-17
    c1222 (\84\:S2 \52\:S2) capacitor c=4.6517e-16
    c1223 (\378\:VDDA \426\:VDDA) capacitor c=3.85048e-16
    c1224 (\1527\:GNDA \19\:Vo1) capacitor c=1.06712e-15
    c1225 (\114\:Vm1 \122\:VDDA) capacitor c=3.44578e-16
    c1226 (\79\:BG_REF \35\:S) capacitor c=7.23815e-16
    c1227 (\928\:GNDA \956\:GNDA) capacitor c=3.13925e-16
    c1228 (\776\:GNDA \818\:GNDA) capacitor c=3.41513e-16
    c1229 (\18\:vv \542\:VDDA) capacitor c=2.66494e-16
    c1230 (\94\:Vm1 \279\:VDDA) capacitor c=3.92467e-15
    c1231 (\128\:VDDA \279\:VDDA) capacitor c=2.95619e-16
    c1232 (\1033\:GNDA \1251\:GNDA) capacitor c=3.11265e-17
    c1233 (\28\:Vo1 \149\:S) capacitor c=5.25159e-17
    c1234 (\476\:VDDA \279\:VDDA) capacitor c=2.65004e-16
    c1235 (\134\:BG_REF \534\:VDDA) capacitor c=1.49709e-17
    c1236 (\1244\:GNDA \1262\:GNDA) capacitor c=4.31113e-16
    c1237 (\41\:U \170\:GNDA) capacitor c=4.6967e-17
    c1238 (\78\:S2 \18\:S2) capacitor c=7.28711e-17
    c1239 (\21\:S2 \26\:S2) capacitor c=2.29581e-16
    c1240 (\162\:GNDA \165\:GNDA) capacitor c=1.59891e-16
    c1241 (\385\:VDDA \73\:BG_REF) capacitor c=2.86633e-16
    c1242 (\25\:D2 \110\:S2) capacitor c=8.60264e-16
    c1243 (\7\:D2 \11\:BG_REF) capacitor c=1.2327e-16
    c1244 (\75\:U \975\:GNDA) capacitor c=4.6967e-17
    c1245 (\214\:Vm1 \442\:VDDA) capacitor c=4.6299e-16
    c1246 (\905\:GNDA \180\:GNDA) capacitor c=1.24327e-17
    c1247 (\245\:GNDA \1251\:GNDA) capacitor c=9.68442e-16
    c1248 (\1221\:GNDA \1200\:GNDA) capacitor c=4.96077e-17
    c1249 (\94\:U \397\:GNDA) capacitor c=1.98382e-16
    c1250 (\115\:GNDA \2\:net10) capacitor c=3.97825e-16
    c1251 (\536\:VDDA \521\:GNDA) capacitor c=1.38088e-17
    c1252 (\73\:U \1362\:GNDA) capacitor c=1.82367e-15
    c1253 (\1472\:GNDA \1403\:GNDA) capacitor c=9.29257e-17
    c1254 (\97\:U \748\:GNDA) capacitor c=4.6967e-17
    c1255 (\77\:BG_REF \61\:VDDA) capacitor c=1.33555e-17
    c1256 (\7\:Vo1 \550\:GNDA) capacitor c=4.05547e-15
    c1257 (\2\:net3 \2\:net9) capacitor c=4.22132e-17
    c1258 (\31\:BG_REF \279\:VDDA) capacitor c=1.88281e-15
    c1259 (\65\:S2 \18\:vv) capacitor c=1.24156e-16
    c1260 (\242\:S \427\:VDDA) capacitor c=1.10139e-16
    c1261 (\16\:vv \500\:VDDA) capacitor c=3.31616e-17
    c1262 (\60\:U \1049\:GNDA) capacitor c=1.14364e-16
    c1263 (\493\:VDDA \279\:VDDA) capacitor c=2.51763e-16
    c1264 (\478\:VDDA \77\:BG_REF) capacitor c=1.56999e-16
    c1265 (\19\:vv \223\:VDDA) capacitor c=3.31616e-17
    c1266 (\112\:Vm1 \140\:VDDA) capacitor c=4.73118e-16
    c1267 (\193\:VDDA \37\:BG_REF) capacitor c=3.23767e-16
    c1268 (\208\:S \542\:VDDA) capacitor c=1.22928e-16
    c1269 (\896\:GNDA \1201\:GNDA) capacitor c=1.26043e-17
    c1270 (\192\:GNDA \40\:U) capacitor c=7.93593e-17
    c1271 (\230\:GNDA \166\:S) capacitor c=7.11868e-17
    c1272 (\259\:Vm1 \75\:S2) capacitor c=5.08078e-16
    c1273 (\37\:U \163\:GNDA) capacitor c=1.09512e-16
    c1274 (\539\:GNDA \1251\:GNDA) capacitor c=3.546e-14
    c1275 (\695\:VDDA \279\:VDDA) capacitor c=4.19755e-16
    c1276 (\771\:GNDA \166\:S) capacitor c=7.4541e-17
    c1277 (\19\:Vs \82\:S2) capacitor c=2.69923e-17
    c1278 (\38\:U \1251\:GNDA) capacitor c=7.1556e-17
    c1279 (\28\:vv \26\:S) capacitor c=3.40015e-17
    c1280 (\286\:Vm1 \104\:BG_REF) capacitor c=1.51104e-15
    c1281 (\205\:GNDA \64\:U) capacitor c=3.36974e-16
    c1282 (\92\:S2 \136\:BG_REF) capacitor c=1.32762e-16
    c1283 (\546\:VDDA \111\:BG_REF) capacitor c=4.80867e-16
    c1284 (\653\:VDDA \204\:S) capacitor c=6.71118e-16
    c1285 (\385\:GNDA \610\:GNDA) capacitor c=9.49164e-17
    c1286 (\16\:vv \517\:VDDA) capacitor c=2.01108e-17
    c1287 (\237\:Vm1 \546\:VDDA) capacitor c=4.29846e-16
    c1288 (\116\:U \2\:net1) capacitor c=1.54001e-17
    c1289 (\41\:X \1133\:GNDA) capacitor c=1.60086e-17
    c1290 (\116\:Vm1 \279\:VDDA) capacitor c=6.11746e-16
    c1291 (\18\:Vs \60\:S2) capacitor c=4.44935e-17
    c1292 (\317\:GNDA \218\:GNDA) capacitor c=3.38454e-16
    c1293 (\138\:BG_REF \241\:S) capacitor c=1.27754e-15
    c1294 (\173\:S \2\:X) capacitor c=8.53378e-16
    c1295 (\515\:VDDA \279\:VDDA) capacitor c=4.15822e-16
    c1296 (\8\:U \1500\:GNDA) capacitor c=5.45326e-17
    c1297 (\17\:X \218\:GNDA) capacitor c=3.19772e-16
    c1298 (\1032\:GNDA \1251\:GNDA) capacitor c=4.19575e-17
    c1299 (\66\:U \1192\:GNDA) capacitor c=4.6967e-17
    c1300 (\12\:X \12\:Y) capacitor c=1.15461e-17
    c1301 (\88\:BG_REF \534\:VDDA) capacitor c=1.94032e-16
    c1302 (\31\:BG_REF \11\:VDDA) capacitor c=3.03102e-17
    c1303 (\1500\:GNDA \1427\:GNDA) capacitor c=4.6967e-17
    c1304 (\108\:U \1300\:GNDA) capacitor c=1.60051e-16
    c1305 (\1206\:GNDA \1192\:GNDA) capacitor c=4.6967e-17
    c1306 (\34\:U \476\:GNDA) capacitor c=1.60051e-16
    c1307 (\1472\:GNDA \1486\:GNDA) capacitor c=3.48337e-16
    c1308 (\641\:VDDA \279\:VDDA) capacitor c=2.99906e-16
    c1309 (\134\:BG_REF \236\:VDDA) capacitor c=1.03669e-17
    c1310 (\66\:S2 \594\:VDDA) capacitor c=6.1755e-17
    c1311 (\2\:net30 \55\:GNDA) capacitor c=7.09094e-16
    c1312 (\452\:VDDA \271\:Vm1) capacitor c=3.9399e-16
    c1313 (\12\:Vs \535\:GNDA) capacitor c=1.368e-16
    c1314 (\23\:D1 \79\:S) capacitor c=3.34655e-16
    c1315 (\203\:GNDA \637\:GNDA) capacitor c=1.7429e-16
    c1316 (\31\:Vs \535\:GNDA) capacitor c=3.47554e-16
    c1317 (\28\:vv \266\:VDDA) capacitor c=3.31616e-17
    c1318 (\87\:BG_REF \44\:S2) capacitor c=1.10736e-15
    c1319 (\2\:net16 \43\:GNDA) capacitor c=1.14266e-15
    c1320 (\27\:X \1113\:GNDA) capacitor c=1.69389e-16
    c1321 (\1555\:GNDA \25\:Vs) capacitor c=4.16031e-16
    c1322 (\110\:GNDA \218\:GNDA) capacitor c=4.72668e-15
    c1323 (\31\:Vo1 \29\:Vo1) capacitor c=1.23799e-15
    c1324 (\27\:Vs \1561\:GNDA) capacitor c=2.10247e-17
    c1325 (\58\:VDDA \279\:VDDA) capacitor c=5.66413e-15
    c1326 (\905\:GNDA \1013\:GNDA) capacitor c=5.5638e-15
    c1327 (\889\:GNDA \1251\:GNDA) capacitor c=3.11265e-17
    c1328 (\69\:U \76\:U) capacitor c=1.13692e-16
    c1329 (\140\:VDDA \279\:VDDA) capacitor c=3.30359e-16
    c1330 (\863\:VDDA \133\:BG_REF) capacitor c=5.66968e-16
    c1331 (\66\:S2 \534\:VDDA) capacitor c=4.5184e-17
    c1332 (\112\:S2 \554\:VDDA) capacitor c=4.60847e-16
    c1333 (\85\:U \212\:GNDA) capacitor c=3.64863e-16
    c1334 (\645\:VDDA \237\:Vm1) capacitor c=5.21476e-16
    c1335 (\55\:VDDA \56\:VDDA) capacitor c=6.69821e-16
    c1336 (\192\:GNDA \1068\:GNDA) capacitor c=3.40431e-17
    c1337 (\38\:D1 \123\:S) capacitor c=2.28667e-16
    c1338 (\905\:GNDA \230\:GNDA) capacitor c=2.36403e-16
    c1339 (\2\:U \207\:GNDA) capacitor c=4.78695e-17
    c1340 (\1012\:GNDA \996\:GNDA) capacitor c=5.35597e-17
    c1341 (\287\:Vm1 \279\:VDDA) capacitor c=1.24516e-15
    c1342 (\33\:U \192\:GNDA) capacitor c=1.38023e-15
    c1343 (\89\:BG_REF \205\:S) capacitor c=7.46089e-15
    c1344 (\116\:Vm1 \94\:VDDA) capacitor c=3.22227e-16
    c1345 (\207\:GNDA \24\:U) capacitor c=3.3004e-16
    c1346 (\21\:Vs \10\:D2) capacitor c=6.64626e-16
    c1347 (\51\:U \776\:GNDA) capacitor c=5.64952e-17
    c1348 (\225\:VDDA \22\:S) capacitor c=5.28406e-16
    c1349 (\16\:U \203\:GNDA) capacitor c=4.06565e-16
    c1350 (\5\:VDDA \279\:VDDA) capacitor c=5.71111e-15
    c1351 (\493\:VDDA \61\:VDDA) capacitor c=8.50906e-16
    c1352 (\746\:GNDA \738\:GNDA) capacitor c=9.29257e-17
    c1353 (\31\:GNDA \218\:GNDA) capacitor c=9.90999e-15
    c1354 (\62\:BG_REF \279\:VDDA) capacitor c=1.15424e-16
    c1355 (\68\:S2 \25\:BG_REF) capacitor c=1.11867e-17
    c1356 (\897\:VDDA \134\:BG_REF) capacitor c=2.75388e-16
    c1357 (\948\:GNDA \149\:GNDA) capacitor c=3.71677e-17
    c1358 (\210\:Vm1 \454\:VDDA) capacitor c=3.537e-16
    c1359 (\162\:Vm1 \280\:VDDA) capacitor c=4.73784e-16
    c1360 (\156\:VDDA \279\:VDDA) capacitor c=3.93795e-16
    c1361 (\645\:VDDA \74\:S2) capacitor c=8.32171e-17
    c1362 (\136\:S \40\:Vo1) capacitor c=9.11917e-17
    c1363 (\133\:BG_REF \292\:VDDA) capacitor c=2.04887e-17
    c1364 (\14\:BG_REF \7\:S2) capacitor c=1.7481e-17
    c1365 (\1401\:GNDA \1374\:GNDA) capacitor c=5.35597e-17
    c1366 (\189\:VDDA \43\:BG_REF) capacitor c=5.38983e-16
    c1367 (\1013\:GNDA \154\:GNDA) capacitor c=3.29919e-17
    c1368 (\91\:U \461\:GNDA) capacitor c=5.23865e-17
    c1369 (\10\:D1 \684\:GNDA) capacitor c=9.23911e-16
    c1370 (\85\:U \1362\:GNDA) capacitor c=2.13648e-15
    c1371 (\33\:vv \554\:VDDA) capacitor c=2.94645e-16
    c1372 (\118\:Vm1 \10\:Vm1) capacitor c=8.80193e-16
    c1373 (\768\:GNDA \728\:GNDA) capacitor c=1.59264e-17
    c1374 (\309\:VDDA \307\:VDDA) capacitor c=4.84335e-16
    c1375 (\1335\:GNDA \1313\:GNDA) capacitor c=4.96077e-17
    c1376 (\60\:S2 \44\:S2) capacitor c=8.91559e-16
    c1377 (\57\:U \1251\:GNDA) capacitor c=5.06676e-17
    c1378 (\192\:GNDA \1167\:GNDA) capacitor c=1.26043e-17
    c1379 (\72\:U \1096\:GNDA) capacitor c=1.98382e-16
    c1380 (\203\:GNDA \1088\:GNDA) capacitor c=3.21511e-17
    c1381 (\88\:BG_REF \279\:VDDA) capacitor c=4.89115e-15
    c1382 (\57\:S2 \534\:VDDA) capacitor c=1.55534e-17
    c1383 (\237\:Vm1 \22\:vv) capacitor c=2.71173e-16
    c1384 (\100\:U \1009\:GNDA) capacitor c=8.85297e-17
    c1385 (\8\:Y \34\:Vo1) capacitor c=3.31464e-17
    c1386 (\117\:U \1362\:GNDA) capacitor c=1.20979e-16
    c1387 (\71\:Vo1 \149\:S) capacitor c=7.84534e-16
    c1388 (\26\:vv \93\:VDDA) capacitor c=3.48219e-17
    c1389 (\93\:GNDA \2\:net19) capacitor c=2.62867e-16
    c1390 (\116\:U \1251\:GNDA) capacitor c=2.63597e-15
    c1391 (\1284\:GNDA \1364\:GNDA) capacitor c=3.1809e-16
    c1392 (\85\:S \34\:Vo1) capacitor c=7.86134e-17
    c1393 (\29\:X \1114\:GNDA) capacitor c=3.9676e-17
    c1394 (\137\:BG_REF \55\:S2) capacitor c=6.65996e-17
    c1395 (\19\:S2 \25\:S2) capacitor c=6.68839e-16
    c1396 (\637\:VDDA \65\:S2) capacitor c=9.64943e-17
    c1397 (\102\:U \1096\:GNDA) capacitor c=3.73689e-17
    c1398 (\69\:U \77\:U) capacitor c=1.3206e-15
    c1399 (\35\:BG_REF \279\:VDDA) capacitor c=7.10308e-16
    c1400 (\14\:BIAS \521\:GNDA) capacitor c=6.19535e-16
    c1401 (\54\:Vo1 \2\:Y) capacitor c=1.26149e-16
    c1402 (\978\:GNDA \1251\:GNDA) capacitor c=3.22349e-17
    c1403 (\23\:BG_REF \207\:S) capacitor c=1.05323e-15
    c1404 (\18\:vv \534\:VDDA) capacitor c=1.19253e-16
    c1405 (\262\:VDDA \10\:S2) capacitor c=5.28947e-16
    c1406 (\774\:GNDA \1251\:GNDA) capacitor c=5.29856e-16
    c1407 (\15\:Vs \44\:S2) capacitor c=1.0296e-15
    c1408 (\236\:S \497\:VDDA) capacitor c=2.04858e-17
    c1409 (\20\:vv \504\:VDDA) capacitor c=3.31616e-17
    c1410 (\1403\:GNDA \109\:U) capacitor c=3.72052e-17
    c1411 (\204\:S \279\:VDDA) capacitor c=4.06117e-15
    c1412 (\1049\:GNDA \1079\:GNDA) capacitor c=3.15482e-16
    c1413 (\403\:VDDA \76\:BG_REF) capacitor c=3.89918e-17
    c1414 (\137\:BG_REF \1251\:GNDA) capacitor c=1.38311e-15
    c1415 (\331\:VDDA \279\:VDDA) capacitor c=4.00809e-16
    c1416 (\6\:U \1233\:GNDA) capacitor c=1.3611e-15
    c1417 (\116\:BG_REF \73\:S2) capacitor c=4.62525e-16
    c1418 (\89\:U \1274\:GNDA) capacitor c=4.10562e-17
    c1419 (\192\:GNDA \42\:U) capacitor c=7.93593e-17
    c1420 (\21\:VDDA \279\:VDDA) capacitor c=4.1435e-15
    c1421 (\66\:U \1251\:GNDA) capacitor c=1.14364e-16
    c1422 (\1099\:GNDA \1130\:GNDA) capacitor c=4.28506e-16
    c1423 (\143\:S \7\:S) capacitor c=4.8546e-16
    c1424 (\82\:VDDA \81\:VDDA) capacitor c=2.08922e-16
    c1425 (\68\:BG_REF \279\:VDDA) capacitor c=1.15424e-16
    c1426 (\11\:U \1398\:GNDA) capacitor c=8.85297e-17
    c1427 (\140\:Vm1 \31\:Vm1) capacitor c=1.05584e-15
    c1428 (\889\:GNDA \890\:GNDA) capacitor c=4.27087e-16
    c1429 (\105\:U \363\:GNDA) capacitor c=1.3699e-16
    c1430 (\1096\:GNDA \1122\:GNDA) capacitor c=3.15482e-16
    c1431 (\137\:BG_REF \25\:D2) capacitor c=5.25329e-17
    c1432 (\7\:U \1401\:GNDA) capacitor c=6.78232e-17
    c1433 (\118\:U \107\:U) capacitor c=1.30713e-15
    c1434 (\73\:U \1335\:GNDA) capacitor c=1.81769e-16
    c1435 (\692\:VDDA \665\:VDDA) capacitor c=1.38874e-15
    c1436 (\896\:GNDA \535\:GNDA) capacitor c=8.37955e-16
    c1437 (\170\:Vm1 \304\:VDDA) capacitor c=3.50869e-16
    c1438 (\65\:S2 \55\:BG_REF) capacitor c=1.11867e-17
    c1439 (\178\:GNDA \1206\:GNDA) capacitor c=3.72052e-17
    c1440 (\29\:D1 \106\:S) capacitor c=1.31373e-16
    c1441 (\2\:net31 \218\:GNDA) capacitor c=3.87171e-16
    c1442 (\31\:Vs \1251\:GNDA) capacitor c=6.89883e-16
    c1443 (\67\:S \20\:D1) capacitor c=1.65903e-15
    c1444 (\74\:S2 \27\:vv) capacitor c=1.24156e-16
    c1445 (\71\:BG_REF \206\:S) capacitor c=1.1267e-15
    c1446 (\104\:VDDA \23\:BG_REF) capacitor c=3.86661e-16
    c1447 (\25\:Vs \11\:Vs) capacitor c=3.17134e-17
    c1448 (\148\:Vm1 \259\:VDDA) capacitor c=3.46264e-16
    c1449 (\43\:U \1159\:GNDA) capacitor c=4.10562e-17
    c1450 (\494\:GNDA \173\:GNDA) capacitor c=5.35597e-17
    c1451 (\14\:X \102\:S) capacitor c=2.1146e-15
    c1452 (\33\:vv \279\:VDDA) capacitor c=5.10401e-15
    c1453 (\105\:S2 \40\:S2) capacitor c=2.29879e-17
    c1454 (\35\:X \2\:net3) capacitor c=4.2413e-16
    c1455 (\157\:GNDA \1251\:GNDA) capacitor c=3.11265e-17
    c1456 (\902\:GNDA \684\:GNDA) capacitor c=2.94558e-16
    c1457 (\116\:Vm1 \7\:Vm1) capacitor c=1.05955e-15
    c1458 (\59\:BG_REF \279\:VDDA) capacitor c=7.11105e-16
    c1459 (\31\:VDDA \279\:VDDA) capacitor c=3.79333e-15
    c1460 (\204\:S \594\:VDDA) capacitor c=1.17566e-15
    c1461 (\202\:S \69\:Vo1) capacitor c=6.96419e-16
    c1462 (\214\:Vm1 \59\:VDDA) capacitor c=3.04777e-16
    c1463 (\202\:S \230\:GNDA) capacitor c=1.99523e-17
    c1464 (\94\:U \1088\:GNDA) capacitor c=9.05792e-17
    c1465 (\804\:VDDA \116\:Vm1) capacitor c=2.39414e-16
    c1466 (\56\:Vo1 \279\:S) capacitor c=1.0754e-16
    c1467 (\1374\:GNDA \1294\:GNDA) capacitor c=9.29257e-17
    c1468 (\25\:BG_REF \27\:S) capacitor c=4.27385e-16
    c1469 (\197\:VDDA \279\:VDDA) capacitor c=3.94428e-16
    c1470 (\2\:net26 \55\:GNDA) capacitor c=4.69977e-16
    c1471 (\49\:Vo1 \684\:GNDA) capacitor c=3.05176e-16
    c1472 (\426\:VDDA \150\:VDDA) capacitor c=4.48505e-16
    c1473 (\54\:Vo1 \200\:S) capacitor c=5.58102e-16
    c1474 (\542\:VDDA \279\:VDDA) capacitor c=5.34032e-16
    c1475 (\30\:S2 \7\:D2) capacitor c=2.67152e-16
    c1476 (\16\:U \738\:GNDA) capacitor c=1.07184e-16
    c1477 (\40\:U \494\:GNDA) capacitor c=1.60051e-16
    c1478 (\748\:VDDA \104\:BG_REF) capacitor c=7.24715e-16
    c1479 (\21\:U \1251\:GNDA) capacitor c=7.1556e-17
    c1480 (\15\:Vs \42\:S2) capacitor c=3.04869e-17
    c1481 (\205\:GNDA \738\:GNDA) capacitor c=3.11107e-17
    c1482 (\59\:U \1082\:GNDA) capacitor c=1.60051e-16
    c1483 (\80\:U \1175\:GNDA) capacitor c=1.51531e-16
    c1484 (\1362\:GNDA \363\:GNDA) capacitor c=3.05186e-17
    c1485 (\103\:S2 \33\:BG_REF) capacitor c=1.11867e-17
    c1486 (\30\:X \1136\:GNDA) capacitor c=1.60051e-16
    c1487 (\177\:GNDA \180\:GNDA) capacitor c=1.62672e-16
    c1488 (\194\:Vm1 \356\:VDDA) capacitor c=4.79798e-16
    c1489 (\88\:U \1430\:GNDA) capacitor c=1.60051e-16
    c1490 (\55\:U \826\:GNDA) capacitor c=1.60051e-16
    c1491 (\138\:Vm1 \228\:VDDA) capacitor c=3.384e-16
    c1492 (\521\:VDDA \520\:VDDA) capacitor c=2.11091e-16
    c1493 (\35\:VDDA \279\:VDDA) capacitor c=3.79368e-15
    c1494 (\1096\:GNDA \1088\:GNDA) capacitor c=9.29257e-17
    c1495 (\31\:BG_REF \235\:S) capacitor c=3.60331e-16
    c1496 (\26\:vv \194\:VDDA) capacitor c=3.31616e-17
    c1497 (\208\:Vm1 \96\:Vm1) capacitor c=8.81959e-16
    c1498 (\78\:BG_REF \279\:VDDA) capacitor c=1.15424e-16
    c1499 (\93\:U \413\:GNDA) capacitor c=1.00278e-16
    c1500 (\59\:GNDA \218\:GNDA) capacitor c=1.51275e-14
    c1501 (\17\:S \214\:VDDA) capacitor c=1.76186e-17
    c1502 (\236\:Vm1 \279\:VDDA) capacitor c=1.01334e-15
    c1503 (\205\:S \594\:VDDA) capacitor c=4.11402e-15
    c1504 (\192\:GNDA \160\:GNDA) capacitor c=2.31793e-15
    c1505 (\42\:GNDA \18\:Y) capacitor c=5.34148e-16
    c1506 (\133\:BG_REF \515\:VDDA) capacitor c=1.06273e-17
    c1507 (\756\:GNDA \1251\:GNDA) capacitor c=4.19575e-17
    c1508 (\333\:GNDA \218\:GNDA) capacitor c=5.61887e-16
    c1509 (\19\:S \279\:VDDA) capacitor c=8.3006e-16
    c1510 (\1312\:GNDA \1293\:GNDA) capacitor c=4.96077e-17
    c1511 (\133\:BG_REF \362\:VDDA) capacitor c=2.04887e-17
    c1512 (\29\:S2 \3\:vv) capacitor c=1.4289e-16
    c1513 (\65\:S \3\:S) capacitor c=4.84209e-16
    c1514 (\179\:S \102\:S) capacitor c=3.15421e-16
    c1515 (\40\:S2 \14\:BG_REF) capacitor c=3.9223e-17
    c1516 (\8\:D2 \52\:S2) capacitor c=1.40782e-16
    c1517 (\2\:net33 \2\:net20) capacitor c=2.47808e-17
    c1518 (\43\:D1 \2\:X) capacitor c=1.11079e-16
    c1519 (\85\:GNDA \2\:net4) capacitor c=5.71823e-17
    c1520 (\48\:U \188\:GNDA) capacitor c=3.73689e-17
    c1521 (\207\:GNDA \1294\:GNDA) capacitor c=3.74307e-15
    c1522 (\226\:VDDA \22\:S) capacitor c=1.23003e-16
    c1523 (\305\:VDDA \310\:VDDA) capacitor c=4.75166e-16
    c1524 (\206\:S \16\:vv) capacitor c=5.11376e-16
    c1525 (\220\:Vm1 \482\:VDDA) capacitor c=2.24131e-16
    c1526 (\122\:GNDA \121\:GNDA) capacitor c=4.26739e-16
    c1527 (\39\:VDDA \279\:VDDA) capacitor c=3.79386e-15
    c1528 (\221\:S \73\:S2) capacitor c=1.31478e-16
    c1529 (\130\:Vm1 \21\:Vm1) capacitor c=1.78161e-16
    c1530 (\26\:vv \29\:S) capacitor c=1.3147e-17
    c1531 (\27\:BG_REF \15\:S) capacitor c=4.21143e-16
    c1532 (\104\:BG_REF \279\:VDDA) capacitor c=7.30306e-16
    c1533 (\1200\:GNDA \1218\:GNDA) capacitor c=1.49181e-16
    c1534 (\247\:S \137\:BG_REF) capacitor c=4.66979e-16
    c1535 (\34\:vv \138\:BG_REF) capacitor c=5.02653e-16
    c1536 (\12\:vv \12\:S2) capacitor c=4.59215e-17
    c1537 (\121\:S \119\:S) capacitor c=1.23567e-15
    c1538 (\134\:BG_REF \130\:VDDA) capacitor c=1.03669e-17
    c1539 (\142\:Vm1 \279\:VDDA) capacitor c=3.74601e-16
    c1540 (\26\:S2 \4\:S2) capacitor c=2.95867e-17
    c1541 (\78\:U \1054\:GNDA) capacitor c=8.85297e-17
    c1542 (\3\:S2 \12\:BG_REF) capacitor c=2.65493e-17
    c1543 (\1138\:GNDA \1140\:GNDA) capacitor c=3.58119e-17
    c1544 (\31\:Vo1 \5\:Y) capacitor c=2.39723e-17
    c1545 (\25\:vv \508\:VDDA) capacitor c=3.31616e-17
    c1546 (\21\:vv \32\:S) capacitor c=3.31616e-17
    c1547 (\19\:Vo1 \684\:GNDA) capacitor c=3.33803e-17
    c1548 (\59\:BG_REF \348\:VDDA) capacitor c=3.01323e-16
    c1549 (\39\:S \298\:VDDA) capacitor c=1.0082e-17
    c1550 (\332\:GNDA \333\:GNDA) capacitor c=6.4313e-17
    c1551 (\751\:VDDA \105\:BG_REF) capacitor c=1.10524e-15
    c1552 (\83\:U \1172\:GNDA) capacitor c=4.6967e-17
    c1553 (\205\:S \534\:VDDA) capacitor c=1.01669e-16
    c1554 (\65\:BG_REF \281\:VDDA) capacitor c=1.23247e-17
    c1555 (\75\:U \839\:GNDA) capacitor c=1.3611e-15
    c1556 (\2\:net13 \218\:GNDA) capacitor c=3.58367e-16
    c1557 (\81\:U \1088\:GNDA) capacitor c=3.8545e-17
    c1558 (\1251\:GNDA \1265\:GNDA) capacitor c=3.15482e-16
    c1559 (\195\:VDDA \17\:S) capacitor c=1.2913e-16
    c1560 (\712\:GNDA \641\:GNDA) capacitor c=3.72052e-17
    c1561 (\55\:BG_REF \312\:VDDA) capacitor c=1.36315e-17
    c1562 (\43\:D1 \54\:Vo1) capacitor c=2.93808e-15
    c1563 (\113\:S \102\:S) capacitor c=5.52163e-16
    c1564 (\168\:GNDA \1105\:GNDA) capacitor c=3.72052e-17
    c1565 (\399\:VDDA \71\:BG_REF) capacitor c=5.37491e-16
    c1566 (\378\:VDDA \279\:VDDA) capacitor c=3.49511e-16
    c1567 (\57\:Vo1 \56\:Vo1) capacitor c=2.75254e-17
    c1568 (\265\:S \102\:S) capacitor c=5.03338e-16
    c1569 (\97\:U \449\:GNDA) capacitor c=4.10562e-17
    c1570 (\83\:Vm1 \279\:VDDA) capacitor c=3.96003e-15
    c1571 (\118\:Vm1 \112\:VDDA) capacitor c=4.39105e-16
    c1572 (\205\:GNDA \1294\:GNDA) capacitor c=1.26043e-17
    c1573 (\19\:U \1005\:GNDA) capacitor c=3.54052e-16
    c1574 (\39\:U \1024\:GNDA) capacitor c=4.10562e-17
    c1575 (\44\:U \1324\:GNDA) capacitor c=5.76316e-17
    c1576 (\1362\:GNDA \1096\:GNDA) capacitor c=3.76928e-15
    c1577 (\166\:S \149\:S) capacitor c=9.45384e-16
    c1578 (\1518\:GNDA \39\:D1) capacitor c=8.10789e-16
    c1579 (\216\:S \279\:VDDA) capacitor c=9.65029e-16
    c1580 (\192\:GNDA \46\:U) capacitor c=6.66184e-17
    c1581 (\776\:VDDA \236\:Vm1) capacitor c=6.78696e-16
    c1582 (\59\:GNDA \2\:net18) capacitor c=3.76945e-16
    c1583 (\37\:BG_REF \176\:VDDA) capacitor c=1.23738e-17
    c1584 (\559\:VDDA \137\:BG_REF) capacitor c=1.41532e-16
    c1585 (\207\:GNDA \25\:U) capacitor c=7.93593e-17
    c1586 (\72\:S2 \77\:BG_REF) capacitor c=1.11867e-17
    c1587 (\29\:D1 \31\:Vo1) capacitor c=5.31358e-16
    c1588 (\45\:U \515\:GNDA) capacitor c=8.42645e-17
    c1589 (\208\:S \505\:VDDA) capacitor c=1.06321e-17
    c1590 (\15\:GNDA \218\:GNDA) capacitor c=5.12942e-17
    c1591 (\44\:Vo1 \541\:GNDA) capacitor c=3.15288e-16
    c1592 (\2\:net16 \218\:GNDA) capacitor c=3.72606e-16
    c1593 (\896\:GNDA \1374\:GNDA) capacitor c=3.39571e-17
    c1594 (\633\:VDDA \594\:VDDA) capacitor c=7.29601e-16
    c1595 (\905\:GNDA \1068\:GNDA) capacitor c=4.80602e-15
    c1596 (\101\:U \935\:GNDA) capacitor c=4.6967e-17
    c1597 (\239\:S \34\:vv) capacitor c=5.23282e-16
    c1598 (\896\:GNDA \1256\:GNDA) capacitor c=2.31744e-15
    c1599 (\330\:GNDA \18\:GNDA) capacitor c=1.25169e-17
    c1600 (\604\:VDDA \1251\:GNDA) capacitor c=1.17404e-14
    c1601 (\81\:BG_REF \65\:VDDA) capacitor c=1.33555e-17
    c1602 (\614\:VDDA \1251\:GNDA) capacitor c=4.37708e-15
    c1603 (\2\:net7 \116\:GNDA) capacitor c=2.44226e-15
    c1604 (\206\:S \67\:S2) capacitor c=1.31551e-16
    c1605 (\62\:U \1481\:GNDA) capacitor c=2.76001e-17
    c1606 (\542\:VDDA \534\:VDDA) capacitor c=4.94886e-16
    c1607 (\905\:GNDA \154\:GNDA) capacitor c=2.32787e-16
    c1608 (\27\:vv \48\:S) capacitor c=3.40015e-17
    c1609 (\66\:S2 \279\:VDDA) capacitor c=3.0361e-15
    c1610 (\34\:X \2\:net32) capacitor c=3.62251e-16
    c1611 (\230\:VDDA \279\:VDDA) capacitor c=4.53555e-16
    c1612 (\58\:D1 \59\:D1) capacitor c=1.46334e-15
    c1613 (\85\:U \1377\:GNDA) capacitor c=2.73391e-17
    c1614 (\104\:VDDA \3\:VDDA) capacitor c=8.50684e-16
    c1615 (\603\:GNDA \366\:GNDA) capacitor c=4.6967e-17
    c1616 (\148\:Vm1 \243\:VDDA) capacitor c=4.66304e-16
    c1617 (\996\:GNDA \890\:GNDA) capacitor c=9.29257e-17
    c1618 (\1535\:GNDA \758\:GNDA) capacitor c=5.4892e-16
    c1619 (\37\:BG_REF \211\:VDDA) capacitor c=1.02632e-17
    c1620 (\26\:BG_REF \279\:VDDA) capacitor c=1.15121e-16
    c1621 (\21\:Vs \1251\:GNDA) capacitor c=8.12001e-16
    c1622 (\120\:BG_REF \237\:S) capacitor c=1.31478e-16
    c1623 (\29\:U \165\:GNDA) capacitor c=3.11605e-16
    c1624 (\67\:S2 \534\:VDDA) capacitor c=6.6252e-17
    c1625 (\17\:vv \167\:VDDA) capacitor c=3.40015e-17
    c1626 (\2\:net24 \24\:GNDA) capacitor c=9.08877e-16
    c1627 (\6\:Vs \535\:GNDA) capacitor c=8.47953e-17
    c1628 (\30\:U \168\:GNDA) capacitor c=1.63679e-16
    c1629 (\19\:S2 \12\:BG_REF) capacitor c=5.16983e-17
    c1630 (\1195\:GNDA \1166\:GNDA) capacitor c=4.96077e-17
    c1631 (\83\:U \1238\:GNDA) capacitor c=1.14364e-16
    c1632 (\237\:Vm1 \111\:BG_REF) capacitor c=1.52034e-15
    c1633 (\93\:GNDA \230\:GNDA) capacitor c=1.71106e-17
    c1634 (\7\:vv \24\:S) capacitor c=3.31616e-17
    c1635 (\366\:VDDA \45\:S) capacitor c=1.28412e-16
    c1636 (\65\:S2 \487\:VDDA) capacitor c=1.23137e-17
    c1637 (\14\:S2 \13\:S2) capacitor c=4.4244e-16
    c1638 (\192\:GNDA \1284\:GNDA) capacitor c=3.23456e-17
    c1639 (\1214\:GNDA \1215\:GNDA) capacitor c=4.10585e-16
    c1640 (\271\:Vm1 \900\:VDDA) capacitor c=3.06548e-16
    c1641 (\910\:VDDA \279\:VDDA) capacitor c=1.40596e-15
    c1642 (\25\:U \1006\:GNDA) capacitor c=3.73689e-17
    c1643 (\203\:GNDA \1201\:GNDA) capacitor c=3.22597e-17
    c1644 (\134\:BG_REF \166\:VDDA) capacitor c=1.03669e-17
    c1645 (\23\:S \279\:VDDA) capacitor c=1.12465e-15
    c1646 (\212\:GNDA \27\:Vs) capacitor c=8.32365e-17
    c1647 (\395\:VDDA \426\:VDDA) capacitor c=6.13053e-16
    c1648 (\17\:vv \633\:VDDA) capacitor c=1.98007e-16
    c1649 (\2\:net32 \2\:net15) capacitor c=5.11628e-16
    c1650 (\192\:GNDA \175\:GNDA) capacitor c=2.31665e-15
    c1651 (\207\:GNDA \776\:GNDA) capacitor c=3.40138e-17
    c1652 (\103\:S2 \28\:vv) capacitor c=6.98069e-15
    c1653 (\236\:Vm1 \24\:vv) capacitor c=3.1837e-16
    c1654 (\6\:Y \8\:X) capacitor c=1.63806e-17
    c1655 (\2\:Vm1 \279\:VDDA) capacitor c=3.92678e-15
    c1656 (\1362\:GNDA \961\:GNDA) capacitor c=3.1596e-17
    c1657 (\18\:vv \64\:BG_REF) capacitor c=3.40015e-17
    c1658 (\193\:S \149\:S) capacitor c=7.0706e-16
    c1659 (\850\:GNDA \1251\:GNDA) capacitor c=1.21942e-15
    c1660 (\27\:U \776\:GNDA) capacitor c=1.42235e-16
    c1661 (\37\:BG_REF \246\:VDDA) capacitor c=1.23247e-17
    c1662 (\297\:Vm1 \590\:VDDA) capacitor c=4.50702e-16
    c1663 (\378\:GNDA \373\:GNDA) capacitor c=6.44491e-17
    c1664 (\87\:U \1427\:GNDA) capacitor c=4.6967e-17
    c1665 (\11\:U \1401\:GNDA) capacitor c=1.60051e-16
    c1666 (\192\:GNDA \669\:GNDA) capacitor c=2.26777e-16
    c1667 (\21\:U \794\:GNDA) capacitor c=1.60051e-16
    c1668 (\227\:S \25\:vv) capacitor c=5.11039e-16
    c1669 (\1394\:GNDA \1421\:GNDA) capacitor c=4.32889e-16
    c1670 (\131\:U \905\:GNDA) capacitor c=8.13352e-15
    c1671 (\15\:Vs \43\:S2) capacitor c=1.09081e-16
    c1672 (\79\:U \1054\:GNDA) capacitor c=1.3611e-15
    c1673 (\33\:vv \512\:VDDA) capacitor c=3.31616e-17
    c1674 (\45\:U \905\:GNDA) capacitor c=2.54339e-15
    c1675 (\905\:GNDA \1040\:GNDA) capacitor c=3.63473e-15
    c1676 (\4\:GNDA \11\:GNDA) capacitor c=2.72885e-16
    c1677 (\692\:VDDA \279\:VDDA) capacitor c=5.98977e-16
    c1678 (\2\:net30 \3\:net30) capacitor c=7.23428e-16
    c1679 (\10\:GNDA \218\:GNDA) capacitor c=6.6369e-15
    c1680 (\720\:VDDA \23\:BG_REF) capacitor c=1.43076e-16
    c1681 (\19\:Vs \535\:GNDA) capacitor c=9.10113e-17
    c1682 (\156\:Vm1 \279\:VDDA) capacitor c=3.74341e-16
    c1683 (\208\:S \57\:VDDA) capacitor c=1.03845e-17
    c1684 (\66\:S2 \3\:VDDA) capacitor c=1.34744e-17
    c1685 (\336\:VDDA \44\:S) capacitor c=5.28947e-16
    c1686 (\28\:vv \161\:VDDA) capacitor c=3.31616e-17
    c1687 (\207\:GNDA \535\:GNDA) capacitor c=1.7606e-16
    c1688 (\594\:VDDA \614\:VDDA) capacitor c=3.87218e-15
    c1689 (\267\:VDDA \29\:S) capacitor c=1.28262e-16
    c1690 (\205\:GNDA \968\:GNDA) capacitor c=2.24602e-15
    c1691 (\593\:GNDA \66\:GNDA) capacitor c=1.02325e-17
    c1692 (\31\:Vo1 \149\:S) capacitor c=3.99272e-16
    c1693 (\491\:VDDA \105\:BG_REF) capacitor c=1.98136e-16
    c1694 (\25\:U \1029\:GNDA) capacitor c=8.85297e-17
    c1695 (\136\:BG_REF \718\:GNDA) capacitor c=4.37009e-16
    c1696 (\572\:VDDA \279\:VDDA) capacitor c=5.95799e-16
    c1697 (\227\:S \102\:S2) capacitor c=1.31551e-16
    c1698 (\411\:VDDA \279\:VDDA) capacitor c=3.71677e-16
    c1699 (\138\:GNDA \6\:Vs) capacitor c=4.87841e-16
    c1700 (\11\:Vm1 \12\:Vm1) capacitor c=6.45654e-16
    c1701 (\19\:U \1006\:GNDA) capacitor c=1.18525e-16
    c1702 (\53\:VDDA \279\:VDDA) capacitor c=4.421e-15
    c1703 (\34\:Vo1 \7\:Y) capacitor c=2.24232e-17
    c1704 (\474\:VDDA \73\:BG_REF) capacitor c=1.56999e-16
    c1705 (\47\:S2 \44\:S2) capacitor c=8.62286e-16
    c1706 (\210\:Vm1 \438\:VDDA) capacitor c=4.6299e-16
    c1707 (\243\:GNDA \684\:GNDA) capacitor c=1.11282e-15
    c1708 (\66\:S2 \17\:vv) capacitor c=7.87739e-15
    c1709 (\621\:VDDA \279\:VDDA) capacitor c=3.00042e-16
    c1710 (\71\:U \1088\:GNDA) capacitor c=1.92194e-16
    c1711 (\82\:S2 \60\:S2) capacitor c=2.64149e-16
    c1712 (\205\:GNDA \954\:GNDA) capacitor c=3.74331e-15
    c1713 (\66\:GNDA \218\:GNDA) capacitor c=3.31037e-14
    c1714 (\91\:U \1362\:GNDA) capacitor c=8.51466e-16
    c1715 (\15\:S \71\:S2) capacitor c=7.90593e-16
    c1716 (\247\:VDDA \279\:VDDA) capacitor c=3.34076e-16
    c1717 (\216\:S \19\:vv) capacitor c=5.23282e-16
    c1718 (\4\:U \1293\:GNDA) capacitor c=4.09732e-16
    c1719 (\26\:vv \804\:VDDA) capacitor c=5.45001e-17
    c1720 (\83\:S \24\:D1) capacitor c=6.24816e-16
    c1721 (\71\:Vo1 \1251\:GNDA) capacitor c=1.60554e-16
    c1722 (\192\:GNDA \48\:U) capacitor c=7.93593e-17
    c1723 (\204\:Vm1 \389\:VDDA) capacitor c=4.65703e-16
    c1724 (\6\:BIAS \5\:BIAS) capacitor c=3.872e-16
    c1725 (\669\:GNDA \672\:GNDA) capacitor c=3.11236e-16
    c1726 (\2\:Vo2 \728\:GNDA) capacitor c=4.16972e-17
    c1727 (\110\:Vm1 \88\:VDDA) capacitor c=3.22227e-16
    c1728 (\160\:Vm1 \294\:VDDA) capacitor c=3.50869e-16
    c1729 (\84\:U \1472\:GNDA) capacitor c=5.25176e-17
    c1730 (\2\:GNDA \218\:GNDA) capacitor c=6.12143e-16
    c1731 (\31\:BG_REF \29\:S) capacitor c=4.27385e-16
    c1732 (\590\:VDDA \279\:VDDA) capacitor c=4.19643e-16
    c1733 (\58\:D1 \149\:S) capacitor c=2.31489e-16
    c1734 (\76\:S2 \34\:vv) capacitor c=2.24666e-16
    c1735 (\29\:D1 \10\:X) capacitor c=6.02843e-17
    c1736 (\71\:BG_REF \279\:VDDA) capacitor c=1.00128e-15
    c1737 (\65\:U \1265\:GNDA) capacitor c=8.85297e-17
    c1738 (\203\:GNDA \93\:U) capacitor c=1.68936e-15
    c1739 (\93\:U \996\:GNDA) capacitor c=1.63679e-16
    c1740 (\52\:U \956\:GNDA) capacitor c=5.22083e-17
    c1741 (\22\:Vo1 \70\:S) capacitor c=1.25487e-16
    c1742 (\207\:GNDA \9\:U) capacitor c=6.66184e-17
    c1743 (\282\:VDDA \65\:BG_REF) capacitor c=2.93949e-16
    c1744 (\27\:U \205\:GNDA) capacitor c=1.57117e-15
    c1745 (\17\:Vo1 \1251\:GNDA) capacitor c=1.52458e-15
    c1746 (\88\:BG_REF \206\:S) capacitor c=2.04489e-16
    c1747 (\239\:S \23\:VDDA) capacitor c=1.34744e-17
    c1748 (\1415\:GNDA \1432\:GNDA) capacitor c=4.25978e-16
    c1749 (\267\:VDDA \279\:VDDA) capacitor c=3.98659e-16
    c1750 (\539\:GNDA \363\:GNDA) capacitor c=1.79046e-16
    c1751 (\203\:GNDA \641\:GNDA) capacitor c=3.79068e-16
    c1752 (\113\:S \33\:D1) capacitor c=3.34161e-16
    c1753 (\190\:Vm1 \368\:VDDA) capacitor c=3.47479e-16
    c1754 (\2\:net9 \2\:net12) capacitor c=4.60022e-17
    c1755 (\506\:GNDA \182\:GNDA) capacitor c=4.96077e-17
    c1756 (\111\:BG_REF \227\:S) capacitor c=1.31405e-16
    c1757 (\335\:VDDA \67\:BG_REF) capacitor c=3.26283e-16
    c1758 (\928\:GNDA \77\:U) capacitor c=3.59294e-17
    c1759 (\230\:GNDA \9\:BG_REF) capacitor c=2.46923e-17
    c1760 (\60\:Vm1 \279\:VDDA) capacitor c=3.92623e-15
    c1761 (\163\:GNDA \158\:GNDA) capacitor c=9.29257e-17
    c1762 (\549\:GNDA \550\:GNDA) capacitor c=1.42026e-15
    c1763 (\366\:VDDA \46\:S) capacitor c=1.22461e-16
    c1764 (\203\:GNDA \467\:GNDA) capacitor c=2.36693e-15
    c1765 (\1362\:GNDA \1377\:GNDA) capacitor c=2.7733e-15
    c1766 (\16\:BG_REF \218\:GNDA) capacitor c=9.87962e-16
    c1767 (\26\:U \1133\:GNDA) capacitor c=4.6967e-17
    c1768 (\207\:GNDA \956\:GNDA) capacitor c=2.24478e-15
    c1769 (\2\:net1 \115\:GNDA) capacitor c=3.77978e-16
    c1770 (\47\:BG_REF \242\:VDDA) capacitor c=1.35815e-17
    c1771 (\24\:U \961\:GNDA) capacitor c=3.88004e-17
    c1772 (\2\:net30 \2\:net26) capacitor c=4.57306e-17
    c1773 (\16\:vv \467\:VDDA) capacitor c=3.31616e-17
    c1774 (\158\:S \102\:S) capacitor c=4.50157e-16
    c1775 (\450\:VDDA \279\:VDDA) capacitor c=2.53529e-16
    c1776 (\212\:GNDA \203\:GNDA) capacitor c=6.89722e-16
    c1777 (\230\:GNDA \1\:BG_REF) capacitor c=4.50788e-17
    c1778 (\27\:vv \57\:S2) capacitor c=2.48011e-17
    c1779 (\2\:net41 \52\:GNDA) capacitor c=5.23657e-15
    c1780 (\16\:vv \88\:BG_REF) capacitor c=4.92479e-16
    c1781 (\66\:S2 \720\:VDDA) capacitor c=4.19417e-16
    c1782 (\14\:Y \40\:Vo1) capacitor c=1.77348e-17
    c1783 (\241\:S \904\:VDDA) capacitor c=1.1241e-16
    c1784 (\42\:D1 \51\:Vo1) capacitor c=4.8773e-16
    c1785 (\138\:Vm1 \212\:VDDA) capacitor c=4.89293e-16
    c1786 (\23\:D1 \102\:S) capacitor c=7.29304e-16
    c1787 (\77\:BG_REF \222\:S) capacitor c=4.90797e-16
    c1788 (\250\:GNDA \1251\:GNDA) capacitor c=5.24026e-15
    c1789 (\534\:GNDA \1251\:GNDA) capacitor c=3.53199e-15
    c1790 (\90\:BG_REF \65\:S2) capacitor c=4.62525e-16
    c1791 (\205\:GNDA \44\:U) capacitor c=1.46272e-15
    c1792 (\71\:S2 \230\:GNDA) capacitor c=1.63858e-17
    c1793 (\133\:BG_REF \376\:VDDA) capacitor c=1.03669e-17
    c1794 (\7\:vv \66\:BG_REF) capacitor c=3.40015e-17
    c1795 (\263\:VDDA \37\:BG_REF) capacitor c=3.23487e-16
    c1796 (\1527\:GNDA \18\:Vo1) capacitor c=4.50396e-16
    c1797 (\73\:S2 \7\:vv) capacitor c=2.65616e-15
    c1798 (\50\:BG_REF \279\:VDDA) capacitor c=1.15424e-16
    c1799 (\103\:S2 \860\:VDDA) capacitor c=4.19417e-16
    c1800 (\550\:GNDA \7\:BG_REF) capacitor c=2.6106e-16
    c1801 (\85\:U \1472\:GNDA) capacitor c=1.11161e-16
    c1802 (\896\:GNDA \1500\:GNDA) capacitor c=3.69127e-16
    c1803 (\205\:GNDA \1324\:GNDA) capacitor c=4.30974e-15
    c1804 (\57\:S2 \1251\:GNDA) capacitor c=2.1393e-16
    c1805 (\89\:S \31\:Vo1) capacitor c=1.70557e-15
    c1806 (\69\:U \978\:GNDA) capacitor c=1.82468e-16
    c1807 (\96\:VDDA \279\:VDDA) capacitor c=3.86108e-16
    c1808 (\192\:GNDA \190\:GNDA) capacitor c=2.31665e-15
    c1809 (\103\:S2 \230\:GNDA) capacitor c=1.63858e-17
    c1810 (\27\:vv \371\:VDDA) capacitor c=3.31616e-17
    c1811 (\154\:GNDA \870\:GNDA) capacitor c=2.34459e-16
    c1812 (\4\:GNDA \2\:GNDA) capacitor c=6.10753e-16
    c1813 (\192\:GNDA \149\:GNDA) capacitor c=5.27556e-16
    c1814 (\28\:Vo1 \26\:D1) capacitor c=5.30583e-16
    c1815 (\774\:GNDA \230\:GNDA) capacitor c=3.2846e-16
    c1816 (\1057\:GNDA \1034\:GNDA) capacitor c=5.35597e-17
    c1817 (\117\:BG_REF \63\:VDDA) capacitor c=1.33555e-17
    c1818 (\84\:U \896\:GNDA) capacitor c=8.51404e-16
    c1819 (\555\:VDDA \534\:VDDA) capacitor c=2.49468e-16
    c1820 (\17\:S2 \2\:S2) capacitor c=2.18685e-16
    c1821 (\207\:S \230\:GNDA) capacitor c=1.63858e-17
    c1822 (\1313\:GNDA \1332\:GNDA) capacitor c=1.49158e-16
    c1823 (\170\:Vm1 \279\:VDDA) capacitor c=3.70428e-16
    c1824 (\26\:D2 \1251\:GNDA) capacitor c=6.01561e-16
    c1825 (\11\:D1 \1251\:GNDA) capacitor c=5.3878e-16
    c1826 (\497\:VDDA \65\:VDDA) capacitor c=1.86343e-16
    c1827 (\87\:BG_REF \1251\:GNDA) capacitor c=2.84239e-16
    c1828 (\354\:VDDA \67\:BG_REF) capacitor c=2.87197e-16
    c1829 (\232\:VDDA \25\:S) capacitor c=1.28281e-16
    c1830 (\22\:BIAS \222\:Vm1) capacitor c=8.16372e-16
    c1831 (\104\:U \1355\:GNDA) capacitor c=5.25176e-17
    c1832 (\4\:U \1314\:GNDA) capacitor c=1.70814e-16
    c1833 (\34\:vv \127\:VDDA) capacitor c=3.31616e-17
    c1834 (\221\:S \7\:VDDA) capacitor c=1.03845e-17
    c1835 (\70\:GNDA \2\:net29) capacitor c=1.02323e-16
    c1836 (\259\:VDDA \52\:BG_REF) capacitor c=3.8451e-17
    c1837 (\207\:GNDA \1403\:GNDA) capacitor c=1.33732e-17
    c1838 (\27\:S \73\:BG_REF) capacitor c=3.01064e-16
    c1839 (\30\:BG_REF \9\:VDDA) capacitor c=2.14804e-17
    c1840 (\1130\:GNDA \1040\:GNDA) capacitor c=4.6967e-17
    c1841 (\226\:S \230\:GNDA) capacitor c=1.63756e-17
    c1842 (\110\:VDDA \279\:VDDA) capacitor c=2.52177e-16
    c1843 (\230\:GNDA \218\:GNDA) capacitor c=1.56637e-14
    c1844 (\1362\:GNDA \68\:U) capacitor c=1.46275e-15
    c1845 (\593\:GNDA \1\:GNDA) capacitor c=1.31326e-15
    c1846 (\210\:Vm1 \98\:Vm1) capacitor c=8.8327e-16
    c1847 (\672\:GNDA \521\:GNDA) capacitor c=1.88594e-17
    c1848 (\117\:BG_REF \74\:S2) capacitor c=4.62525e-16
    c1849 (\144\:Vm1 \234\:VDDA) capacitor c=3.384e-16
    c1850 (\65\:U \1268\:GNDA) capacitor c=1.60051e-16
    c1851 (\74\:U \842\:GNDA) capacitor c=1.60051e-16
    c1852 (\83\:BG_REF \136\:BG_REF) capacitor c=4.18501e-17
    c1853 (\204\:S \534\:VDDA) capacitor c=1.11147e-16
    c1854 (\203\:GNDA \70\:GNDA) capacitor c=6.9058e-17
    c1855 (\105\:S \103\:S) capacitor c=1.23567e-15
    c1856 (\6\:BIAS \1251\:GNDA) capacitor c=1.36044e-15
    c1857 (\136\:Vm1 \27\:Vm1) capacitor c=1.05584e-15
    c1858 (\4\:vv \11\:D2) capacitor c=5.05828e-17
    c1859 (\1561\:GNDA \1251\:GNDA) capacitor c=3.22984e-17
    c1860 (\2\:net9 \55\:GNDA) capacitor c=2.60964e-15
    c1861 (\205\:GNDA \55\:U) capacitor c=7.93593e-17
    c1862 (\230\:GNDA \10\:GNDA) capacitor c=2.2191e-16
    c1863 (\239\:S \230\:GNDA) capacitor c=1.63858e-17
    c1864 (\224\:Vm1 \1251\:GNDA) capacitor c=9.32295e-16
    c1865 (\247\:S \47\:D1) capacitor c=8.25681e-16
    c1866 (\905\:GNDA \1432\:GNDA) capacitor c=5.59716e-15
    c1867 (\106\:GNDA \218\:GNDA) capacitor c=8.92333e-15
    c1868 (\288\:VDDA \279\:VDDA) capacitor c=3.29407e-16
    c1869 (\239\:S \897\:VDDA) capacitor c=4.2408e-16
    c1870 (\203\:GNDA \378\:GNDA) capacitor c=2.16369e-16
    c1871 (\68\:U \797\:GNDA) capacitor c=3.54052e-16
    c1872 (\75\:U \835\:GNDA) capacitor c=4.6967e-17
    c1873 (\22\:U \956\:GNDA) capacitor c=4.6967e-17
    c1874 (\180\:Vm1 \335\:VDDA) capacitor c=3.49531e-16
    c1875 (\12\:BIAS \275\:Vm1) capacitor c=6.0175e-16
    c1876 (\918\:VDDA \594\:VDDA) capacitor c=6.49964e-15
    c1877 (\54\:BG_REF \279\:VDDA) capacitor c=1.15424e-16
    c1878 (\88\:S2 \95\:S2) capacitor c=1.44417e-16
    c1879 (\954\:GNDA \968\:GNDA) capacitor c=3.13925e-16
    c1880 (\100\:BG_REF \230\:GNDA) capacitor c=1.69312e-17
    c1881 (\50\:U \230\:GNDA) capacitor c=1.59214e-16
    c1882 (\72\:VDDA \71\:VDDA) capacitor c=2.08922e-16
    c1883 (\1\:BIAS \1251\:GNDA) capacitor c=1.49863e-15
    c1884 (\8\:S \102\:S) capacitor c=4.05125e-16
    c1885 (\124\:VDDA \279\:VDDA) capacitor c=2.95619e-16
    c1886 (\960\:GNDA \961\:GNDA) capacitor c=4.27087e-16
    c1887 (\20\:vv \475\:VDDA) capacitor c=3.31616e-17
    c1888 (\2\:net11 \218\:GNDA) capacitor c=3.71646e-16
    c1889 (\54\:Vo1 \172\:S) capacitor c=1.22071e-16
    c1890 (\10\:BIAS \1251\:GNDA) capacitor c=4.94356e-16
    c1891 (\472\:VDDA \279\:VDDA) capacitor c=2.65004e-16
    c1892 (\15\:GNDA \14\:GNDA) capacitor c=7.67775e-17
    c1893 (\53\:U \1082\:GNDA) capacitor c=6.78232e-17
    c1894 (\38\:D1 \149\:S) capacitor c=5.18359e-16
    c1895 (\4\:Vo1 \1251\:GNDA) capacitor c=6.71729e-16
    c1896 (\550\:GNDA \684\:GNDA) capacitor c=9.4747e-16
    c1897 (\92\:S2 \22\:Vs) capacitor c=2.92469e-16
    c1898 (\16\:U \827\:GNDA) capacitor c=5.71258e-17
    c1899 (\116\:BG_REF \230\:GNDA) capacitor c=1.69312e-17
    c1900 (\68\:U \75\:U) capacitor c=1.69405e-17
    c1901 (\43\:U \500\:GNDA) capacitor c=5.82324e-17
    c1902 (\1523\:GNDA \118\:GNDA) capacitor c=3.03202e-16
    c1903 (\67\:BG_REF \353\:VDDA) capacitor c=1.13151e-17
    c1904 (\16\:U \230\:GNDA) capacitor c=1.58212e-16
    c1905 (\896\:GNDA \738\:GNDA) capacitor c=3.87281e-17
    c1906 (\117\:VDDA \24\:BG_REF) capacitor c=5.18673e-16
    c1907 (\900\:VDDA \279\:VDDA) capacitor c=3.86188e-15
    c1908 (\619\:VDDA \68\:S2) capacitor c=1.09771e-16
    c1909 (\31\:D2 \12\:vv) capacitor c=3.26747e-16
    c1910 (\47\:BG_REF \243\:VDDA) capacitor c=3.01353e-16
    c1911 (\65\:S2 \536\:VDDA) capacitor c=5.13593e-16
    c1912 (\302\:VDDA \279\:VDDA) capacitor c=4.01187e-16
    c1913 (\23\:D2 \44\:S2) capacitor c=1.07467e-15
    c1914 (\89\:BG_REF \207\:S) capacitor c=2.04562e-16
    c1915 (\28\:U \476\:GNDA) capacitor c=6.78232e-17
    c1916 (\206\:Vm1 \407\:VDDA) capacitor c=3.4614e-16
    c1917 (\44\:S2 \6\:vv) capacitor c=1.16996e-17
    c1918 (\107\:U \1218\:GNDA) capacitor c=1.26142e-15
    c1919 (\809\:GNDA \1251\:GNDA) capacitor c=5.93279e-16
    c1920 (\56\:U \784\:GNDA) capacitor c=1.14364e-16
    c1921 (\18\:vv \363\:VDDA) capacitor c=3.31616e-17
    c1922 (\108\:Vm1 \279\:VDDA) capacitor c=3.92678e-15
    c1923 (\19\:vv \24\:BG_REF) capacitor c=3.40015e-17
    c1924 (\203\:GNDA \1355\:GNDA) capacitor c=1.55094e-16
    c1925 (\335\:VDDA \41\:S) capacitor c=1.27935e-16
    c1926 (\27\:BG_REF \279\:VDDA) capacitor c=9.7876e-16
    c1927 (\129\:S \141\:S) capacitor c=1.70245e-15
    c1928 (\489\:VDDA \279\:VDDA) capacitor c=2.51763e-16
    c1929 (\832\:VDDA \31\:BG_REF) capacitor c=1.43076e-16
    c1930 (\216\:S \748\:VDDA) capacitor c=3.83836e-16
    c1931 (\286\:Vm1 \230\:GNDA) capacitor c=1.71068e-16
    c1932 (\1262\:GNDA \1181\:GNDA) capacitor c=4.6967e-17
    c1933 (\14\:S2 \22\:S2) capacitor c=1.34643e-16
    c1934 (\207\:GNDA \1555\:GNDA) capacitor c=2.18104e-17
    c1935 (\158\:S \149\:S) capacitor c=1.12432e-15
    c1936 (VDDA \230\:GNDA) capacitor c=3.83626e-16
    c1937 (\425\:GNDA \431\:GNDA) capacitor c=3.37157e-16
    c1938 (\112\:Vm1 \106\:VDDA) capacitor c=4.39105e-16
    c1939 (\259\:Vm1 \579\:VDDA) capacitor c=7.65022e-16
    c1940 (\658\:VDDA \279\:VDDA) capacitor c=1.15127e-15
    c1941 (\68\:U \896\:GNDA) capacitor c=8.51466e-16
    c1942 (\2\:net39 \11\:GNDA) capacitor c=2.72781e-15
    c1943 (\308\:VDDA \279\:VDDA) capacitor c=3.23729e-16
    c1944 (\17\:Y \1251\:GNDA) capacitor c=1.3819e-16
    c1945 (\259\:Vm1 \230\:GNDA) capacitor c=1.80952e-16
    c1946 (\49\:Vo1 \849\:GNDA) capacitor c=2.16253e-16
    c1947 (\86\:S2 \35\:S2) capacitor c=7.41148e-17
    c1948 (\3\:Vs \27\:S2) capacitor c=7.15865e-16
    c1949 (\45\:U \203\:GNDA) capacitor c=4.84482e-16
    c1950 (\579\:VDDA \534\:VDDA) capacitor c=2.81835e-16
    c1951 (\16\:U \896\:GNDA) capacitor c=1.62424e-15
    c1952 (\231\:VDDA \26\:S) capacitor c=5.28406e-16
    c1953 (BG_REF \230\:GNDA) capacitor c=9.02901e-17
    c1954 (\58\:BG_REF \279\:VDDA) capacitor c=1.15424e-16
    c1955 (\3\:U \1251\:GNDA) capacitor c=6.849e-16
    c1956 (\19\:S2 \3\:S2) capacitor c=1.02549e-16
    c1957 (\905\:GNDA \1447\:GNDA) capacitor c=3.59273e-15
    c1958 (\1175\:GNDA \1172\:GNDA) capacitor c=7.95573e-17
    c1959 (\1362\:GNDA \385\:GNDA) capacitor c=1.26043e-17
    c1960 (\170\:S \102\:S) capacitor c=9.19138e-16
    c1961 (\112\:Vm1 \279\:VDDA) capacitor c=6.11746e-16
    c1962 (\124\:U \203\:GNDA) capacitor c=4.01664e-15
    c1963 (\553\:VDDA \271\:Vm1) capacitor c=4.7853e-16
    c1964 (\21\:Vs \34\:D2) capacitor c=1.80847e-15
    c1965 (\25\:S2 \44\:S2) capacitor c=2.58521e-17
    c1966 (\896\:GNDA \1138\:GNDA) capacitor c=3.5991e-15
    c1967 (\205\:GNDA \173\:GNDA) capacitor c=3.39571e-17
    c1968 (\205\:S \426\:VDDA) capacitor c=1.61214e-16
    c1969 (\511\:VDDA \279\:VDDA) capacitor c=3.77935e-16
    c1970 (\65\:S \17\:D1) capacitor c=6.13602e-16
    c1971 (\126\:GNDA \16\:Vo1) capacitor c=4.22813e-16
    c1972 (\204\:S \536\:VDDA) capacitor c=2.70225e-16
    c1973 (\79\:U \1034\:GNDA) capacitor c=1.14364e-16
    c1974 (\4\:U \207\:GNDA) capacitor c=6.34433e-16
    c1975 (\18\:Vs \31\:D2) capacitor c=2.98403e-15
    c1976 (\75\:S \26\:Vo1) capacitor c=6.24816e-16
    c1977 (\127\:GNDA \1251\:GNDA) capacitor c=1.23214e-17
    c1978 (\1373\:GNDA \1251\:GNDA) capacitor c=3.11265e-17
    c1979 (\637\:VDDA \279\:VDDA) capacitor c=2.77691e-16
    c1980 (\216\:Vm1 \478\:VDDA) capacitor c=2.24131e-16
    c1981 (\98\:U \890\:GNDA) capacitor c=3.77148e-17
    c1982 (\35\:X \69\:GNDA) capacitor c=3.93736e-16
    c1983 (\333\:VDDA \40\:S) capacitor c=1.21854e-16
    c1984 (\2\:Y \22\:Vo1) capacitor c=4.73982e-17
    c1985 (\594\:VDDA \203\:GNDA) capacitor c=6.97236e-15
    c1986 (\17\:U \1251\:GNDA) capacitor c=1.17221e-15
    c1987 (\16\:X \102\:S) capacitor c=1.26572e-15
    c1988 (\51\:U \826\:GNDA) capacitor c=6.78232e-17
    c1989 (\53\:D1 \158\:S) capacitor c=1.06291e-16
    c1990 (\19\:U \207\:GNDA) capacitor c=2.82661e-16
    c1991 (\184\:Vm1 \279\:VDDA) capacitor c=3.71141e-16
    c1992 (\197\:VDDA \31\:BG_REF) capacitor c=3.23767e-16
    c1993 (\287\:Vm1 \65\:S2) capacitor c=5.29375e-16
    c1994 (\25\:vv \479\:VDDA) capacitor c=3.31616e-17
    c1995 (\63\:GNDA \218\:GNDA) capacitor c=1.54438e-14
    c1996 (\192\:GNDA \158\:GNDA) capacitor c=3.77343e-15
    c1997 (\167\:GNDA \168\:GNDA) capacitor c=4.12292e-16
    c1998 (\62\:S \4\:S) capacitor c=4.36201e-16
    c1999 (\88\:GNDA \2\:net13) capacitor c=2.57236e-17
    c2000 (\61\:U \1268\:GNDA) capacitor c=6.78232e-17
    c2001 (\207\:GNDA \746\:GNDA) capacitor c=3.77359e-15
    c2002 (\43\:Vo1 \130\:S) capacitor c=1.06017e-16
    c2003 (\249\:Vm1 \74\:S2) capacitor c=5.23191e-16
    c2004 (\16\:vv \275\:Vm1) capacitor c=1.65318e-16
    c2005 (\18\:X \183\:S) capacitor c=1.05164e-15
    c2006 (\629\:VDDA \77\:S2) capacitor c=2.71236e-16
    c2007 (\53\:BG_REF \288\:VDDA) capacitor c=3.01392e-16
    c2008 (\239\:S \574\:VDDA) capacitor c=2.00927e-16
    c2009 (\82\:U \1238\:GNDA) capacitor c=3.73689e-17
    c2010 (\61\:U \1374\:GNDA) capacitor c=1.98382e-16
    c2011 (\69\:S2 \544\:VDDA) capacitor c=2.37205e-16
    c2012 (\108\:U \1251\:GNDA) capacitor c=7.1556e-17
    c2013 (\3\:Vs \2\:vv) capacitor c=8.44e-17
    c2014 (\158\:Vm1 \47\:Vm1) capacitor c=1.82432e-16
    c2015 (\32\:U \1251\:GNDA) capacitor c=9.05965e-16
    c2016 (\53\:D1 \102\:S) capacitor c=1.48273e-15
    c2017 (\120\:BG_REF \534\:VDDA) capacitor c=7.3223e-17
    c2018 (\97\:S \27\:D1) capacitor c=3.34161e-16
    c2019 (\34\:X \42\:GNDA) capacitor c=1.0788e-15
    c2020 (\133\:BG_REF \279\:VDDA) capacitor c=2.97961e-15
    c2021 (\58\:Vo1 \149\:S) capacitor c=1.18242e-16
    c2022 (\22\:vv \523\:VDDA) capacitor c=1.07028e-17
    c2023 (\27\:BG_REF \7\:VDDA) capacitor c=3.03102e-17
    c2024 (\38\:U \170\:GNDA) capacitor c=8.85297e-17
    c2025 (\107\:U \1221\:GNDA) capacitor c=5.64553e-17
    c2026 (\17\:vv \307\:VDDA) capacitor c=3.40015e-17
    c2027 (\321\:VDDA \279\:VDDA) capacitor c=3.35043e-16
    c2028 (\35\:X \81\:U) capacitor c=1.48574e-15
    c2029 (\2\:U \1238\:GNDA) capacitor c=4.58176e-17
    c2030 (\2\:net37 \93\:GNDA) capacitor c=3.76675e-16
    c2031 (\240\:S \40\:Vo1) capacitor c=8.51689e-17
    c2032 (\1\:VDDA \279\:VDDA) capacitor c=4.38098e-15
    c2033 (\84\:S2 \25\:D2) capacitor c=6.80132e-16
    c2034 (\27\:vv \44\:S) capacitor c=3.40015e-17
    c2035 (\182\:Vm1 \321\:VDDA) capacitor c=4.74167e-16
    c2036 (\675\:GNDA \535\:GNDA) capacitor c=8.23384e-16
    c2037 (\42\:S \279\:VDDA) capacitor c=1.67343e-16
    c2038 (\105\:Vm1 \106\:Vm1) capacitor c=6.50917e-16
    c2039 (\57\:Vo1 \771\:GNDA) capacitor c=2.61069e-16
    c2040 (\139\:GNDA \1251\:GNDA) capacitor c=1.11954e-17
    c2041 (\227\:S \548\:VDDA) capacitor c=1.22928e-16
    c2042 (\896\:GNDA \1355\:GNDA) capacitor c=3.04635e-17
    c2043 (\133\:S \5\:S) capacitor c=4.21131e-16
    c2044 (\2\:net12 \2\:net31) capacitor c=4.11228e-17
    c2045 (\535\:GNDA \203\:GNDA) capacitor c=6.0616e-16
    c2046 (\67\:S2 \18\:vv) capacitor c=6.22643e-15
    c2047 (\68\:U \1251\:GNDA) capacitor c=1.17427e-15
    c2048 (\145\:GNDA \18\:D2) capacitor c=5.34379e-16
    c2049 (\166\:VDDA \279\:VDDA) capacitor c=3.71677e-16
    c2050 (\28\:U \776\:GNDA) capacitor c=5.23865e-17
    c2051 (\718\:GNDA \84\:BG_REF) capacitor c=6.08631e-16
    c2052 (\3\:U \1215\:GNDA) capacitor c=1.16592e-16
    c2053 (\2\:net35 \59\:GNDA) capacitor c=2.96847e-15
    c2054 (\96\:U \756\:GNDA) capacitor c=1.60051e-16
    c2055 (\48\:U \512\:GNDA) capacitor c=1.60051e-16
    c2056 (\203\:GNDA \627\:GNDA) capacitor c=3.78748e-16
    c2057 (\204\:S \658\:VDDA) capacitor c=2.3671e-16
    c2058 (\32\:D1 \149\:S) capacitor c=4.29852e-16
    c2059 (\44\:U \188\:GNDA) capacitor c=1.63679e-16
    c2060 (\711\:GNDA \712\:GNDA) capacitor c=4.12292e-16
    c2061 (\637\:GNDA \443\:GNDA) capacitor c=4.02886e-16
    c2062 (\16\:vv \469\:VDDA) capacitor c=3.31616e-17
    c2063 (\122\:Vm1 \173\:VDDA) capacitor c=4.76167e-16
    c2064 (\25\:vv \548\:VDDA) capacitor c=2.72459e-16
    c2065 (\203\:GNDA \419\:GNDA) capacitor c=2.35721e-15
    c2066 (\27\:U \874\:GNDA) capacitor c=5.50084e-17
    c2067 (\702\:GNDA \203\:GNDA) capacitor c=4.79948e-16
    c2068 (\238\:S \279\:VDDA) capacitor c=2.97123e-15
    c2069 (\1362\:GNDA \996\:GNDA) capacitor c=3.77184e-15
    c2070 (\29\:U \205\:GNDA) capacitor c=1.81028e-15
    c2071 (\669\:GNDA \1251\:GNDA) capacitor c=1.46162e-14
    c2072 (\29\:BIAS \275\:Vm1) capacitor c=5.77682e-16
    c2073 (\1268\:GNDA \1251\:GNDA) capacitor c=9.55172e-17
    c2074 (\527\:VDDA \526\:VDDA) capacitor c=2.16852e-16
    c2075 (\88\:S2 \9\:vv) capacitor c=4.08254e-16
    c2076 (\23\:VDDA \279\:VDDA) capacitor c=3.79348e-15
    c2077 (\91\:U \1251\:GNDA) capacitor c=1.17427e-15
    c2078 (\1049\:GNDA \1024\:GNDA) capacitor c=9.29257e-17
    c2079 (\620\:GNDA \401\:GNDA) capacitor c=4.6967e-17
    c2080 (\146\:S \145\:S) capacitor c=1.85911e-15
    c2081 (\110\:Vm1 \2\:Vm1) capacitor c=8.80193e-16
    c2082 (\43\:U \185\:GNDA) capacitor c=4.6967e-17
    c2083 (\17\:Y \25\:GNDA) capacitor c=9.10734e-16
    c2084 (\48\:U \190\:GNDA) capacitor c=8.85297e-17
    c2085 (\33\:vv \483\:VDDA) capacitor c=3.31616e-17
    c2086 (\34\:vv \46\:BG_REF) capacitor c=3.31616e-17
    c2087 (\187\:VDDA \279\:VDDA) capacitor c=2.75667e-16
    c2088 (\13\:GNDA \218\:GNDA) capacitor c=9.70292e-17
    c2089 (\191\:VDDA \25\:BG_REF) capacitor c=3.23767e-16
    c2090 (\9\:vv \34\:S2) capacitor c=2.85522e-17
    c2091 (\8\:U \1481\:GNDA) capacitor c=6.18343e-17
    c2092 (\827\:GNDA \738\:GNDA) capacitor c=1.57517e-16
    c2093 (\91\:U \711\:GNDA) capacitor c=3.54052e-16
    c2094 (\449\:GNDA \455\:GNDA) capacitor c=3.34825e-16
    c2095 (\147\:GNDA \1251\:GNDA) capacitor c=1.11954e-17
    c2096 (\1313\:GNDA \1251\:GNDA) capacitor c=3.11265e-17
    c2097 (\76\:S2 \279\:VDDA) capacitor c=2.79339e-15
    c2098 (\112\:S2 \555\:VDDA) capacitor c=5.12913e-16
    c2099 (\18\:vv \37\:S) capacitor c=1.3147e-17
    c2100 (\123\:VDDA \30\:BG_REF) capacitor c=5.18673e-16
    c2101 (\203\:GNDA \1389\:GNDA) capacitor c=1.00274e-16
    c2102 (\406\:VDDA \80\:BG_REF) capacitor c=5.28406e-16
    c2103 (\126\:Vm1 \17\:Vm1) capacitor c=1.05688e-15
    c2104 (\341\:VDDA \279\:VDDA) capacitor c=3.71677e-16
    c2105 (\35\:D1 \102\:S) capacitor c=8.83229e-16
    c2106 (\55\:BG_REF \313\:VDDA) capacitor c=3.01441e-16
    c2107 (\738\:GNDA \203\:GNDA) capacitor c=1.05708e-16
    c2108 (\13\:BG_REF \44\:S2) capacitor c=9.0147e-17
    c2109 (\572\:VDDA \573\:VDDA) capacitor c=5.13047e-16
    c2110 (\46\:S \279\:VDDA) capacitor c=1.67328e-16
    c2111 (\49\:U \185\:GNDA) capacitor c=4.6967e-17
    c2112 (\96\:U \753\:GNDA) capacitor c=8.85297e-17
    c2113 (\1559\:GNDA \62\:U) capacitor c=1.48163e-16
    c2114 (\8\:D2 \136\:BG_REF) capacitor c=3.18069e-16
    c2115 (\27\:U \998\:GNDA) capacitor c=5.18539e-17
    c2116 (\128\:Vm1 \179\:VDDA) capacitor c=4.76167e-16
    c2117 (\181\:VDDA \279\:VDDA) capacitor c=3.3347e-16
    c2118 (\88\:S2 \11\:D2) capacitor c=3.73182e-17
    c2119 (\896\:GNDA \74\:U) capacitor c=7.93593e-17
    c2120 (\1511\:GNDA \849\:GNDA) capacitor c=3.13497e-16
    c2121 (\373\:VDDA \70\:BG_REF) capacitor c=5.28947e-16
    c2122 (\237\:Vm1 \25\:vv) capacitor c=3.18761e-16
    c2123 (\70\:U \996\:GNDA) capacitor c=1.98382e-16
    c2124 (\238\:S \452\:VDDA) capacitor c=1.23137e-17
    c2125 (\555\:VDDA \279\:VDDA) capacitor c=6.22036e-16
    c2126 (\8\:Vs \105\:S2) capacitor c=6.29476e-17
    c2127 (\378\:GNDA \379\:GNDA) capacitor c=1.18497e-15
    c2128 (\39\:BG_REF \8\:vv) capacitor c=3.67117e-17
    c2129 (\28\:vv \534\:VDDA) capacitor c=4.51962e-17
    c2130 (\7\:vv \40\:S) capacitor c=3.40015e-17
    c2131 (\226\:S \73\:S2) capacitor c=3.37597e-15
    c2132 (\896\:GNDA \75\:U) capacitor c=3.38399e-16
    c2133 (\2\:net4 \2\:net19) capacitor c=2.49536e-15
    c2134 (\112\:Vm1 \3\:Vm1) capacitor c=1.05955e-15
    c2135 (\2\:S \102\:S) capacitor c=3.80231e-16
    c2136 (\16\:U \835\:GNDA) capacitor c=2.75603e-17
    c2137 (\29\:U \954\:GNDA) capacitor c=1.71879e-16
    c2138 (\25\:vv \279\:VDDA) capacitor c=4.8427e-15
    c2139 (\2\:Vo2 \768\:GNDA) capacitor c=3.90367e-17
    c2140 (\33\:Vm1 \34\:Vm1) capacitor c=6.37972e-16
    c2141 (\230\:GNDA \149\:S) capacitor c=5.16468e-15
    c2142 (\3\:net30 \66\:GNDA) capacitor c=5.5557e-17
    c2143 (\362\:VDDA \279\:VDDA) capacitor c=2.75667e-16
    c2144 (\1293\:GNDA \1309\:GNDA) capacitor c=1.49136e-16
    c2145 (\537\:GNDA \1251\:GNDA) capacitor c=3.07757e-16
    c2146 (\20\:vv \455\:VDDA) capacitor c=3.31616e-17
    c2147 (\90\:GNDA \218\:GNDA) capacitor c=3.47928e-15
    c2148 (\134\:BG_REF \15\:VDDA) capacitor c=1.03845e-17
    c2149 (\13\:vv \1251\:GNDA) capacitor c=9.61942e-17
    c2150 (\2\:S2 \44\:S2) capacitor c=5.39e-16
    c2151 (\482\:GNDA \162\:GNDA) capacitor c=4.97393e-17
    c2152 (\46\:U \1251\:GNDA) capacitor c=5.09198e-17
    c2153 (\144\:Vm1 \218\:VDDA) capacitor c=4.78423e-16
    c2154 (\2\:X \102\:S) capacitor c=3.30759e-15
    c2155 (\35\:X \218\:GNDA) capacitor c=4.68547e-16
    c2156 (\18\:U \927\:GNDA) capacitor c=4.06876e-16
    c2157 (\4\:Y \28\:Vo1) capacitor c=3.31464e-17
    c2158 (\639\:VDDA \519\:VDDA) capacitor c=7.65346e-16
    c2159 (\48\:Vo1 \120\:GNDA) capacitor c=3.16891e-17
    c2160 (\1495\:GNDA \1398\:GNDA) capacitor c=4.6967e-17
    c2161 (\33\:S \319\:VDDA) capacitor c=1.93444e-17
    c2162 (\192\:GNDA \39\:U) capacitor c=3.38399e-16
    c2163 (\33\:vv \555\:VDDA) capacitor c=5.81367e-16
    c2164 (\51\:Vo1 \550\:GNDA) capacitor c=4.07467e-16
    c2165 (\1362\:GNDA \704\:GNDA) capacitor c=3.40138e-17
    c2166 (\59\:BG_REF \206\:S) capacitor c=6.30961e-16
    c2167 (\193\:VDDA \279\:VDDA) capacitor c=3.94428e-16
    c2168 (\133\:BG_REF \341\:VDDA) capacitor c=1.03669e-17
    c2169 (\1136\:GNDA \1133\:GNDA) capacitor c=8.23837e-17
    c2170 (\537\:VDDA \279\:VDDA) capacitor c=7.80777e-16
    c2171 (\33\:BG_REF \147\:VDDA) capacitor c=1.23404e-17
    c2172 (\276\:Vm1 \505\:VDDA) capacitor c=3.19444e-16
    c2173 (\173\:GNDA \175\:GNDA) capacitor c=3.15482e-16
    c2174 (\1553\:GNDA \26\:D2) capacitor c=9.4064e-16
    c2175 (\154\:Vm1 \265\:VDDA) capacitor c=3.46264e-16
    c2176 (\144\:GNDA \1251\:GNDA) capacitor c=6.64424e-16
    c2177 (\278\:VDDA \55\:BG_REF) capacitor c=1.35399e-17
    c2178 (\21\:vv \190\:VDDA) capacitor c=3.31616e-17
    c2179 (\905\:GNDA \188\:GNDA) capacitor c=2.35944e-16
    c2180 (\54\:U \1167\:GNDA) capacitor c=1.52412e-16
    c2181 (\8\:Vs \44\:S2) capacitor c=6.36789e-16
    c2182 (\268\:VDDA \54\:BG_REF) capacitor c=5.28947e-16
    c2183 (\1312\:GNDA \1251\:GNDA) capacitor c=3.1724e-17
    c2184 (\35\:D1 \122\:S) capacitor c=1.2331e-16
    c2185 (\21\:vv \89\:VDDA) capacitor c=3.49326e-17
    c2186 (\534\:VDDA \44\:S2) capacitor c=3.13777e-16
    c2187 (\356\:VDDA \279\:VDDA) capacitor c=3.33877e-16
    c2188 (\207\:GNDA \10\:U) capacitor c=3.36974e-16
    c2189 (\52\:D1 \170\:S) capacitor c=6.54278e-16
    c2190 (\18\:vv \275\:Vm1) capacitor c=2.23659e-16
    c2191 (\1452\:GNDA \1481\:GNDA) capacitor c=3.47503e-16
    c2192 (\758\:GNDA \534\:VDDA) capacitor c=6.07001e-17
    c2193 (\12\:vv \7\:D2) capacitor c=1.43879e-17
    c2194 (\1273\:GNDA \1297\:GNDA) capacitor c=1.62672e-16
    c2195 (\12\:GNDA \218\:GNDA) capacitor c=4.44752e-15
    c2196 (\74\:BG_REF \279\:VDDA) capacitor c=1.15424e-16
    c2197 (\18\:vv \60\:BG_REF) capacitor c=3.40015e-17
    c2198 (\58\:D1 \102\:S) capacitor c=2.12059e-16
    c2199 (\297\:Vm1 \279\:VDDA) capacitor c=1.24412e-15
    c2200 (\1206\:GNDA \1187\:GNDA) capacitor c=1.21586e-15
    c2201 (\238\:S \362\:VDDA) capacitor c=1.23137e-17
    c2202 (\610\:GNDA \401\:GNDA) capacitor c=4.6967e-17
    c2203 (\15\:S \279\:VDDA) capacitor c=1.42939e-15
    c2204 (\183\:GNDA \178\:GNDA) capacitor c=9.29257e-17
    c2205 (\350\:VDDA \73\:BG_REF) capacitor c=2.87197e-16
    c2206 (\15\:vv \1251\:GNDA) capacitor c=2.92905e-16
    c2207 (\25\:vv \43\:S) capacitor c=1.3147e-17
    c2208 (\61\:BG_REF \358\:VDDA) capacitor c=3.01323e-16
    c2209 (\74\:U \839\:GNDA) capacitor c=8.85297e-17
    c2210 (\227\:S \511\:VDDA) capacitor c=1.06321e-17
    c2211 (\136\:BG_REF \84\:BG_REF) capacitor c=1.48606e-17
    c2212 (\292\:VDDA \35\:VDDA) capacitor c=1.05536e-15
    c2213 (\62\:U \1324\:GNDA) capacitor c=1.11161e-16
    c2214 (\1095\:GNDA \1251\:GNDA) capacitor c=3.11265e-17
    c2215 (\34\:vv \242\:S) capacitor c=5.12333e-16
    c2216 (\31\:Vs \21\:D2) capacitor c=8.9983e-16
    c2217 (\22\:U \791\:GNDA) capacitor c=1.3611e-15
    c2218 (\17\:D1 \73\:S) capacitor c=5.08853e-16
    c2219 (\7\:vv \262\:VDDA) capacitor c=3.31616e-17
    c2220 (\1537\:GNDA \534\:VDDA) capacitor c=5.33455e-17
    c2221 (\28\:X \1113\:GNDA) capacitor c=1.76945e-16
    c2222 (\28\:X \1114\:GNDA) capacitor c=4.53174e-17
    c2223 (\2\:net8 \2\:net13) capacitor c=4.60022e-17
    c2224 (\497\:VDDA \121\:BG_REF) capacitor c=1.98136e-16
    c2225 (\136\:S \58\:Vo1) capacitor c=1.98496e-16
    c2226 (\131\:BG_REF \237\:S) capacitor c=2.56266e-15
    c2227 (\35\:X \28\:X) capacitor c=2.33358e-15
    c2228 (\374\:VDDA \279\:VDDA) capacitor c=3.97994e-16
    c2229 (\25\:vv \459\:VDDA) capacitor c=3.31616e-17
    c2230 (\1238\:GNDA \1256\:GNDA) capacitor c=3.15482e-16
    c2231 (\37\:BG_REF \177\:VDDA) capacitor c=3.14461e-16
    c2232 (\69\:Vm1 \279\:VDDA) capacitor c=3.9572e-15
    c2233 (\67\:BG_REF \33\:S) capacitor c=1.0135e-15
    c2234 (\221\:S \583\:VDDA) capacitor c=1.2299e-16
    c2235 (\105\:U \1251\:GNDA) capacitor c=2.75456e-15
    c2236 (\2\:net28 \2\:net25) capacitor c=4.42506e-17
    c2237 (\170\:S \534\:VDDA) capacitor c=1.877e-17
    c2238 (\89\:BG_REF \279\:VDDA) capacitor c=4.54538e-15
    c2239 (\41\:BG_REF \183\:VDDA) capacitor c=2.93937e-16
    c2240 (\1472\:GNDA \1405\:GNDA) capacitor c=3.72052e-17
    c2241 (\21\:Vs \809\:GNDA) capacitor c=2.20138e-16
    c2242 (\1362\:GNDA \1251\:GNDA) capacitor c=6.14195e-15
    c2243 (\138\:Vm1 \279\:VDDA) capacitor c=3.74601e-16
    c2244 (\102\:S2 \27\:vv) capacitor c=6.34926e-15
    c2245 (\1500\:GNDA \1355\:GNDA) capacitor c=3.70876e-17
    c2246 (\297\:Vm1 \587\:VDDA) capacitor c=8.39722e-16
    c2247 (\2\:net2 \218\:GNDA) capacitor c=4.17794e-16
    c2248 (\28\:Vo1 \3\:Y) capacitor c=2.24232e-17
    c2249 (\245\:GNDA \230\:GNDA) capacitor c=1.74913e-15
    c2250 (\27\:vv \336\:VDDA) capacitor c=3.31616e-17
    c2251 (\17\:U \704\:GNDA) capacitor c=5.23865e-17
    c2252 (\617\:VDDA \17\:vv) capacitor c=9.30341e-16
    c2253 (\637\:VDDA \287\:Vm1) capacitor c=5.55012e-16
    c2254 (\40\:S2 \39\:S2) capacitor c=5.02984e-16
    c2255 (\26\:GNDA \17\:Y) capacitor c=6.91224e-17
    c2256 (\72\:S2 \493\:VDDA) capacitor c=1.23137e-17
    c2257 (\69\:U \1362\:GNDA) capacitor c=1.81028e-15
    c2258 (\561\:GNDA \550\:GNDA) capacitor c=9.5151e-16
    c2259 (\205\:GNDA \1265\:GNDA) capacitor c=2.31665e-15
    c2260 (\7\:U \12\:U) capacitor c=1.69405e-17
    c2261 (\95\:U \1251\:GNDA) capacitor c=9.13481e-16
    c2262 (\14\:Y \16\:X) capacitor c=1.63788e-17
    c2263 (\248\:Vm1 \534\:VDDA) capacitor c=2.53879e-16
    c2264 (\1527\:GNDA \39\:D1) capacitor c=9.5245e-16
    c2265 (\69\:BG_REF \279\:VDDA) capacitor c=7.1068e-16
    c2266 (\134\:BG_REF \31\:VDDA) capacitor c=1.03845e-17
    c2267 (\69\:BG_REF \393\:VDDA) capacitor c=3.01353e-16
    c2268 (\79\:Vm1 \279\:VDDA) capacitor c=3.95842e-15
    c2269 (\323\:VDDA \322\:VDDA) capacitor c=1.82943e-16
    c2270 (\657\:GNDA \1251\:GNDA) capacitor c=1.77022e-15
    c2271 (\234\:VDDA \50\:BG_REF) capacitor c=3.89918e-17
    c2272 (\129\:VDDA \135\:VDDA) capacitor c=4.75166e-16
    c2273 (\103\:S2 \34\:vv) capacitor c=1.22457e-16
    c2274 (\26\:D1 \102\:S) capacitor c=1.15303e-15
    c2275 (\539\:GNDA \44\:S2) capacitor c=6.32737e-16
    c2276 (\90\:U \659\:GNDA) capacitor c=1.10455e-16
    c2277 (\73\:BG_REF \314\:VDDA) capacitor c=1.23247e-17
    c2278 (\205\:S \279\:VDDA) capacitor c=4.08776e-15
    c2279 (\971\:GNDA \953\:GNDA) capacitor c=4.97393e-17
    c2280 (\25\:S2 \11\:BG_REF) capacitor c=1.2327e-16
    c2281 (\1284\:GNDA \1383\:GNDA) capacitor c=7.82115e-17
    c2282 (\27\:U \774\:GNDA) capacitor c=6.8128e-16
    c2283 (\216\:VDDA \279\:VDDA) capacitor c=3.32577e-16
    c2284 (\1018\:GNDA \1130\:GNDA) capacitor c=7.83365e-17
    c2285 (\239\:S \116\:VDDA) capacitor c=1.23137e-17
    c2286 (\1362\:GNDA \1117\:GNDA) capacitor c=2.75833e-15
    c2287 (\61\:D1 \1251\:GNDA) capacitor c=6.89883e-16
    c2288 (\132\:GNDA \131\:GNDA) capacitor c=4.26802e-16
    c2289 (\205\:GNDA \1206\:GNDA) capacitor c=3.70786e-16
    c2290 (\35\:X \3\:GNDA) capacitor c=3.69633e-16
    c2291 (\539\:GNDA \27\:GNDA) capacitor c=1.39608e-16
    c2292 (\17\:vv \665\:VDDA) capacitor c=5.12333e-16
    c2293 (\248\:Vm1 \24\:vv) capacitor c=2.66552e-16
    c2294 (\812\:GNDA \684\:GNDA) capacitor c=6.46495e-16
    c2295 (\33\:vv \463\:VDDA) capacitor c=3.31616e-17
    c2296 (\21\:U \791\:GNDA) capacitor c=8.85297e-17
    c2297 (\20\:BG_REF \7\:BG_REF) capacitor c=5.41362e-16
    c2298 (\88\:BG_REF \205\:S) capacitor c=2.60951e-16
    c2299 (\634\:GNDA \437\:GNDA) capacitor c=1.5081e-16
    c2300 (\1259\:GNDA \1251\:GNDA) capacitor c=4.19575e-17
    c2301 (\398\:VDDA \72\:BG_REF) capacitor c=5.28406e-16
    c2302 (\328\:VDDA \60\:BG_REF) capacitor c=5.28947e-16
    c2303 (\39\:D1 \57\:Vo1) capacitor c=7.49364e-16
    c2304 (\1515\:GNDA \684\:GNDA) capacitor c=1.6628e-15
    c2305 (\896\:GNDA \27\:X) capacitor c=1.70315e-16
    c2306 (\50\:U \818\:GNDA) capacitor c=6.20368e-17
    c2307 (\151\:S \149\:S) capacitor c=3.47908e-16
    c2308 (\397\:VDDA \279\:VDDA) capacitor c=2.75667e-16
    c2309 (\12\:vv \19\:S2) capacitor c=1.43879e-17
    c2310 (\73\:S \23\:Vo1) capacitor c=3.34161e-16
    c2311 (\249\:VDDA \154\:Vm1) capacitor c=4.69662e-16
    c2312 (\89\:Vm1 \279\:VDDA) capacitor c=3.95939e-15
    c2313 (\188\:VDDA \44\:BG_REF) capacitor c=5.28947e-16
    c2314 (\203\:GNDA \92\:U) capacitor c=1.05363e-15
    c2315 (\12\:Vs \895\:GNDA) capacitor c=2.01795e-16
    c2316 (\221\:S \108\:VDDA) capacitor c=2.04887e-17
    c2317 (\1509\:GNDA \1251\:GNDA) capacitor c=1.61409e-17
    c2318 (\220\:VDDA \25\:VDDA) capacitor c=1.03916e-15
    c2319 (\28\:vv \279\:VDDA) capacitor c=5.44181e-15
    c2320 (\18\:U \1251\:GNDA) capacitor c=1.01999e-15
    c2321 (\79\:U \975\:GNDA) capacitor c=4.6967e-17
    c2322 (\226\:VDDA \279\:VDDA) capacitor c=3.91235e-16
    c2323 (\1537\:GNDA \32\:D2) capacitor c=7.87381e-16
    c2324 (\25\:Vo1 \23\:Vo1) capacitor c=1.23765e-15
    c2325 (\247\:S \191\:S) capacitor c=6.46904e-16
    c2326 (\4\:U \9\:U) capacitor c=1.12841e-16
    c2327 (\784\:GNDA \776\:GNDA) capacitor c=9.29257e-17
    c2328 (\95\:U \1201\:GNDA) capacitor c=1.62295e-16
    c2329 (\192\:GNDA \173\:GNDA) capacitor c=3.76911e-15
    c2330 (\128\:VDDA \33\:BG_REF) capacitor c=4.80342e-16
    c2331 (\19\:vv \27\:S) capacitor c=1.3147e-17
    c2332 (\43\:BG_REF \207\:VDDA) capacitor c=1.13753e-17
    c2333 (\6\:U \1133\:GNDA) capacitor c=4.6967e-17
    c2334 (\222\:Vm1 \521\:GNDA) capacitor c=7.06805e-16
    c2335 (\110\:BG_REF \21\:vv) capacitor c=5.24628e-16
    c2336 (\66\:S2 \47\:BG_REF) capacitor c=1.11867e-17
    c2337 (\918\:VDDA \1251\:GNDA) capacitor c=2.95619e-17
    c2338 (\40\:Vo1 \107\:S) capacitor c=1.65953e-15
    c2339 (\203\:GNDA \732\:GNDA) capacitor c=5.6058e-15
    c2340 (\391\:VDDA \279\:VDDA) capacitor c=3.34901e-16
    c2341 (\2\:net11 \63\:GNDA) capacitor c=2.33664e-15
    c2342 (\297\:VDDA \171\:Vm1) capacitor c=4.74597e-16
    c2343 (\66\:S2 \19\:vv) capacitor c=1.22457e-16
    c2344 (\23\:BG_REF \137\:VDDA) capacitor c=1.23404e-17
    c2345 (\78\:S2 \3\:Vs) capacitor c=2.60169e-17
    c2346 (\4\:Vo2 \3\:Vo2) capacitor c=3.0104e-16
    c2347 (\191\:S \102\:S) capacitor c=3.01864e-16
    c2348 (\117\:BG_REF \534\:VDDA) capacitor c=4.93476e-17
    c2349 (\103\:Vm1 \279\:VDDA) capacitor c=3.95929e-15
    c2350 (\207\:GNDA \961\:GNDA) capacitor c=1.26043e-17
    c2351 (\172\:GNDA \1251\:GNDA) capacitor c=3.11265e-17
    c2352 (\1032\:GNDA \1006\:GNDA) capacitor c=5.35597e-17
    c2353 (\464\:VDDA \81\:BG_REF) capacitor c=2.34161e-16
    c2354 (\637\:VDDA \16\:vv) capacitor c=3.57561e-16
    c2355 (\79\:BG_REF \47\:S) capacitor c=1.67359e-15
    c2356 (\12\:vv \44\:S2) capacitor c=1.1613e-15
    c2357 (\203\:GNDA \366\:GNDA) capacitor c=3.53957e-15
    c2358 (\897\:VDDA \279\:VDDA) capacitor c=6.42015e-16
    c2359 (\154\:Vm1 \43\:Vm1) capacitor c=1.06133e-15
    c2360 (\779\:VDDA \72\:S2) capacitor c=1.6115e-16
    c2361 (\89\:S \102\:S) capacitor c=5.50685e-16
    c2362 (\26\:vv \832\:VDDA) capacitor c=7.21812e-16
    c2363 (\47\:BG_REF \279\:VDDA) capacitor c=7.09559e-16
    c2364 (\645\:VDDA \25\:vv) capacitor c=3.58065e-16
    c2365 (\41\:U \173\:GNDA) capacitor c=1.14364e-16
    c2366 (\79\:BG_REF \320\:VDDA) capacitor c=1.23247e-17
    c2367 (\140\:S \8\:S) capacitor c=4.5312e-16
    c2368 (\1324\:GNDA \1421\:GNDA) capacitor c=1.03907e-16
    c2369 (\73\:BG_REF \439\:VDDA) capacitor c=1.36071e-17
    c2370 (\905\:GNDA \1130\:GNDA) capacitor c=5.59735e-15
    c2371 (\51\:U \56\:U) capacitor c=1.69405e-17
    c2372 (\621\:VDDA \74\:VDDA) capacitor c=7.65166e-16
    c2373 (\559\:VDDA \149\:S) capacitor c=8.45846e-17
    c2374 (\1518\:GNDA \1251\:GNDA) capacitor c=7.62183e-16
    c2375 (\1082\:GNDA \1079\:GNDA) capacitor c=8.23837e-17
    c2376 (\55\:U \823\:GNDA) capacitor c=8.85297e-17
    c2377 (\896\:GNDA \712\:GNDA) capacitor c=1.33732e-17
    c2378 (\137\:BG_REF \436\:VDDA) capacitor c=1.63243e-16
    c2379 (\27\:U \1251\:GNDA) capacitor c=2.97286e-15
    c2380 (\168\:Vm1 \286\:VDDA) capacitor c=4.73784e-16
    c2381 (\453\:VDDA \473\:VDDA) capacitor c=5.18716e-16
    c2382 (\30\:X \1251\:GNDA) capacitor c=7.43134e-17
    c2383 (\33\:U \205\:GNDA) capacitor c=1.82367e-15
    c2384 (\927\:GNDA \928\:GNDA) capacitor c=4.27087e-16
    c2385 (\9\:vv \14\:BG_REF) capacitor c=6.8845e-16
    c2386 (\67\:VDDA \279\:VDDA) capacitor c=4.04306e-15
    c2387 (\18\:X \19\:Y) capacitor c=2.69773e-16
    c2388 (\67\:BG_REF \7\:vv) capacitor c=1.14264e-17
    c2389 (\1167\:GNDA \10\:U) capacitor c=3.63621e-17
    c2390 (\1200\:GNDA \1201\:GNDA) capacitor c=4.05613e-16
    c2391 (\38\:S2 \14\:BG_REF) capacitor c=4.38464e-17
    c2392 (\110\:S2 \44\:S2) capacitor c=4.70688e-16
    c2393 (\111\:GNDA \218\:GNDA) capacitor c=2.03929e-15
    c2394 (\7\:vv \402\:VDDA) capacitor c=2.14169e-17
    c2395 (\450\:VDDA \49\:VDDA) capacitor c=1.06369e-15
    c2396 (\46\:Vo1 \1251\:GNDA) capacitor c=3.56617e-16
    c2397 (\661\:VDDA \88\:BG_REF) capacitor c=8.80021e-16
    c2398 (\152\:Vm1 \279\:VDDA) capacitor c=3.74341e-16
    c2399 (\64\:U \1294\:GNDA) capacitor c=3.83457e-17
    c2400 (\541\:GNDA \149\:S) capacitor c=6.07642e-17
    c2401 (\19\:vv \21\:S) capacitor c=1.3147e-17
    c2402 (\959\:GNDA \927\:GNDA) capacitor c=4.97393e-17
    c2403 (\271\:Vm1 \904\:VDDA) capacitor c=1.19335e-15
    c2404 (\40\:Vo1 \115\:S) capacitor c=2.29306e-16
    c2405 (\2\:net39 \218\:GNDA) capacitor c=6.7722e-16
    c2406 (\168\:Vm1 \57\:Vm1) capacitor c=1.83865e-16
    c2407 (\36\:Vm1 \279\:VDDA) capacitor c=3.92629e-15
    c2408 (\1125\:GNDA \1096\:GNDA) capacitor c=5.35597e-17
    c2409 (\54\:Vo1 \149\:S) capacitor c=1.95843e-16
    c2410 (\208\:S \67\:S2) capacitor c=3.27206e-15
    c2411 (\26\:U \1029\:GNDA) capacitor c=1.3611e-15
    c2412 (\263\:VDDA \10\:S2) capacitor c=2.3815e-16
    c2413 (\574\:VDDA \279\:VDDA) capacitor c=4.56638e-16
    c2414 (\59\:D1 \166\:S) capacitor c=6.13216e-16
    c2415 (\896\:GNDA \2\:U) capacitor c=2.91323e-16
    c2416 (\51\:Vo1 \7\:Vo1) capacitor c=1.35959e-15
    c2417 (\546\:VDDA \535\:GNDA) capacitor c=7.27272e-17
    c2418 (\188\:GNDA \190\:GNDA) capacitor c=3.15482e-16
    c2419 (\53\:U \1006\:GNDA) capacitor c=9.23319e-17
    c2420 (\627\:VDDA \28\:vv) capacitor c=1.05234e-15
    c2421 (\133\:BG_REF \452\:VDDA) capacitor c=2.04887e-17
    c2422 (\535\:GNDA \521\:GNDA) capacitor c=2.6186e-16
    c2423 (\131\:BG_REF \577\:VDDA) capacitor c=7.15471e-16
    c2424 (\226\:S \94\:VDDA) capacitor c=1.06321e-17
    c2425 (\120\:Vm1 \13\:VDDA) capacitor c=4.55576e-16
    c2426 (\617\:VDDA \279\:VDDA) capacitor c=2.77828e-16
    c2427 (\537\:VDDA \534\:VDDA) capacitor c=4.87524e-16
    c2428 (\270\:Vm1 \103\:S2) capacitor c=5.08078e-16
    c2429 (\243\:VDDA \279\:VDDA) capacitor c=3.30364e-16
    c2430 (\53\:BG_REF \237\:S) capacitor c=5.55246e-16
    c2431 (\2\:net32 \2\:net2) capacitor c=8.39519e-17
    c2432 (\77\:S \102\:S) capacitor c=5.03252e-16
    c2433 (\4\:U \87\:U) capacitor c=1.23363e-15
    c2434 (\24\:vv \157\:VDDA) capacitor c=3.31616e-17
    c2435 (\20\:S \279\:VDDA) capacitor c=1.67398e-16
    c2436 (\34\:U \160\:GNDA) capacitor c=8.85297e-17
    c2437 (\190\:Vm1 \352\:VDDA) capacitor c=4.79798e-16
    c2438 (\46\:Vm1 \279\:VDDA) capacitor c=3.92464e-15
    c2439 (\385\:GNDA \397\:GNDA) capacitor c=9.29257e-17
    c2440 (\212\:Vm1 \474\:VDDA) capacitor c=2.24131e-16
    c2441 (\63\:GNDA \2\:net3) capacitor c=4.97753e-17
    c2442 (\230\:GNDA \534\:VDDA) capacitor c=6.60305e-15
    c2443 (\51\:BG_REF \278\:VDDA) capacitor c=3.01392e-16
    c2444 (\1523\:GNDA \117\:GNDA) capacitor c=2.38454e-16
    c2445 (\452\:VDDA \279\:VDDA) capacitor c=2.75667e-16
    c2446 (\1166\:GNDA \1192\:GNDA) capacitor c=1.49158e-16
    c2447 (\33\:vv \534\:VDDA) capacitor c=3.94536e-16
    c2448 (\7\:U \1472\:GNDA) capacitor c=5.76316e-17
    c2449 (\207\:GNDA \791\:GNDA) capacitor c=2.31665e-15
    c2450 (\29\:U \192\:GNDA) capacitor c=1.38677e-15
    c2451 (\80\:S2 \25\:S2) capacitor c=3.74454e-17
    c2452 (\226\:VDDA \21\:S) capacitor c=1.28281e-16
    c2453 (\19\:vv \258\:VDDA) capacitor c=3.31616e-17
    c2454 (\18\:vv \328\:VDDA) capacitor c=3.31616e-17
    c2455 (\73\:S2 \110\:VDDA) capacitor c=1.23137e-17
    c2456 (\948\:GNDA \998\:GNDA) capacitor c=3.07233e-16
    c2457 (\76\:U \961\:GNDA) capacitor c=3.77148e-17
    c2458 (\629\:VDDA \82\:VDDA) capacitor c=7.65191e-16
    c2459 (\25\:S \75\:S2) capacitor c=7.37279e-16
    c2460 (\48\:Vo1 \42\:D1) capacitor c=1.24762e-15
    c2461 (\67\:U \835\:GNDA) capacitor c=6.16902e-17
    c2462 (\38\:S2 \35\:S2) capacitor c=5.34881e-16
    c2463 (\263\:VDDA \279\:VDDA) capacitor c=3.99886e-16
    c2464 (\85\:U \1500\:GNDA) capacitor c=5.78794e-17
    c2465 (\1362\:GNDA \413\:GNDA) capacitor c=2.42764e-17
    c2466 (\72\:S2 \61\:VDDA) capacitor c=1.34744e-17
    c2467 (\61\:U \205\:GNDA) capacitor c=8.51338e-16
    c2468 (\327\:VDDA \271\:Vm1) capacitor c=3.9399e-16
    c2469 (\198\:S \1251\:GNDA) capacitor c=2.96005e-16
    c2470 (\200\:Vm1 \385\:VDDA) capacitor c=4.77611e-16
    c2471 (\19\:vv \48\:BG_REF) capacitor c=3.40015e-17
    c2472 (\88\:BG_REF \658\:VDDA) capacitor c=1.88627e-15
    c2473 (\33\:S2 \11\:D2) capacitor c=1.20319e-16
    c2474 (\390\:GNDA \610\:GNDA) capacitor c=5.46303e-15
    c2475 (\534\:GNDA \85\:U) capacitor c=4.78619e-16
    c2476 (\107\:U \1201\:GNDA) capacitor c=1.08835e-16
    c2477 (\461\:VDDA \481\:VDDA) capacitor c=5.18716e-16
    c2478 (\96\:U \712\:GNDA) capacitor c=3.73689e-17
    c2479 (\78\:U \1251\:GNDA) capacitor c=7.1556e-17
    c2480 (\2\:net20 \42\:GNDA) capacitor c=1.88213e-15
    c2481 (\797\:GNDA \798\:GNDA) capacitor c=4.12292e-16
    c2482 (\192\:GNDA \47\:U) capacitor c=3.36974e-16
    c2483 (\53\:S \20\:Vo1) capacitor c=6.24816e-16
    c2484 (\442\:VDDA \441\:VDDA) capacitor c=1.82419e-16
    c2485 (\109\:U \1377\:GNDA) capacitor c=4.6967e-17
    c2486 (\42\:S2 \9\:vv) capacitor c=3.41665e-17
    c2487 (\12\:S2 \100\:S2) capacitor c=3.51361e-17
    c2488 (\495\:VDDA \79\:BG_REF) capacitor c=1.89197e-16
    c2489 (\8\:U \212\:GNDA) capacitor c=2.30425e-16
    c2490 (\153\:VDDA \36\:BG_REF) capacitor c=5.28947e-16
    c2491 (\24\:Vs \55\:S2) capacitor c=8.33119e-16
    c2492 (\29\:X \207\:GNDA) capacitor c=1.68235e-16
    c2493 (\18\:X \102\:S) capacitor c=1.37431e-15
    c2494 (\7\:D2 \44\:S2) capacitor c=1.32088e-16
    c2495 (\236\:S \102\:S2) capacitor c=6.30217e-15
    c2496 (\9\:vv \27\:S2) capacitor c=1.81587e-17
    c2497 (\29\:S \279\:VDDA) capacitor c=8.22982e-16
    c2498 (\35\:D1 \43\:Vo1) capacitor c=1.02517e-15
    c2499 (\10\:U \1398\:GNDA) capacitor c=4.6967e-17
    c2500 (\1362\:GNDA \1405\:GNDA) capacitor c=3.63666e-16
    c2501 (\287\:Vm1 \88\:BG_REF) capacitor c=1.57228e-15
    c2502 (\240\:S \900\:VDDA) capacitor c=1.3531e-16
    c2503 (\212\:VDDA \37\:BG_REF) capacitor c=2.93779e-16
    c2504 (\978\:GNDA \960\:GNDA) capacitor c=4.97393e-17
    c2505 (\1452\:GNDA \1374\:GNDA) capacitor c=9.29257e-17
    c2506 (\20\:D1 \102\:S) capacitor c=1.39453e-15
    c2507 (\1105\:GNDA \1079\:GNDA) capacitor c=4.6967e-17
    c2508 (\207\:GNDA \1049\:GNDA) capacitor c=3.39571e-17
    c2509 (\661\:VDDA \204\:S) capacitor c=7.19459e-16
    c2510 (\92\:VDDA \279\:VDDA) capacitor c=3.86108e-16
    c2511 (\27\:X \1138\:GNDA) capacitor c=4.00118e-17
    c2512 (\100\:BG_REF \207\:S) capacitor c=2.65064e-15
    c2513 (\67\:S \18\:D1) capacitor c=6.24816e-16
    c2514 (\54\:U \1192\:GNDA) capacitor c=2.62879e-16
    c2515 (\37\:X \35\:X) capacitor c=1.31581e-16
    c2516 (\44\:Vo1 \4\:Vo1) capacitor c=3.37773e-16
    c2517 (\85\:U \896\:GNDA) capacitor c=1.07683e-15
    c2518 (\206\:S \487\:VDDA) capacitor c=2.04858e-17
    c2519 (\275\:Vm1 \521\:GNDA) capacitor c=9.31841e-16
    c2520 (\488\:GNDA \1251\:GNDA) capacitor c=4.19575e-17
    c2521 (\31\:BG_REF \25\:S) capacitor c=7.21395e-16
    c2522 (\116\:Vm1 \160\:VDDA) capacitor c=3.38176e-16
    c2523 (\56\:GNDA \218\:GNDA) capacitor c=3.78661e-15
    c2524 (\1402\:GNDA \1427\:GNDA) capacitor c=1.62672e-16
    c2525 (\22\:U \786\:GNDA) capacitor c=4.69573e-17
    c2526 (\81\:BG_REF \448\:VDDA) capacitor c=3.13598e-16
    c2527 (\365\:VDDA \46\:S) capacitor c=5.28947e-16
    c2528 (\134\:BG_REF \152\:VDDA) capacitor c=2.04887e-17
    c2529 (\79\:BG_REF \445\:VDDA) capacitor c=1.36071e-17
    c2530 (\166\:Vm1 \279\:VDDA) capacitor c=3.73939e-16
    c2531 (\7\:S \102\:S) capacitor c=2.21944e-15
    c2532 (\16\:BG_REF \27\:GNDA) capacitor c=1.86162e-15
    c2533 (\32\:D1 \30\:D1) capacitor c=1.24402e-15
    c2534 (\594\:VDDA \534\:VDDA) capacitor c=4.88468e-15
    c2535 (\117\:S \38\:D1) capacitor c=3.80969e-16
    c2536 (\798\:GNDA \97\:U) capacitor c=3.72052e-17
    c2537 (\90\:BG_REF \206\:S) capacitor c=3.01415e-15
    c2538 (\117\:BG_REF \227\:S) capacitor c=2.92617e-15
    c2539 (\896\:GNDA \975\:GNDA) capacitor c=2.24479e-15
    c2540 (\9\:D1 \127\:GNDA) capacitor c=4.58871e-16
    c2541 (\372\:VDDA \79\:BG_REF) capacitor c=3.23795e-16
    c2542 (\561\:GNDA \1251\:GNDA) capacitor c=3.33847e-16
    c2543 (\664\:GNDA \515\:GNDA) capacitor c=1.22217e-15
    c2544 (\494\:GNDA \175\:GNDA) capacitor c=8.23837e-17
    c2545 (\228\:VDDA \37\:BG_REF) capacitor c=3.17145e-16
    c2546 (\56\:U \968\:GNDA) capacitor c=4.6967e-17
    c2547 (\106\:VDDA \279\:VDDA) capacitor c=2.52177e-16
    c2548 (\561\:GNDA \7\:Vo1) capacitor c=4.33828e-16
    c2549 (\938\:GNDA \890\:GNDA) capacitor c=4.83144e-17
    c2550 (\63\:Vo1 \50\:S) capacitor c=1.07858e-16
    c2551 (\75\:U \712\:GNDA) capacitor c=4.10562e-17
    c2552 (\247\:S \534\:VDDA) capacitor c=4.76183e-17
    c2553 (\1362\:GNDA \712\:GNDA) capacitor c=3.77359e-15
    c2554 (\927\:GNDA \1251\:GNDA) capacitor c=3.11265e-17
    c2555 (\466\:VDDA \279\:VDDA) capacitor c=3.71677e-16
    c2556 (\41\:X \28\:X) capacitor c=1.43771e-16
    c2557 (\198\:S \186\:S) capacitor c=6.11989e-16
    c2558 (\71\:Vo1 \102\:S) capacitor c=1.31753e-15
    c2559 (\42\:GNDA \218\:GNDA) capacitor c=9.81834e-15
    c2560 (\2\:net18 \18\:GNDA) capacitor c=4.20961e-18
    c2561 (\198\:S \279\:VDDA) capacitor c=8.33571e-17
    c2562 (\28\:vv \30\:S) capacitor c=3.40015e-17
    c2563 (\71\:Vo1 \19\:Y) capacitor c=3.87849e-16
    c2564 (\35\:S \74\:S2) capacitor c=6.20026e-16
    c2565 (\69\:U \890\:GNDA) capacitor c=1.71879e-16
    c2566 (\284\:VDDA \279\:VDDA) capacitor c=3.35645e-16
    c2567 (\52\:D1 \186\:S) capacitor c=1.87391e-16
    c2568 (\4\:U \1332\:GNDA) capacitor c=5.2224e-17
    c2569 (\249\:Vm1 \227\:S) capacitor c=5.22878e-16
    c2570 (\164\:Vm1 \53\:Vm1) capacitor c=1.06749e-15
    c2571 (\1226\:GNDA \43\:U) capacitor c=3.72052e-17
    c2572 (\28\:vv \80\:VDDA) capacitor c=2.94309e-17
    c2573 (\205\:GNDA \1215\:GNDA) capacitor c=3.36727e-17
    c2574 (\8\:vv \279\:VDDA) capacitor c=2.8964e-16
    c2575 (\73\:S2 \9\:VDDA) capacitor c=1.34744e-17
    c2576 (\537\:VDDA \536\:VDDA) capacitor c=5.13608e-16
    c2577 (\5\:GNDA \218\:GNDA) capacitor c=6.41596e-16
    c2578 (\98\:U \1251\:GNDA) capacitor c=5.06676e-17
    c2579 (\163\:GNDA \165\:GNDA) capacitor c=3.13925e-16
    c2580 (\94\:U \103\:U) capacitor c=1.69405e-17
    c2581 (\86\:Vm1 \279\:VDDA) capacitor c=3.92629e-15
    c2582 (\450\:VDDA \426\:VDDA) capacitor c=4.56638e-16
    c2583 (\2\:net18 \218\:GNDA) capacitor c=3.6109e-16
    c2584 (\390\:GNDA \391\:GNDA) capacitor c=1.13718e-15
    c2585 (\1320\:GNDA \178\:GNDA) capacitor c=3.33463e-17
    c2586 (\120\:VDDA \279\:VDDA) capacitor c=2.95619e-16
    c2587 (\407\:VDDA \80\:BG_REF) capacitor c=3.89918e-17
    c2588 (\192\:GNDA \905\:GNDA) capacitor c=9.97378e-15
    c2589 (\896\:GNDA \88\:U) capacitor c=7.93593e-17
    c2590 (\120\:BG_REF \75\:S2) capacitor c=4.62525e-16
    c2591 (\191\:S \149\:S) capacitor c=4.15734e-16
    c2592 (\34\:X \2\:net41) capacitor c=5.86563e-16
    c2593 (\73\:BG_REF \384\:VDDA) capacitor c=1.2345e-17
    c2594 (\235\:S \534\:VDDA) capacitor c=4.5184e-17
    c2595 (\385\:GNDA \391\:GNDA) capacitor c=3.27893e-16
    c2596 (\90\:BG_REF \16\:vv) capacitor c=5.14773e-16
    c2597 (\19\:vv \72\:VDDA) capacitor c=9.86212e-17
    c2598 (\31\:D2 \44\:S2) capacitor c=9.33049e-16
    c2599 (\73\:S \25\:Vo1) capacitor c=1.69435e-15
    c2600 (\238\:S \67\:VDDA) capacitor c=1.34744e-17
    c2601 (\16\:vv \412\:VDDA) capacitor c=3.40015e-17
    c2602 (\835\:VDDA \279\:VDDA) capacitor c=4.15931e-16
    c2603 (\2\:net29 \2\:net3) capacitor c=4.5945e-17
    c2604 (\181\:VDDA \31\:BG_REF) capacitor c=2.9077e-16
    c2605 (\317\:VDDA \316\:VDDA) capacitor c=1.82964e-16
    c2606 (\2\:net34 \2\:net17) capacitor c=2.00415e-16
    c2607 (\34\:Vo1 \91\:S) capacitor c=1.65953e-15
    c2608 (\298\:VDDA \279\:VDDA) capacitor c=4.62741e-16
    c2609 (\203\:GNDA \603\:GNDA) capacitor c=1.60688e-16
    c2610 (\29\:D2 \64\:S2) capacitor c=4.86013e-16
    c2611 (BG_REF \9\:BG_REF) capacitor c=8.58702e-17
    c2612 (\29\:U \58\:U) capacitor c=1.23833e-15
    c2613 (\938\:GNDA \889\:GNDA) capacitor c=4.97393e-17
    c2614 (\28\:vv \301\:VDDA) capacitor c=3.31616e-17
    c2615 (\6\:Y \102\:S) capacitor c=2.1074e-15
    c2616 (\2\:net10 \2\:net28) capacitor c=4.54619e-17
    c2617 (\505\:VDDA \101\:BG_REF) capacitor c=2.22142e-16
    c2618 (\66\:S2 \51\:BG_REF) capacitor c=1.11867e-17
    c2619 (\1068\:GNDA \39\:U) capacitor c=3.72052e-17
    c2620 (\202\:Vm1 \403\:VDDA) capacitor c=3.4614e-16
    c2621 (\287\:Vm1 \206\:S) capacitor c=5.22878e-16
    c2622 (\373\:GNDA \603\:GNDA) capacitor c=9.52729e-17
    c2623 (\118\:U \1251\:GNDA) capacitor c=3.808e-15
    c2624 (\23\:BG_REF \279\:VDDA) capacitor c=9.7877e-16
    c2625 (\2\:net21 \2\:net38) capacitor c=3.02389e-17
    c2626 (\17\:GNDA \16\:GNDA) capacitor c=8.99687e-17
    c2627 (\5\:S2 \44\:S2) capacitor c=9.33136e-17
    c2628 (\94\:VDDA \29\:BG_REF) capacitor c=2.22142e-16
    c2629 (\15\:GNDA \18\:GNDA) capacitor c=2.48094e-16
    c2630 (\5\:U \1215\:GNDA) capacitor c=3.73689e-17
    c2631 (\485\:VDDA \279\:VDDA) capacitor c=2.86639e-16
    c2632 (\1203\:GNDA \168\:GNDA) capacitor c=3.33701e-17
    c2633 (\28\:X \27\:X) capacitor c=1.81779e-16
    c2634 (\109\:GNDA \2\:net28) capacitor c=4.78517e-16
    c2635 (\26\:vv \123\:VDDA) capacitor c=3.31616e-17
    c2636 (\905\:GNDA \1226\:GNDA) capacitor c=4.80136e-15
    c2637 (\971\:GNDA \1251\:GNDA) capacitor c=3.22349e-17
    c2638 (\206\:S \294\:VDDA) capacitor c=1.0082e-17
    c2639 (\35\:X \593\:GNDA) capacitor c=4.62013e-16
    c2640 (\1238\:GNDA \1138\:GNDA) capacitor c=9.29257e-17
    c2641 (\192\:GNDA \188\:GNDA) capacitor c=3.7774e-15
    c2642 (\67\:U \203\:GNDA) capacitor c=1.83402e-16
    c2643 (\20\:vv \74\:BG_REF) capacitor c=3.40015e-17
    c2644 (\1374\:GNDA \89\:U) capacitor c=3.72052e-17
    c2645 (\117\:U \218\:GNDA) capacitor c=2.57584e-15
    c2646 (\134\:BG_REF \187\:VDDA) capacitor c=2.04887e-17
    c2647 (\2\:GNDA \12\:GNDA) capacitor c=5.12164e-16
    c2648 (\37\:S2 \8\:S2) capacitor c=2.34557e-16
    c2649 (\548\:VDDA \675\:GNDA) capacitor c=1.84359e-17
    c2650 (\40\:S2 \35\:S2) capacitor c=1.17359e-16
    c2651 (\57\:BG_REF \279\:VDDA) capacitor c=7.10697e-16
    c2652 (\675\:GNDA \60\:S2) capacitor c=2.78172e-17
    c2653 (\2\:net10 \2\:net1) capacitor c=9.66744e-16
    c2654 (\49\:U \188\:GNDA) capacitor c=1.14364e-16
    c2655 (\18\:U \23\:U) capacitor c=1.13692e-16
    c2656 (\553\:VDDA \55\:S2) capacitor c=1.54925e-17
    c2657 (\905\:GNDA \163\:GNDA) capacitor c=2.13015e-16
    c2658 (\39\:GNDA \2\:net24) capacitor c=3.46377e-16
    c2659 (\121\:S \102\:S) capacitor c=5.51432e-16
    c2660 (\1362\:GNDA \98\:U) capacitor c=6.66184e-17
    c2661 (\12\:U \1403\:GNDA) capacitor c=4.10562e-17
    c2662 (\553\:VDDA \534\:VDDA) capacitor c=9.78143e-16
    c2663 (\3\:net30 \55\:GNDA) capacitor c=6.23733e-17
    c2664 (\35\:X \70\:GNDA) capacitor c=1.23913e-16
    c2665 (\37\:S2 \8\:Vs) capacitor c=2.76224e-16
    c2666 (\150\:Vm1 \39\:Vm1) capacitor c=1.06533e-15
    c2667 (\207\:GNDA \53\:U) capacitor c=2.25351e-15
    c2668 (\1114\:GNDA \81\:U) capacitor c=3.58123e-17
    c2669 (\196\:S \102\:S) capacitor c=4.74138e-16
    c2670 (\34\:S \279\:VDDA) capacitor c=1.67297e-16
    c2671 (\779\:VDDA \237\:Vm1) capacitor c=1.69999e-15
    c2672 (\648\:GNDA \455\:GNDA) capacitor c=4.6967e-17
    c2673 (\2\:net27 \2\:net7) capacitor c=1.12347e-16
    c2674 (\2\:net7 \2\:net1) capacitor c=9.65631e-17
    c2675 (\207\:GNDA \22\:U) capacitor c=3.38399e-16
    c2676 (\797\:GNDA \1251\:GNDA) capacitor c=3.11265e-17
    c2677 (\150\:VDDA \279\:VDDA) capacitor c=2.66893e-16
    c2678 (\105\:S2 \44\:S2) capacitor c=4.52952e-16
    c2679 (\122\:Vm1 \13\:Vm1) capacitor c=1.78161e-16
    c2680 (\55\:Vo1 \812\:GNDA) capacitor c=4.2704e-16
    c2681 (\31\:X \1138\:GNDA) capacitor c=3.95102e-17
    c2682 (\25\:vv \78\:BG_REF) capacitor c=3.40015e-17
    c2683 (\45\:S \67\:S2) capacitor c=1.79451e-15
    c2684 (\507\:VDDA \279\:VDDA) capacitor c=3.77935e-16
    c2685 (\2\:vv \44\:S2) capacitor c=9.3045e-16
    c2686 (\38\:U \168\:GNDA) capacitor c=3.73689e-17
    c2687 (\104\:BG_REF \585\:VDDA) capacitor c=6.89703e-16
    c2688 (\24\:BG_REF \3\:VDDA) capacitor c=2.14804e-17
    c2689 (\173\:VDDA \43\:BG_REF) capacitor c=2.32098e-17
    c2690 (\247\:S \40\:Vo1) capacitor c=6.46379e-17
    c2691 (\10\:Y \10\:X) capacitor c=6.73517e-16
    c2692 (\186\:Vm1 \364\:VDDA) capacitor c=3.47479e-16
    c2693 (\41\:BG_REF \237\:S) capacitor c=6.30485e-16
    c2694 (\76\:S2 \534\:VDDA) capacitor c=1.89261e-17
    c2695 (\260\:Vm1 \279\:VDDA) capacitor c=1.18332e-15
    c2696 (\33\:vv \82\:BG_REF) capacitor c=3.31616e-17
    c2697 (\1505\:GNDA \51\:Vo1) capacitor c=9.45579e-16
    c2698 (\237\:S \13\:VDDA) capacitor c=1.03845e-17
    c2699 (\1034\:GNDA \961\:GNDA) capacitor c=9.29257e-17
    c2700 (\21\:GNDA \2\:net22) capacitor c=1.74979e-16
    c2701 (\87\:U \1335\:GNDA) capacitor c=5.64553e-17
    c2702 (\23\:GNDA \218\:GNDA) capacitor c=6.89734e-15
    c2703 (\996\:GNDA \1009\:GNDA) capacitor c=3.15482e-16
    c2704 (\180\:Vm1 \279\:VDDA) capacitor c=3.74426e-16
    c2705 (\776\:VDDA \110\:BG_REF) capacitor c=7.24715e-16
    c2706 (\1251\:GNDA \1167\:GNDA) capacitor c=9.29257e-17
    c2707 (\30\:U \192\:GNDA) capacitor c=5.47526e-16
    c2708 (\850\:GNDA \203\:GNDA) capacitor c=4.93613e-16
    c2709 (\15\:VDDA \279\:VDDA) capacitor c=4.0591e-15
    c2710 (\898\:GNDA \535\:GNDA) capacitor c=5.70766e-16
    c2711 (\779\:VDDA \222\:S) capacitor c=3.82852e-16
    c2712 (\4\:X \102\:S) capacitor c=1.27873e-15
    c2713 (\896\:GNDA \928\:GNDA) capacitor c=3.1596e-17
    c2714 (\249\:Vm1 \511\:VDDA) capacitor c=3.22227e-16
    c2715 (\16\:BIAS \8\:BIAS) capacitor c=6.44011e-16
    c2716 (\117\:BG_REF \25\:vv) capacitor c=5.14497e-16
    c2717 (\426\:VDDA \279\:VDDA) capacitor c=7.44711e-15
    c2718 (\118\:U \379\:GNDA) capacitor c=5.9219e-17
    c2719 (\7\:Vs \8\:S2) capacitor c=1.11925e-17
    c2720 (\2\:net34 \218\:GNDA) capacitor c=3.7992e-16
    c2721 (\122\:VDDA \27\:BG_REF) capacitor c=4.80342e-16
    c2722 (\51\:BG_REF \277\:VDDA) capacitor c=1.36071e-17
    c2723 (\151\:S \718\:GNDA) capacitor c=1.5799e-16
    c2724 (\92\:S2 \8\:D2) capacitor c=1.79151e-16
    c2725 (\65\:S2 \537\:VDDA) capacitor c=3.13954e-16
    c2726 (\86\:S2 \40\:S2) capacitor c=1.89203e-15
    c2727 (\205\:GNDA \818\:GNDA) capacitor c=2.78288e-15
    c2728 (\684\:GNDA \1251\:GNDA) capacitor c=2.07844e-14
    c2729 (\71\:Vo1 \539\:GNDA) capacitor c=6.75235e-17
    c2730 (\86\:VDDA \665\:VDDA) capacitor c=2.25167e-16
    c2731 (\110\:Vm1 \154\:VDDA) capacitor c=3.38176e-16
    c2732 (\120\:Vm1 \12\:Vm1) capacitor c=8.80193e-16
    c2733 (\117\:BG_REF \279\:VDDA) capacitor c=9.52457e-16
    c2734 (\34\:U \1251\:GNDA) capacitor c=7.1556e-17
    c2735 (\645\:VDDA \525\:VDDA) capacitor c=7.65448e-16
    c2736 (\47\:D1 \254\:S) capacitor c=9.14752e-16
    c2737 (\297\:Vm1 \66\:S2) capacitor c=5.08078e-16
    c2738 (\34\:Vo1 \99\:S) capacitor c=2.29306e-16
    c2739 (\317\:VDDA \279\:VDDA) capacitor c=3.27009e-16
    c2740 (\905\:GNDA \1302\:GNDA) capacitor c=3.62082e-15
    c2741 (\2\:net36 \39\:GNDA) capacitor c=2.01497e-15
    c2742 (\63\:Vo1 \194\:S) capacitor c=9.54295e-16
    c2743 (\226\:S \75\:S2) capacitor c=1.31478e-16
    c2744 (\114\:VDDA \13\:VDDA) capacitor c=8.50684e-16
    c2745 (\105\:BG_REF \59\:VDDA) capacitor c=1.33555e-17
    c2746 (\93\:S \102\:S) capacitor c=5.01659e-16
    c2747 (\448\:VDDA \447\:VDDA) capacitor c=1.82419e-16
    c2748 (\38\:S \279\:VDDA) capacitor c=1.67343e-16
    c2749 (\84\:U \1402\:GNDA) capacitor c=3.54052e-16
    c2750 (\45\:BG_REF \217\:VDDA) capacitor c=1.13753e-17
    c2751 (\175\:VDDA \25\:BG_REF) capacitor c=2.9077e-16
    c2752 (\46\:GNDA \2\:net31) capacitor c=4.60159e-16
    c2753 (\54\:Vo1 \102\:S) capacitor c=1.14936e-15
    c2754 (\689\:GNDA \1251\:GNDA) capacitor c=2.09898e-17
    c2755 (\205\:GNDA \784\:GNDA) capacitor c=3.77359e-15
    c2756 (\2\:net33 \2\:net41) capacitor c=2.50259e-17
    c2757 (\20\:vv \542\:VDDA) capacitor c=7.86867e-17
    c2758 (\1\:GNDA \218\:GNDA) capacitor c=3.78192e-16
    c2759 (\28\:X \31\:X) capacitor c=1.00794e-16
    c2760 (\41\:BG_REF \279\:VDDA) capacitor c=7.10308e-16
    c2761 (\5\:D1 \1251\:GNDA) capacitor c=1.28139e-15
    c2762 (\79\:BG_REF \390\:VDDA) capacitor c=1.2345e-17
    c2763 (\182\:GNDA \185\:GNDA) capacitor c=1.49158e-16
    c2764 (\15\:S2 \23\:S2) capacitor c=6.68839e-16
    c2765 (\12\:S2 \18\:S2) capacitor c=1.31885e-16
    c2766 (\87\:U \1332\:GNDA) capacitor c=1.26142e-15
    c2767 (\286\:VDDA \285\:VDDA) capacitor c=1.82419e-16
    c2768 (\239\:S \257\:VDDA) capacitor c=1.23137e-17
    c2769 (\54\:U \64\:U) capacitor c=1.315e-15
    c2770 (\794\:GNDA \1251\:GNDA) capacitor c=4.19575e-17
    c2771 (\30\:U \170\:GNDA) capacitor c=1.54869e-17
    c2772 (\160\:Vm1 \49\:Vm1) capacitor c=1.83865e-16
    c2773 (\26\:vv \18\:S) capacitor c=3.40015e-17
    c2774 (\34\:vv \233\:VDDA) capacitor c=3.31616e-17
    c2775 (\2\:net21 \8\:GNDA) capacitor c=3.94178e-15
    c2776 (\212\:Vm1 \99\:Vm1) capacitor c=1.06629e-15
    c2777 (\134\:BG_REF \222\:VDDA) capacitor c=2.04887e-17
    c2778 (\227\:S \279\:VDDA) capacitor c=1.09416e-15
    c2779 (\15\:vv \44\:S2) capacitor c=1.98867e-17
    c2780 (\33\:vv \529\:VDDA) capacitor c=1.0092e-17
    c2781 (\186\:Vm1 \73\:Vm1) capacitor c=1.06182e-15
    c2782 (\20\:BG_REF \230\:GNDA) capacitor c=2.38201e-16
    c2783 (\23\:BG_REF \3\:VDDA) capacitor c=3.03102e-17
    c2784 (\175\:S \102\:S) capacitor c=2.93114e-16
    c2785 (\280\:VDDA \73\:BG_REF) capacitor c=2.84857e-16
    c2786 (\204\:S \537\:VDDA) capacitor c=1.54711e-16
    c2787 (\1362\:GNDA \748\:GNDA) capacitor c=2.79934e-15
    c2788 (\896\:GNDA \1314\:GNDA) capacitor c=3.74307e-15
    c2789 (\712\:GNDA \753\:GNDA) capacitor c=3.15482e-16
    c2790 (\18\:D2 \12\:Vs) capacitor c=1.04649e-15
    c2791 (\534\:VDDA \149\:S) capacitor c=1.59846e-15
    c2792 (\804\:VDDA \248\:Vm1) capacitor c=6.77282e-16
    c2793 (\583\:VDDA \534\:VDDA) capacitor c=5.76555e-16
    c2794 (\587\:VDDA \230\:GNDA) capacitor c=2.67794e-16
    c2795 (\72\:U \83\:U) capacitor c=1.69405e-17
    c2796 (\720\:VDDA \110\:Vm1) capacitor c=2.42065e-16
    c2797 (\17\:Y \218\:GNDA) capacitor c=1.4255e-15
    c2798 (\205\:GNDA \203\:GNDA) capacitor c=5.38841e-16
    c2799 (\512\:GNDA \188\:GNDA) capacitor c=5.35597e-17
    c2800 (\31\:BG_REF \146\:VDDA) capacitor c=3.12125e-16
    c2801 (\130\:Vm1 \279\:VDDA) capacitor c=3.73738e-16
    c2802 (\559\:VDDA \534\:VDDA) capacitor c=3.57513e-16
    c2803 (\194\:VDDA \18\:S) capacitor c=5.28947e-16
    c2804 (\69\:GNDA \3\:GNDA) capacitor c=8.61395e-16
    c2805 (\1018\:GNDA \983\:GNDA) capacitor c=9.29257e-17
    c2806 (\534\:VDDA \550\:GNDA) capacitor c=7.58639e-16
    c2807 (\31\:D2 \534\:VDDA) capacitor c=2.0313e-16
    c2808 (\4\:Vo2 \149\:S) capacitor c=8.23209e-18
    c2809 (\137\:BG_REF \900\:VDDA) capacitor c=2.96182e-16
    c2810 (\131\:BG_REF \239\:S) capacitor c=1.31478e-16
    c2811 (\69\:Vo1 \684\:GNDA) capacitor c=2.1036e-17
    c2812 (\581\:VDDA \230\:GNDA) capacitor c=1.76877e-16
    c2813 (\74\:S2 \279\:VDDA) capacitor c=2.75117e-15
    c2814 (\29\:D2 \14\:BG_REF) capacitor c=5.66594e-17
    c2815 (\18\:U \928\:GNDA) capacitor c=1.50519e-16
    c2816 (\6\:U \1215\:GNDA) capacitor c=1.14364e-16
    c2817 (\17\:Y \32\:GNDA) capacitor c=1.57893e-15
    c2818 (\17\:S2 \23\:S2) capacitor c=4.55374e-17
    c2819 (\166\:Vm1 \300\:VDDA) capacitor c=3.50869e-16
    c2820 (\61\:BG_REF \279\:VDDA) capacitor c=7.11105e-16
    c2821 (\954\:GNDA \24\:U) capacitor c=3.59294e-17
    c2822 (\554\:VDDA \44\:S2) capacitor c=1.27237e-17
    c2823 (\370\:VDDA \68\:BG_REF) capacitor c=3.8451e-17
    c2824 (\31\:Vm1 \279\:VDDA) capacitor c=3.95899e-15
    c2825 (\659\:GNDA \648\:GNDA) capacitor c=3.71555e-17
    c2826 (\647\:VDDA \249\:Vm1) capacitor c=5.15469e-16
    c2827 (\240\:S \554\:VDDA) capacitor c=1.5556e-16
    c2828 (\574\:VDDA \230\:GNDA) capacitor c=3.92058e-16
    c2829 (\58\:U \928\:GNDA) capacitor c=3.88004e-17
    c2830 (\150\:VDDA \17\:VDDA) capacitor c=1.06141e-15
    c2831 (\177\:VDDA \279\:VDDA) capacitor c=3.30782e-16
    c2832 (\800\:GNDA \461\:GNDA) capacitor c=3.64213e-17
    c2833 (\32\:D1 \9\:X) capacitor c=2.39703e-17
    c2834 (\19\:Vo1 \10\:D1) capacitor c=1.12849e-15
    c2835 (\553\:VDDA \279\:VDDA) capacitor c=4.44933e-16
    c2836 (\542\:VDDA \101\:BG_REF) capacitor c=4.48158e-16
    c2837 (\115\:S \38\:D1) capacitor c=1.65903e-15
    c2838 (\159\:VDDA \40\:BG_REF) capacitor c=5.28947e-16
    c2839 (\191\:VDDA \14\:S) capacitor c=1.22542e-16
    c2840 (\205\:GNDA \1251\:GNDA) capacitor c=1.21104e-14
    c2841 (\487\:VDDA \56\:VDDA) capacitor c=6.64563e-16
    c2842 (\20\:vv \279\:VDDA) capacitor c=4.84688e-15
    c2843 (\204\:S \668\:VDDA) capacitor c=1.34387e-16
    c2844 (\110\:BG_REF \534\:VDDA) capacitor c=2.14746e-17
    c2845 (\1507\:GNDA \684\:GNDA) capacitor c=2.54269e-16
    c2846 (\194\:Vm1 \279\:VDDA) capacitor c=3.7428e-16
    c2847 (\67\:S2 \20\:vv) capacitor c=1.24156e-16
    c2848 (\102\:S2 \550\:VDDA) capacitor c=2.45064e-16
    c2849 (\953\:GNDA \954\:GNDA) capacitor c=4.27087e-16
    c2850 (\81\:U \1175\:GNDA) capacitor c=6.53004e-17
    c2851 (\17\:vv \204\:VDDA) capacitor c=3.31616e-17
    c2852 (\41\:Vm1 \279\:VDDA) capacitor c=3.95779e-15
    c2853 (\1140\:GNDA \1122\:GNDA) capacitor c=4.6967e-17
    c2854 (\32\:D2 \1251\:GNDA) capacitor c=1.49521e-15
    c2855 (\122\:GNDA \1251\:GNDA) capacitor c=9.37118e-16
    c2856 (\395\:VDDA \45\:VDDA) capacitor c=1.03461e-15
    c2857 (\207\:GNDA \1215\:GNDA) capacitor c=3.77098e-15
    c2858 (\116\:U \657\:GNDA) capacitor c=9.94847e-17
    c2859 (\248\:Vm1 \26\:vv) capacitor c=3.1837e-16
    c2860 (\276\:Vm1 \542\:VDDA) capacitor c=7.63406e-16
    c2861 (\53\:U \1159\:GNDA) capacitor c=7.21959e-17
    c2862 (\189\:VDDA \279\:VDDA) capacitor c=3.94466e-16
    c2863 (\337\:VDDA \44\:S) capacitor c=1.21854e-16
    c2864 (\460\:VDDA \77\:BG_REF) capacitor c=2.34161e-16
    c2865 (\249\:VDDA \39\:BG_REF) capacitor c=2.96269e-16
    c2866 (\437\:GNDA \449\:GNDA) capacitor c=9.29257e-17
    c2867 (\379\:GNDA \603\:GNDA) capacitor c=4.30497e-16
    c2868 (\31\:S2 \5\:S2) capacitor c=1.03984e-16
    c2869 (\190\:Vm1 \77\:Vm1) capacitor c=1.06288e-15
    c2870 (\1320\:GNDA \1364\:GNDA) capacitor c=4.6967e-17
    c2871 (\56\:U \823\:GNDA) capacitor c=1.3611e-15
    c2872 (\648\:GNDA \467\:GNDA) capacitor c=1.62264e-15
    c2873 (\620\:GNDA \419\:GNDA) capacitor c=1.5803e-15
    c2874 (\352\:VDDA \279\:VDDA) capacitor c=3.33877e-16
    c2875 (\287\:Vm1 \16\:vv) capacitor c=2.99977e-16
    c2876 (\29\:D2 \43\:S2) capacitor c=9.03576e-16
    c2877 (\116\:GNDA \218\:GNDA) capacitor c=5.31243e-15
    c2878 (\65\:S2 \59\:BG_REF) capacitor c=1.11867e-17
    c2879 (\77\:S2 \34\:vv) capacitor c=8.38746e-15
    c2880 (\1373\:GNDA \1398\:GNDA) capacitor c=1.62672e-16
    c2881 (\5\:GNDA \2\:net7) capacitor c=4.48236e-17
    c2882 (\16\:vv \414\:VDDA) capacitor c=3.31616e-17
    c2883 (\53\:Vm1 \279\:VDDA) capacitor c=3.90305e-15
    c2884 (\647\:VDDA \102\:S2) capacitor c=9.64943e-17
    c2885 (\287\:Vm1 \658\:VDDA) capacitor c=5.12333e-16
    c2886 (\33\:vv \408\:VDDA) capacitor c=3.31616e-17
    c2887 (\104\:U \1362\:GNDA) capacitor c=8.51404e-16
    c2888 (\88\:S2 \15\:Vs) capacitor c=6.23008e-16
    c2889 (\74\:U \798\:GNDA) capacitor c=3.73689e-17
    c2890 (\134\:BG_REF \279\:VDDA) capacitor c=2.77379e-15
    c2891 (\2\:net12 \2\:net26) capacitor c=1.05956e-15
    c2892 (\47\:S \74\:S2) capacitor c=1.79451e-15
    c2893 (\43\:BG_REF \279\:VDDA) capacitor c=7.10839e-16
    c2894 (\20\:vv \400\:VDDA) capacitor c=3.31616e-17
    c2895 (\756\:GNDA \712\:GNDA) capacitor c=5.35597e-17
    c2896 (\4\:U \1312\:GNDA) capacitor c=1.81769e-16
    c2897 (\25\:vv \404\:VDDA) capacitor c=3.31616e-17
    c2898 (\82\:S2 \44\:S2) capacitor c=1.0125e-16
    c2899 (\177\:GNDA \178\:GNDA) capacitor c=4.12292e-16
    c2900 (\45\:BG_REF \237\:S) capacitor c=6.30485e-16
    c2901 (\126\:VDDA \32\:BG_REF) capacitor c=4.86031e-17
    c2902 (\745\:GNDA \746\:GNDA) capacitor c=4.12292e-16
    c2903 (\17\:vv \692\:VDDA) capacitor c=9.7932e-16
    c2904 (\35\:U \158\:GNDA) capacitor c=1.14364e-16
    c2905 (\39\:S \9\:S2) capacitor c=2.26646e-15
    c2906 (\134\:BG_REF \201\:VDDA) capacitor c=1.03669e-17
    c2907 (\370\:VDDA \279\:VDDA) capacitor c=3.97994e-16
    c2908 (\95\:S2 \29\:D2) capacitor c=3.8047e-16
    c2909 (\23\:U \928\:GNDA) capacitor c=3.77148e-17
    c2910 (\227\:S \534\:VDDA) capacitor c=4.92369e-17
    c2911 (\65\:Vm1 \279\:VDDA) capacitor c=3.94854e-15
    c2912 (\1152\:GNDA \1244\:GNDA) capacitor c=3.21646e-16
    c2913 (\905\:GNDA \203\:GNDA) capacitor c=1.22702e-15
    c2914 (\35\:X \1140\:GNDA) capacitor c=1.41018e-15
    c2915 (\37\:BG_REF \9\:S2) capacitor c=1.17219e-16
    c2916 (\539\:GNDA \4\:Vo1) capacitor c=9.01599e-17
    c2917 (\239\:S \279\:VDDA) capacitor c=2.97147e-15
    c2918 (\17\:S2 \44\:S2) capacitor c=3.95477e-16
    c2919 (\249\:Vm1 \25\:vv) capacitor c=2.70636e-16
    c2920 (\71\:S2 \27\:BG_REF) capacitor c=1.11867e-17
    c2921 (\639\:VDDA \67\:S2) capacitor c=1.09771e-16
    c2922 (\896\:GNDA \79\:U) capacitor c=3.38399e-16
    c2923 (\26\:GNDA \218\:GNDA) capacitor c=1.19148e-15
    c2924 (\134\:Vm1 \279\:VDDA) capacitor c=3.71316e-16
    c2925 (\1561\:GNDA \898\:GNDA) capacitor c=4.20515e-17
    c2926 (\59\:D1 \1527\:GNDA) capacitor c=1.21531e-15
    c2927 (\2\:net22 \218\:GNDA) capacitor c=1.11138e-15
    c2928 (\116\:U \203\:GNDA) capacitor c=3.23635e-15
    c2929 (\426\:VDDA \168\:VDDA) capacitor c=3.88687e-16
    c2930 (\267\:VDDA \30\:S) capacitor c=1.22443e-16
    c2931 (\491\:VDDA \75\:BG_REF) capacitor c=1.89197e-16
    c2932 (\146\:Vm1 \230\:VDDA) capacitor c=3.08363e-16
    c2933 (\29\:BIAS \27\:BIAS) capacitor c=1.25883e-16
    c2934 (\70\:U \1054\:GNDA) capacitor c=1.54869e-17
    c2935 (\221\:S \21\:vv) capacitor c=5.23282e-16
    c2936 (\1432\:GNDA \1364\:GNDA) capacitor c=4.6967e-17
    c2937 (\24\:vv \534\:VDDA) capacitor c=4.51962e-17
    c2938 (\76\:VDDA \75\:VDDA) capacitor c=2.07097e-16
    c2939 (\112\:VDDA \31\:BG_REF) capacitor c=3.86661e-16
    c2940 (\55\:Vo1 \54\:Vo1) capacitor c=2.74626e-17
    c2941 (\67\:BG_REF \279\:VDDA) capacitor c=1.42359e-15
    c2942 (\194\:Vm1 \81\:Vm1) capacitor c=1.06288e-15
    c2943 (\52\:S \51\:S) capacitor c=1.74061e-15
    c2944 (\68\:S2 \19\:vv) capacitor c=6.88182e-15
    c2945 (\41\:S \72\:S2) capacitor c=2.12625e-15
    c2946 (\296\:VDDA \32\:S) capacitor c=1.21882e-16
    c2947 (\1362\:GNDA \437\:GNDA) capacitor c=1.26043e-17
    c2948 (\75\:Vm1 \279\:VDDA) capacitor c=3.95842e-15
    c2949 (\620\:GNDA \413\:GNDA) capacitor c=1.49572e-16
    c2950 (\634\:GNDA \431\:GNDA) capacitor c=4.6967e-17
    c2951 (\2\:net32 \63\:GNDA) capacitor c=5.59944e-16
    c2952 (\534\:VDDA \521\:GNDA) capacitor c=4.62204e-16
    c2953 (\68\:U \798\:GNDA) capacitor c=1.63679e-16
    c2954 (\255\:VDDA \29\:VDDA) capacitor c=1.06673e-15
    c2955 (\31\:Vo1 \98\:S) capacitor c=1.02961e-16
    c2956 (\103\:S2 \279\:VDDA) capacitor c=3.00652e-15
    c2957 (\212\:VDDA \279\:VDDA) capacitor c=3.32577e-16
    c2958 (\70\:U \1057\:GNDA) capacitor c=6.78232e-17
    c2959 (\44\:D1 \49\:Vo1) capacitor c=2.20481e-15
    c2960 (\17\:vv \85\:VDDA) capacitor c=3.49326e-17
    c2961 (\25\:BG_REF \216\:S) capacitor c=3.60331e-16
    c2962 (\28\:vv \12\:S) capacitor c=3.40015e-17
    c2963 (\122\:VDDA \28\:BG_REF) capacitor c=4.86031e-17
    c2964 (\32\:U \192\:GNDA) capacitor c=5.47526e-16
    c2965 (\43\:U \180\:GNDA) capacitor c=1.3611e-15
    c2966 (\55\:Vo1 \39\:D1) capacitor c=1.06825e-15
    c2967 (\331\:VDDA \37\:S) capacitor c=1.27935e-16
    c2968 (\64\:Vo1 \230\:GNDA) capacitor c=1.85588e-16
    c2969 (\668\:VDDA \658\:VDDA) capacitor c=1.38873e-15
    c2970 (\28\:vv \832\:VDDA) capacitor c=5.99724e-17
    c2971 (\116\:U \115\:GNDA) capacitor c=3.06776e-16
    c2972 (\118\:U \591\:GNDA) capacitor c=2.731e-16
    c2973 (\1096\:GNDA \732\:GNDA) capacitor c=3.24909e-17
    c2974 (\18\:GNDA \2\:net22) capacitor c=2.20369e-16
    c2975 (\120\:Vm1 \148\:VDDA) capacitor c=4.73118e-16
    c2976 (\206\:Vm1 \279\:VDDA) capacitor c=3.75029e-16
    c2977 (\205\:GNDA \168\:GNDA) capacitor c=3.39571e-17
    c2978 (\320\:GNDA \330\:GNDA) capacitor c=1.14366e-16
    c2979 (\1362\:GNDA \107\:U) capacitor c=3.36974e-16
    c2980 (\31\:Vs \28\:D2) capacitor c=4.99043e-16
    c2981 (\192\:GNDA \954\:GNDA) capacitor c=1.26043e-17
    c2982 (\103\:U \397\:GNDA) capacitor c=4.10562e-17
    c2983 (\24\:vv \279\:VDDA) capacitor c=2.72934e-15
    c2984 (\815\:GNDA \850\:GNDA) capacitor c=1.46284e-16
    c2985 (\134\:BG_REF \100\:VDDA) capacitor c=1.06273e-17
    c2986 (\236\:VDDA \279\:VDDA) capacitor c=3.71677e-16
    c2987 (\639\:VDDA \287\:Vm1) capacitor c=5.09483e-16
    c2988 (\107\:U \1122\:GNDA) capacitor c=4.6967e-17
    c2989 (\978\:GNDA \961\:GNDA) capacitor c=4.83144e-17
    c2990 (\80\:S2 \14\:S2) capacitor c=1.89512e-15
    c2991 (\1259\:GNDA \1238\:GNDA) capacitor c=5.35597e-17
    c2992 (\116\:U \90\:U) capacitor c=3.71334e-16
    c2993 (\176\:Vm1 \331\:VDDA) capacitor c=3.49531e-16
    c2994 (\22\:S2 \3\:S2) capacitor c=1.04081e-16
    c2995 (\22\:BIAS \1\:BIAS) capacitor c=9.02596e-16
    c2996 (\29\:S2 \44\:S2) capacitor c=2.8631e-17
    c2997 (\306\:VDDA \271\:Vm1) capacitor c=2.18118e-16
    c2998 (\1362\:GNDA \72\:U) capacitor c=1.12455e-15
    c2999 (\1215\:GNDA \1233\:GNDA) capacitor c=3.15482e-16
    c3000 (\12\:Vm1 \279\:VDDA) capacitor c=3.92678e-15
    c3001 (\26\:U \956\:GNDA) capacitor c=4.6967e-17
    c3002 (\1421\:GNDA \1265\:GNDA) capacitor c=4.6967e-17
    c3003 (\118\:VDDA \24\:BG_REF) capacitor c=4.86031e-17
    c3004 (\387\:VDDA \279\:VDDA) capacitor c=3.31143e-16
    c3005 (\279\:S \59\:D1) capacitor c=6.5796e-16
    c3006 (\102\:S2 \33\:vv) capacitor c=1.24156e-16
    c3007 (\230\:GNDA \2\:net22) capacitor c=4.24492e-16
    c3008 (\362\:VDDA \43\:VDDA) capacitor c=1.0554e-15
    c3009 (\99\:Vm1 \279\:VDDA) capacitor c=3.95929e-15
    c3010 (\50\:S2 \8\:D2) capacitor c=3.1614e-17
    c3011 (\874\:GNDA \776\:GNDA) capacitor c=1.57813e-16
    c3012 (\67\:BG_REF \389\:VDDA) capacitor c=3.01353e-16
    c3013 (\22\:Vs \1251\:GNDA) capacitor c=6.33758e-17
    c3014 (\128\:GNDA \1251\:GNDA) capacitor c=3.93281e-16
    c3015 (\832\:VDDA \279\:VDDA) capacitor c=4.17492e-16
    c3016 (\779\:VDDA \111\:BG_REF) capacitor c=1.10524e-15
    c3017 (\68\:S2 \748\:VDDA) capacitor c=4.0614e-16
    c3018 (\77\:S2 \897\:VDDA) capacitor c=3.06752e-16
    c3019 (\160\:VDDA \39\:BG_REF) capacitor c=5.39428e-16
    c3020 (\2\:net38 \218\:GNDA) capacitor c=4.31459e-16
    c3021 (\195\:VDDA \18\:S) capacitor c=1.22542e-16
    c3022 (\69\:Vo1 \149\:S) capacitor c=3.52685e-16
    c3023 (\12\:S \279\:VDDA) capacitor c=1.67411e-16
    c3024 (\26\:U \1006\:GNDA) capacitor c=1.14364e-16
    c3025 (\25\:BG_REF \140\:VDDA) capacitor c=3.12125e-16
    c3026 (\33\:BG_REF \237\:S) capacitor c=1.05323e-15
    c3027 (\22\:Vm1 \279\:VDDA) capacitor c=3.92464e-15
    c3028 (\203\:GNDA \104\:U) capacitor c=1.46279e-15
    c3029 (\89\:S \87\:S) capacitor c=1.23567e-15
    c3030 (\1551\:GNDA \1251\:GNDA) capacitor c=7.56923e-16
    c3031 (\71\:U \1175\:GNDA) capacitor c=6.12347e-17
    c3032 (\1313\:GNDA \1314\:GNDA) capacitor c=4.05613e-16
    c3033 (\407\:VDDA \279\:VDDA) capacitor c=3.96231e-16
    c3034 (\203\:GNDA \716\:GNDA) capacitor c=3.40786e-16
    c3035 (\758\:GNDA \1251\:GNDA) capacitor c=2.13982e-16
    c3036 (\2\:net2 \63\:GNDA) capacitor c=1.14217e-15
    c3037 (\46\:GNDA \218\:GNDA) capacitor c=8.56924e-15
    c3038 (\1557\:GNDA \27\:Vs) capacitor c=6.17503e-16
    c3039 (\1324\:GNDA \1394\:GNDA) capacitor c=3.47775e-16
    c3040 (\124\:Vm1 \191\:VDDA) capacitor c=3.39738e-16
    c3041 (\63\:Vo1 \170\:S) capacitor c=2.36311e-16
    c3042 (\204\:S \426\:VDDA) capacitor c=1.49093e-16
    c3043 (\88\:VDDA \23\:BG_REF) capacitor c=2.22142e-16
    c3044 (\832\:VDDA \118\:Vm1) capacitor c=2.4074e-16
    c3045 (\77\:BG_REF \444\:VDDA) capacitor c=3.13598e-16
    c3046 (\148\:Vm1 \279\:VDDA) capacitor c=3.71056e-16
    c3047 (\156\:VDDA \10\:S) capacitor c=1.22557e-16
    c3048 (\69\:U \99\:U) capacitor c=1.24143e-15
    c3049 (\200\:Vm1 \87\:Vm1) capacitor c=1.06544e-15
    c3050 (\2\:net9 \218\:GNDA) capacitor c=3.94806e-16
    c3051 (\69\:U \975\:GNDA) capacitor c=2.65805e-16
    c3052 (\31\:BG_REF \180\:VDDA) capacitor c=1.1294e-17
    c3053 (\25\:Vs \1251\:GNDA) capacitor c=6.37792e-16
    c3054 (\1362\:GNDA \102\:U) capacitor c=7.93593e-17
    c3055 (\130\:GNDA \1251\:GNDA) capacitor c=9.28217e-16
    c3056 (\12\:BG_REF \14\:BG_REF) capacitor c=1.76438e-17
    c3057 (\57\:S2 \44\:S2) capacitor c=1.38591e-15
    c3058 (\105\:U \203\:GNDA) capacitor c=3.39706e-15
    c3059 (\222\:S \493\:VDDA) capacitor c=2.04858e-17
    c3060 (\242\:S \901\:VDDA) capacitor c=1.35229e-16
    c3061 (\19\:Y \541\:GNDA) capacitor c=2.10264e-17
    c3062 (\1206\:GNDA \1079\:GNDA) capacitor c=4.6967e-17
    c3063 (\579\:VDDA \279\:VDDA) capacitor c=3.30453e-16
    c3064 (\94\:U \1095\:GNDA) capacitor c=3.54052e-16
    c3065 (\81\:BG_REF \279\:VDDA) capacitor c=1.00128e-15
    c3066 (\100\:BG_REF \216\:S) capacitor c=1.31478e-16
    c3067 (\7\:U \1398\:GNDA) capacitor c=1.54869e-17
    c3068 (\995\:GNDA \1009\:GNDA) capacitor c=1.62672e-16
    c3069 (\896\:GNDA \1251\:GNDA) capacitor c=8.76712e-15
    c3070 (\409\:VDDA \81\:BG_REF) capacitor c=5.37491e-16
    c3071 (\208\:S \18\:vv) capacitor c=5.10492e-16
    c3072 (\48\:Vo1 \684\:GNDA) capacitor c=2.58583e-16
    c3073 (\58\:Vo1 \102\:S) capacitor c=9.02184e-16
    c3074 (\207\:GNDA \786\:GNDA) capacitor c=2.80754e-15
    c3075 (\23\:Vm1 \24\:Vm1) capacitor c=6.39737e-16
    c3076 (\64\:S2 \537\:GNDA) capacitor c=1.08784e-17
    c3077 (\4\:BIAS \1251\:GNDA) capacitor c=1.47213e-15
    c3078 (\905\:GNDA \948\:GNDA) capacitor c=4.6653e-15
    c3079 (\23\:D1 \6\:X) capacitor c=6.02843e-17
    c3080 (\61\:D1 \48\:Vo1) capacitor c=2.41676e-15
    c3081 (\1\:BG_REF \3\:BG_REF) capacitor c=1.2753e-16
    c3082 (\116\:U \800\:GNDA) capacitor c=5.22777e-17
    c3083 (\6\:Vs \1251\:GNDA) capacitor c=1.03974e-15
    c3084 (\1105\:GNDA \1074\:GNDA) capacitor c=1.12465e-15
    c3085 (\2\:D2 \1251\:GNDA) capacitor c=1.82933e-15
    c3086 (\216\:Vm1 \103\:Vm1) capacitor c=1.06629e-15
    c3087 (\154\:VDDA \35\:BG_REF) capacitor c=5.39428e-16
    c3088 (\218\:Vm1 \495\:VDDA) capacitor c=2.88285e-16
    c3089 (\66\:GNDA \2\:net30) capacitor c=4.40651e-16
    c3090 (\16\:S \279\:VDDA) capacitor c=1.67398e-16
    c3091 (\31\:D2 \57\:S2) capacitor c=1.12181e-15
    c3092 (\669\:GNDA \203\:GNDA) capacitor c=1.57456e-15
    c3093 (\45\:Vm1 \46\:Vm1) capacitor c=6.44982e-16
    c3094 (\34\:vv \34\:BG_REF) capacitor c=3.31616e-17
    c3095 (\73\:S \102\:S) capacitor c=5.6921e-16
    c3096 (\594\:VDDA \279\:VDDA) capacitor c=2.78043e-15
    c3097 (\165\:VDDA \170\:VDDA) capacitor c=4.75166e-16
    c3098 (\116\:Vm1 \124\:VDDA) capacitor c=3.44656e-16
    c3099 (\15\:vv \6\:vv) capacitor c=7.06321e-16
    c3100 (\218\:Vm1 \279\:VDDA) capacitor c=4.52787e-16
    c3101 (\118\:U \401\:GNDA) capacitor c=5.79169e-17
    c3102 (\3\:D2 \1251\:GNDA) capacitor c=1.91067e-15
    c3103 (\116\:Vm1 \9\:VDDA) capacitor c=4.55576e-16
    c3104 (\27\:Vs \534\:GNDA) capacitor c=2.89292e-16
    c3105 (\7\:vv \16\:S) capacitor c=3.40015e-17
    c3106 (\675\:GNDA \1251\:GNDA) capacitor c=3.90552e-16
    c3107 (\94\:GNDA \218\:GNDA) capacitor c=8.20737e-15
    c3108 (\18\:U \959\:GNDA) capacitor c=1.82468e-16
    c3109 (\6\:vv \1251\:GNDA) capacitor c=2.16436e-15
    c3110 (\896\:GNDA \996\:GNDA) capacitor c=1.33732e-17
    c3111 (\19\:vv \153\:VDDA) capacitor c=3.31616e-17
    c3112 (\196\:S \63\:S) capacitor c=4.50343e-16
    c3113 (\259\:VDDA \279\:VDDA) capacitor c=3.98521e-16
    c3114 (\249\:Vm1 \117\:BG_REF) capacitor c=1.52034e-15
    c3115 (\117\:U \419\:GNDA) capacitor c=2.90508e-17
    c3116 (\130\:Vm1 \197\:VDDA) capacitor c=3.39738e-16
    c3117 (\1507\:GNDA \689\:GNDA) capacitor c=5.76397e-16
    c3118 (\7\:U \1374\:GNDA) capacitor c=1.63679e-16
    c3119 (\6\:Vs \134\:GNDA) capacitor c=2.95202e-16
    c3120 (\160\:VDDA \40\:BG_REF) capacitor c=3.8451e-17
    c3121 (\8\:Y \102\:S) capacitor c=1.27707e-15
    c3122 (\53\:D1 \143\:S) capacitor c=2.88893e-16
    c3123 (\173\:GNDA \168\:GNDA) capacitor c=9.29257e-17
    c3124 (\221\:S \776\:VDDA) capacitor c=3.90385e-16
    c3125 (\44\:U \187\:GNDA) capacitor c=3.54052e-16
    c3126 (\59\:BG_REF \347\:VDDA) capacitor c=1.2524e-17
    c3127 (\621\:VDDA \71\:S2) capacitor c=1.0092e-16
    c3128 (\2\:net33 \63\:GNDA) capacitor c=2.42792e-16
    c3129 (\16\:U \704\:GNDA) capacitor c=1.42235e-16
    c3130 (\134\:GNDA \1251\:GNDA) capacitor c=7.31883e-16
    c3131 (\446\:VDDA \279\:VDDA) capacitor c=3.30986e-16
    c3132 (\56\:U \818\:GNDA) capacitor c=4.6967e-17
    c3133 (\208\:S \69\:S2) capacitor c=1.31551e-16
    c3134 (\315\:VDDA \73\:BG_REF) capacitor c=2.84294e-16
    c3135 (\223\:VDDA \48\:BG_REF) capacitor c=5.28406e-16
    c3136 (\73\:S2 \534\:VDDA) capacitor c=4.5184e-17
    c3137 (\41\:S \354\:VDDA) capacitor c=1.85729e-17
    c3138 (\35\:D1 \33\:D1) capacitor c=5.43125e-16
    c3139 (\25\:GNDA \218\:GNDA) capacitor c=4.86952e-15
    c3140 (\207\:GNDA \1314\:GNDA) capacitor c=1.26043e-17
    c3141 (\90\:S2 \44\:S2) capacitor c=7.24682e-17
    c3142 (\196\:S \52\:S) capacitor c=1.71871e-15
    c3143 (\4\:vv \44\:S2) capacitor c=1.19085e-15
    c3144 (\534\:GNDA \203\:GNDA) capacitor c=8.58934e-16
    c3145 (\2\:net8 \109\:GNDA) capacitor c=4.77214e-16
    c3146 (\260\:VDDA \28\:S) capacitor c=5.28947e-16
    c3147 (\511\:VDDA \117\:BG_REF) capacitor c=2.22142e-16
    c3148 (\20\:BG_REF \3\:BG_REF) capacitor c=2.53145e-16
    c3149 (\245\:S \102\:S) capacitor c=5.46364e-16
    c3150 (\9\:S2 \279\:VDDA) capacitor c=2.98013e-15
    c3151 (\22\:Vo1 \53\:S) capacitor c=1.71131e-15
    c3152 (\594\:VDDA \1251\:GNDA) capacitor c=6.89282e-14
    c3153 (\31\:D2 \12\:S2) capacitor c=1.30661e-16
    c3154 (\27\:vv \31\:D2) capacitor c=2.48733e-16
    c3155 (\22\:S \279\:VDDA) capacitor c=1.67328e-16
    c3156 (\2\:net1 \218\:GNDA) capacitor c=3.98218e-16
    c3157 (\117\:GNDA \1251\:GNDA) capacitor c=1.16097e-17
    c3158 (\117\:U \935\:GNDA) capacitor c=2.63534e-16
    c3159 (\29\:X \1251\:GNDA) capacitor c=1.75685e-16
    c3160 (\88\:VDDA \279\:VDDA) capacitor c=3.86108e-16
    c3161 (\317\:VDDA \178\:Vm1) capacitor c=4.62641e-16
    c3162 (\15\:Vs \62\:S2) capacitor c=3.08464e-16
    c3163 (\126\:GNDA \130\:GNDA) capacitor c=1.08958e-17
    c3164 (\715\:GNDA \535\:GNDA) capacitor c=3.75202e-16
    c3165 (\54\:U \1166\:GNDA) capacitor c=4.09597e-16
    c3166 (\462\:VDDA \279\:VDDA) capacitor c=3.86901e-16
    c3167 (\35\:U \165\:GNDA) capacitor c=4.6967e-17
    c3168 (\37\:S2 \44\:S2) capacitor c=2.89412e-16
    c3169 (\28\:X \2\:U) capacitor c=3.76588e-17
    c3170 (\661\:VDDA \426\:VDDA) capacitor c=2.37098e-15
    c3171 (\47\:D1 \58\:Vo1) capacitor c=2.54597e-15
    c3172 (\1250\:GNDA \1265\:GNDA) capacitor c=1.62672e-16
    c3173 (\72\:U \1259\:GNDA) capacitor c=6.78232e-17
    c3174 (\85\:GNDA \218\:GNDA) capacitor c=1.68178e-14
    c3175 (\19\:Vo1 \1251\:GNDA) capacitor c=1.0163e-15
    c3176 (\142\:Vm1 \34\:Vm1) capacitor c=8.79087e-16
    c3177 (\19\:Y \539\:GNDA) capacitor c=6.34246e-16
    c3178 (\239\:S \27\:VDDA) capacitor c=1.34744e-17
    c3179 (\114\:Vm1 \142\:VDDA) capacitor c=4.73118e-16
    c3180 (\17\:D1 \25\:Vo1) capacitor c=7.77351e-16
    c3181 (\220\:Vm1 \464\:VDDA) capacitor c=3.537e-16
    c3182 (\162\:Vm1 \279\:VDDA) capacitor c=4.26576e-16
    c3183 (\7\:U \1373\:GNDA) capacitor c=3.54052e-16
    c3184 (\18\:Vo1 \1251\:GNDA) capacitor c=1.35669e-16
    c3185 (\187\:GNDA \1251\:GNDA) capacitor c=3.81427e-17
    c3186 (\200\:VDDA \205\:VDDA) capacitor c=4.75166e-16
    c3187 (\164\:VDDA \42\:BG_REF) capacitor c=3.8451e-17
    c3188 (\203\:GNDA \1452\:GNDA) capacitor c=1.04797e-16
    c3189 (\28\:U \1251\:GNDA) capacitor c=1.17427e-15
    c3190 (\668\:VDDA \88\:BG_REF) capacitor c=9.31771e-16
    c3191 (\39\:U \175\:GNDA) capacitor c=4.6967e-17
    c3192 (\144\:GNDA \18\:D2) capacitor c=4.01576e-16
    c3193 (\1545\:GNDA \21\:Vs) capacitor c=2.70454e-15
    c3194 (\11\:S2 \18\:S2) capacitor c=4.65271e-17
    c3195 (\84\:U \1274\:GNDA) capacitor c=1.98382e-16
    c3196 (\203\:GNDA \461\:GNDA) capacitor c=4.34068e-15
    c3197 (\670\:GNDA \521\:GNDA) capacitor c=4.58933e-16
    c3198 (\534\:VDDA \279\:VDDA) capacitor c=5.50722e-15
    c3199 (\102\:VDDA \279\:VDDA) capacitor c=2.49099e-16
    c3200 (\938\:GNDA \935\:GNDA) capacitor c=7.86382e-17
    c3201 (\118\:Vm1 \96\:VDDA) capacitor c=3.22227e-16
    c3202 (\236\:S \27\:vv) capacitor c=5.14201e-16
    c3203 (\482\:VDDA \279\:VDDA) capacitor c=2.65004e-16
    c3204 (\110\:S2 \14\:S2) capacitor c=3.12442e-17
    c3205 (\218\:Vm1 \106\:Vm1) capacitor c=8.8327e-16
    c3206 (\287\:Vm1 \90\:BG_REF) capacitor c=1.86105e-15
    c3207 (\1345\:GNDA \1415\:GNDA) capacitor c=3.1803e-16
    c3208 (\104\:U \1297\:GNDA) capacitor c=1.54869e-17
    c3209 (\199\:VDDA \46\:BG_REF) capacitor c=3.8451e-17
    c3210 (\2\:net6 \46\:GNDA) capacitor c=1.22342e-15
    c3211 (\45\:U \1394\:GNDA) capacitor c=2.73391e-17
    c3212 (\25\:vv \534\:VDDA) capacitor c=2.12163e-16
    c3213 (\11\:U \1251\:GNDA) capacitor c=7.1556e-17
    c3214 (\651\:VDDA \531\:VDDA) capacitor c=2.29206e-16
    c3215 (\203\:GNDA \95\:U) capacitor c=1.064e-15
    c3216 (\51\:U \1251\:GNDA) capacitor c=1.17427e-15
    c3217 (\81\:S \21\:D1) capacitor c=3.34161e-16
    c3218 (\104\:U \373\:GNDA) capacitor c=1.98382e-16
    c3219 (\205\:GNDA \1187\:GNDA) capacitor c=2.81201e-15
    c3220 (\28\:X \1136\:GNDA) capacitor c=7.15196e-17
    c3221 (\280\:VDDA \279\:VDDA) capacitor c=5.15504e-16
    c3222 (\2\:net10 \109\:GNDA) capacitor c=7.15848e-16
    c3223 (\31\:D2 \80\:S2) capacitor c=8.78267e-17
    c3224 (\236\:S \76\:S2) capacitor c=1.31551e-16
    c3225 (\904\:VDDA \240\:S) capacitor c=2.09897e-15
    c3226 (\303\:VDDA \58\:BG_REF) capacitor c=5.29488e-16
    c3227 (\192\:GNDA \1018\:GNDA) capacitor c=3.16819e-17
    c3228 (\14\:U \218\:GNDA) capacitor c=1.58679e-15
    c3229 (\90\:U \1362\:GNDA) capacitor c=8.15149e-16
    c3230 (\134\:Vm1 \224\:VDDA) capacitor c=3.384e-16
    c3231 (\1018\:GNDA \1099\:GNDA) capacitor c=3.16982e-16
    c3232 (\28\:S \279\:VDDA) capacitor c=1.67313e-16
    c3233 (\17\:U \794\:GNDA) capacitor c=6.78232e-17
    c3234 (\34\:Vo1 \102\:S) capacitor c=8.6967e-16
    c3235 (\845\:GNDA \535\:GNDA) capacitor c=1.97116e-16
    c3236 (\69\:Vo1 \102\:S) capacitor c=4.92141e-16
    c3237 (\1033\:GNDA \1054\:GNDA) capacitor c=1.62672e-16
    c3238 (\158\:GNDA \154\:GNDA) capacitor c=9.29257e-17
    c3239 (\202\:S \163\:S) capacitor c=5.56847e-16
    c3240 (\130\:VDDA \279\:VDDA) capacitor c=3.71677e-16
    c3241 (\137\:GNDA \1251\:GNDA) capacitor c=1.06448e-17
    c3242 (\1300\:GNDA \1251\:GNDA) capacitor c=4.19575e-17
    c3243 (\6\:Vs \140\:GNDA) capacitor c=8.99363e-17
    c3244 (\499\:VDDA \279\:VDDA) capacitor c=2.75667e-16
    c3245 (\71\:U \1251\:GNDA) capacitor c=9.04052e-16
    c3246 (\205\:GNDA \60\:U) capacitor c=3.38399e-16
    c3247 (\593\:GNDA \70\:GNDA) capacitor c=3.55194e-17
    c3248 (\18\:U \24\:U) capacitor c=1.32064e-15
    c3249 (\842\:GNDA \798\:GNDA) capacitor c=5.35597e-17
    c3250 (\918\:VDDA \204\:S) capacitor c=2.76565e-16
    c3251 (\21\:U \746\:GNDA) capacitor c=3.73689e-17
    c3252 (\205\:S \591\:VDDA) capacitor c=2.7036e-16
    c3253 (\850\:GNDA \905\:GNDA) capacitor c=4.18473e-17
    c3254 (\30\:S2 \8\:Vs) capacitor c=3.71181e-16
    c3255 (\58\:Vo1 \151\:S) capacitor c=7.53296e-16
    c3256 (\37\:Vo1 \103\:S) capacitor c=3.34161e-16
    c3257 (\748\:VDDA \25\:BG_REF) capacitor c=1.43076e-16
    c3258 (\29\:S2 \7\:Vs) capacitor c=5.88195e-16
    c3259 (\779\:VDDA \279\:VDDA) capacitor c=4.15166e-16
    c3260 (\800\:GNDA \753\:GNDA) capacitor c=4.6967e-17
    c3261 (\27\:U \850\:GNDA) capacitor c=8.02656e-16
    c3262 (\12\:D2 \4\:Vs) capacitor c=8.83021e-16
    c3263 (\294\:VDDA \279\:VDDA) capacitor c=4.01618e-16
    c3264 (\162\:GNDA \163\:GNDA) capacitor c=4.27087e-16
    c3265 (\16\:D2 \1251\:GNDA) capacitor c=8.7306e-16
    c3266 (\117\:BG_REF \236\:S) capacitor c=1.31405e-16
    c3267 (\28\:S2 \11\:D2) capacitor c=1.49612e-16
    c3268 (\117\:U \889\:GNDA) capacitor c=5.25256e-17
    c3269 (\604\:VDDA \534\:VDDA) capacitor c=4.74399e-15
    c3270 (\15\:Vs \9\:vv) capacitor c=5.01892e-17
    c3271 (\16\:U \207\:GNDA) capacitor c=1.092e-15
    c3272 (\304\:VDDA \57\:BG_REF) capacitor c=5.35451e-16
    c3273 (\671\:GNDA \1251\:GNDA) capacitor c=7.76174e-16
    c3274 (\204\:Vm1 \91\:Vm1) capacitor c=1.06438e-15
    c3275 (\90\:BG_REF \208\:S) capacitor c=1.31405e-16
    c3276 (\198\:Vm1 \399\:VDDA) capacitor c=3.4614e-16
    c3277 (\192\:GNDA \1159\:GNDA) capacitor c=1.33732e-17
    c3278 (\783\:GNDA \784\:GNDA) capacitor c=4.12292e-16
    c3279 (\54\:U \1159\:GNDA) capacitor c=9.14829e-17
    c3280 (\94\:U \1251\:GNDA) capacitor c=1.34811e-15
    c3281 (\57\:BG_REF \236\:S) capacitor c=6.30475e-16
    c3282 (\99\:U \890\:GNDA) capacitor c=1.09512e-16
    c3283 (\550\:VDDA \44\:S2) capacitor c=5.39005e-17
    c3284 (\195\:VDDA \39\:BG_REF) capacitor c=3.23767e-16
    c3285 (\152\:VDDA \279\:VDDA) capacitor c=2.75667e-16
    c3286 (\64\:U \1265\:GNDA) capacitor c=4.6967e-17
    c3287 (\29\:U \968\:GNDA) capacitor c=5.23333e-17
    c3288 (\391\:VDDA \79\:BG_REF) capacitor c=2.86633e-16
    c3289 (\207\:GNDA \738\:GNDA) capacitor c=4.10339e-15
    c3290 (\235\:S \75\:S2) capacitor c=3.01544e-15
    c3291 (\203\:GNDA \230\:GNDA) capacitor c=7.55152e-15
    c3292 (\34\:X \52\:GNDA) capacitor c=1.66405e-15
    c3293 (\207\:S \3\:VDDA) capacitor c=1.03845e-17
    c3294 (\49\:GNDA \218\:GNDA) capacitor c=7.79657e-15
    c3295 (\10\:U \1312\:GNDA) capacitor c=5.64553e-17
    c3296 (\2\:net38 \9\:GNDA) capacitor c=8.60487e-16
    c3297 (\896\:GNDA \1332\:GNDA) capacitor c=2.24575e-15
    c3298 (\411\:VDDA \271\:Vm1) capacitor c=2.18118e-16
    c3299 (\647\:VDDA \279\:VDDA) capacitor c=3.00785e-16
    c3300 (\13\:S \210\:VDDA) capacitor c=1.68039e-17
    c3301 (\146\:GNDA \1251\:GNDA) capacitor c=1.06763e-17
    c3302 (\488\:GNDA \168\:GNDA) capacitor c=5.35597e-17
    c3303 (\57\:Vo1 \684\:GNDA) capacitor c=4.57653e-16
    c3304 (\1166\:GNDA \1251\:GNDA) capacitor c=3.11265e-17
    c3305 (\33\:S \279\:VDDA) capacitor c=1.13005e-15
    c3306 (\19\:GNDA \18\:GNDA) capacitor c=3.23499e-16
    c3307 (\51\:Vo1 \1523\:GNDA) capacitor c=1.85597e-15
    c3308 (\89\:U \1486\:GNDA) capacitor c=4.6967e-17
    c3309 (\519\:VDDA \518\:VDDA) capacitor c=2.15475e-16
    c3310 (\34\:BG_REF \13\:VDDA) capacitor c=2.14804e-17
    c3311 (\32\:S \279\:VDDA) capacitor c=1.67297e-16
    c3312 (\203\:GNDA \390\:GNDA) capacitor c=2.07357e-16
    c3313 (\64\:VDDA \279\:VDDA) capacitor c=5.66413e-15
    c3314 (BIAS \594\:VDDA) capacitor c=5.98082e-17
    c3315 (\40\:Vo1 \149\:S) capacitor c=8.25465e-17
    c3316 (\207\:GNDA \1324\:GNDA) capacitor c=3.39687e-17
    c3317 (\35\:vv \539\:GNDA) capacitor c=7.31217e-17
    c3318 (\89\:BG_REF \417\:VDDA) capacitor c=1.9349e-16
    c3319 (\146\:VDDA \279\:VDDA) capacitor c=3.30359e-16
    c3320 (\978\:GNDA \975\:GNDA) capacitor c=7.86382e-17
    c3321 (\456\:VDDA \73\:BG_REF) capacitor c=2.34161e-16
    c3322 (\2\:Vo2 \1251\:GNDA) capacitor c=8.41833e-16
    c3323 (\503\:VDDA \279\:VDDA) capacitor c=3.77935e-16
    c3324 (\106\:VDDA \25\:BG_REF) capacitor c=3.86661e-16
    c3325 (\101\:BG_REF \67\:S2) capacitor c=4.62525e-16
    c3326 (\86\:U \1251\:GNDA) capacitor c=5.09198e-17
    c3327 (\2\:net9 \3\:net30) capacitor c=1.54434e-17
    c3328 (\57\:U \954\:GNDA) capacitor c=3.77148e-17
    c3329 (\1284\:GNDA \1226\:GNDA) capacitor c=9.29257e-17
    c3330 (\51\:U \784\:GNDA) capacitor c=1.63679e-16
    c3331 (\237\:Vm1 \279\:VDDA) capacitor c=1.14754e-15
    c3332 (\186\:Vm1 \348\:VDDA) capacitor c=4.68098e-16
    c3333 (\67\:S2 \73\:BG_REF) capacitor c=1.11867e-17
    c3334 (\487\:VDDA \71\:BG_REF) capacitor c=1.89197e-16
    c3335 (\176\:Vm1 \279\:VDDA) capacitor c=3.74426e-16
    c3336 (\134\:BG_REF \239\:S) capacitor c=6.49038e-15
    c3337 (\11\:VDDA \279\:VDDA) capacitor c=5.71111e-15
    c3338 (\61\:D1 \684\:GNDA) capacitor c=4.7145e-16
    c3339 (\173\:S \102\:S) capacitor c=3.30063e-16
    c3340 (\298\:VDDA \65\:BG_REF) capacitor c=3.26226e-16
    c3341 (\31\:X \1136\:GNDA) capacitor c=5.82324e-17
    c3342 (\145\:GNDA \1251\:GNDA) capacitor c=4.1623e-16
    c3343 (\158\:S \64\:Vo1) capacitor c=5.22142e-16
    c3344 (\93\:U \1012\:GNDA) capacitor c=6.78232e-17
    c3345 (\334\:VDDA \42\:S) capacitor c=5.28947e-16
    c3346 (\363\:GNDA \597\:GNDA) capacitor c=1.41173e-16
    c3347 (\550\:GNDA \1251\:GNDA) capacitor c=9.64883e-16
    c3348 (\26\:vv \229\:VDDA) capacitor c=3.31616e-17
    c3349 (\162\:VDDA \279\:VDDA) capacitor c=3.93795e-16
    c3350 (\905\:GNDA \1262\:GNDA) capacitor c=5.59821e-15
    c3351 (\184\:Vm1 \71\:Vm1) capacitor c=1.06919e-15
    c3352 (\539\:GNDA \15\:vv) capacitor c=1.04572e-16
    c3353 (\17\:S \73\:S2) capacitor c=2.59233e-15
    c3354 (\25\:BG_REF \21\:S) capacitor c=7.21395e-16
    c3355 (\16\:vv \536\:VDDA) capacitor c=5.88934e-16
    c3356 (\66\:S2 \89\:BG_REF) capacitor c=5.07061e-16
    c3357 (\15\:S \9\:S2) capacitor c=1.08058e-15
    c3358 (\77\:S \28\:Vo1) capacitor c=7.37265e-16
    c3359 (\29\:S \79\:BG_REF) capacitor c=3.01064e-16
    c3360 (\21\:vv \14\:S) capacitor c=3.40015e-17
    c3361 (\487\:VDDA \90\:BG_REF) capacitor c=1.98136e-16
    c3362 (\67\:BG_REF \41\:S) capacitor c=1.35527e-15
    c3363 (\31\:Vs \537\:GNDA) capacitor c=4.78189e-16
    c3364 (\154\:GNDA \203\:GNDA) capacitor c=1.21207e-16
    c3365 (\2\:net34 \100\:GNDA) capacitor c=1.35925e-15
    c3366 (\270\:Vm1 \577\:VDDA) capacitor c=8.08946e-16
    c3367 (\121\:BG_REF \102\:S2) capacitor c=4.62525e-16
    c3368 (\21\:vv \119\:VDDA) capacitor c=3.31616e-17
    c3369 (\41\:X \35\:X) capacitor c=1.3161e-16
    c3370 (\27\:Vs \898\:GNDA) capacitor c=2.1549e-16
    c3371 (\105\:BG_REF \279\:VDDA) capacitor c=9.52457e-16
    c3372 (\221\:S \534\:VDDA) capacitor c=4.5184e-17
    c3373 (\80\:S2 \44\:S2) capacitor c=3.73915e-16
    c3374 (\313\:VDDA \279\:VDDA) capacitor c=3.31309e-16
    c3375 (\1447\:GNDA \1466\:GNDA) capacitor c=4.29847e-16
    c3376 (\10\:BIAS \222\:Vm1) capacitor c=5.84515e-16
    c3377 (\49\:GNDA \1\:GNDA) capacitor c=4.44008e-17
    c3378 (\1034\:GNDA \1054\:GNDA) capacitor c=3.15482e-16
    c3379 (\7\:Vm1 \279\:VDDA) capacitor c=3.95631e-15
    c3380 (\506\:GNDA \1251\:GNDA) capacitor c=3.1724e-17
    c3381 (\343\:VDDA \426\:VDDA) capacitor c=3.85969e-16
    c3382 (\205\:GNDA \31\:U) capacitor c=1.13492e-15
    c3383 (\210\:Vm1 \56\:VDDA) capacitor c=2.90616e-16
    c3384 (\257\:VDDA \272\:Vm1) capacitor c=3.9399e-16
    c3385 (\20\:GNDA \218\:GNDA) capacitor c=4.80565e-17
    c3386 (\2\:net15 \2\:net2) capacitor c=2.38759e-17
    c3387 (\275\:Vm1 \535\:GNDA) capacitor c=5.73658e-17
    c3388 (\2\:net20 \218\:GNDA) capacitor c=3.908e-16
    c3389 (\1201\:GNDA \1218\:GNDA) capacitor c=3.14499e-16
    c3390 (\39\:BG_REF \279\:VDDA) capacitor c=1.43012e-15
    c3391 (\205\:GNDA \57\:U) capacitor c=6.66184e-17
    c3392 (\798\:GNDA \839\:GNDA) capacitor c=3.15482e-16
    c3393 (\31\:BG_REF \215\:VDDA) capacitor c=1.02632e-17
    c3394 (\895\:GNDA \1251\:GNDA) capacitor c=1.66164e-16
    c3395 (\24\:S2 \44\:S2) capacitor c=1.54797e-16
    c3396 (\1362\:GNDA \461\:GNDA) capacitor c=3.60084e-17
    c3397 (\1125\:GNDA \1122\:GNDA) capacitor c=8.23837e-17
    c3398 (\20\:D1 \75\:S) capacitor c=2.28667e-16
    c3399 (\996\:GNDA \627\:GNDA) capacitor c=3.72052e-17
    c3400 (\1214\:GNDA \1251\:GNDA) capacitor c=3.11265e-17
    c3401 (\217\:S \279\:VDDA) capacitor c=1.28081e-15
    c3402 (\56\:Vo1 \196\:S) capacitor c=1.29899e-15
    c3403 (\180\:Vm1 \67\:Vm1) capacitor c=1.07025e-15
    c3404 (\1152\:GNDA \1262\:GNDA) capacitor c=7.85446e-17
    c3405 (\671\:GNDA \670\:GNDA) capacitor c=6.41048e-17
    c3406 (\337\:VDDA \279\:VDDA) capacitor c=4.00809e-16
    c3407 (\16\:Vo1 \125\:GNDA) capacitor c=4.58871e-16
    c3408 (\23\:D1 \73\:S) capacitor c=7.39548e-17
    c3409 (\134\:Vm1 \26\:Vm1) capacitor c=8.78027e-16
    c3410 (\101\:U \425\:GNDA) capacitor c=4.10562e-17
    c3411 (\634\:GNDA \443\:GNDA) capacitor c=1.45875e-15
    c3412 (\959\:GNDA \928\:GNDA) capacitor c=4.83144e-17
    c3413 (\1005\:GNDA \1029\:GNDA) capacitor c=1.62672e-16
    c3414 (\17\:Vm1 \279\:VDDA) capacitor c=3.96062e-15
    c3415 (\31\:S \67\:S2) capacitor c=6.20026e-16
    c3416 (\29\:D1 \27\:D1) capacitor c=1.24248e-15
    c3417 (\259\:Vm1 \26\:vv) capacitor c=2.66552e-16
    c3418 (\372\:VDDA \47\:S) capacitor c=1.28412e-16
    c3419 (\70\:U \896\:GNDA) capacitor c=5.47526e-16
    c3420 (\196\:Vm1 \374\:VDDA) capacitor c=3.47479e-16
    c3421 (\110\:Vm1 \118\:VDDA) capacitor c=3.44578e-16
    c3422 (\61\:U \66\:U) capacitor c=1.69405e-17
    c3423 (\548\:VDDA \534\:VDDA) capacitor c=2.59805e-16
    c3424 (\62\:U \1251\:GNDA) capacitor c=1.5477e-15
    c3425 (\126\:Vm1 \279\:VDDA) capacitor c=3.70454e-16
    c3426 (\220\:Vm1 \107\:Vm1) capacitor c=1.83024e-16
    c3427 (\959\:GNDA \956\:GNDA) capacitor c=7.86382e-17
    c3428 (\102\:U \1251\:GNDA) capacitor c=7.1556e-17
    c3429 (\152\:VDDA \19\:VDDA) capacitor c=1.0554e-15
    c3430 (\898\:GNDA \212\:GNDA) capacitor c=2.02871e-16
    c3431 (\227\:S \63\:VDDA) capacitor c=1.03845e-17
    c3432 (\191\:VDDA \13\:S) capacitor c=1.2913e-16
    c3433 (\1362\:GNDA \1140\:GNDA) capacitor c=3.90975e-16
    c3434 (\88\:BG_REF \594\:VDDA) capacitor c=6.1755e-17
    c3435 (\85\:U \1355\:GNDA) capacitor c=1.3699e-16
    c3436 (\1273\:GNDA \1274\:GNDA) capacitor c=4.12292e-16
    c3437 (\905\:GNDA \1099\:GNDA) capacitor c=3.54397e-15
    c3438 (\69\:S2 \279\:VDDA) capacitor c=1.6326e-15
    c3439 (\896\:GNDA \1114\:GNDA) capacitor c=1.94745e-17
    c3440 (\242\:S \573\:VDDA) capacitor c=1.55716e-16
    c3441 (\2\:vv \15\:S2) capacitor c=5.16983e-17
    c3442 (\120\:Vm1 \114\:VDDA) capacitor c=4.39105e-16
    c3443 (\230\:GNDA \333\:GNDA) capacitor c=1.01006e-16
    c3444 (\397\:VDDA \271\:Vm1) capacitor c=3.9399e-16
    c3445 (\176\:Vm1 \63\:Vm1) capacitor c=1.07025e-15
    c3446 (\41\:S \279\:VDDA) capacitor c=1.56105e-15
    c3447 (\74\:S2 \534\:VDDA) capacitor c=7.83035e-17
    c3448 (\308\:VDDA \426\:VDDA) capacitor c=3.64985e-16
    c3449 (\52\:U \953\:GNDA) capacitor c=4.06727e-16
    c3450 (\27\:Vm1 \279\:VDDA) capacitor c=3.95899e-15
    c3451 (\4\:U \1251\:GNDA) capacitor c=1.02189e-15
    c3452 (\800\:GNDA \748\:GNDA) capacitor c=1.20227e-15
    c3453 (\57\:Vm1 \58\:Vm1) capacitor c=6.4674e-16
    c3454 (\65\:S2 \540\:VDDA) capacitor c=2.35215e-16
    c3455 (\2\:Y \4\:X) capacitor c=1.63806e-17
    c3456 (\29\:D1 \149\:S) capacitor c=4.84158e-17
    c3457 (\27\:BG_REF \141\:VDDA) capacitor c=1.23404e-17
    c3458 (\331\:VDDA \73\:BG_REF) capacitor c=3.26283e-16
    c3459 (\173\:VDDA \279\:VDDA) capacitor c=3.29821e-16
    c3460 (\241\:S \534\:VDDA) capacitor c=1.62356e-16
    c3461 (\207\:GNDA \6\:U) capacitor c=3.38399e-16
    c3462 (\1452\:GNDA \1500\:GNDA) capacitor c=3.71985e-17
    c3463 (\118\:U \390\:GNDA) capacitor c=2.87776e-15
    c3464 (\548\:VDDA \279\:VDDA) capacitor c=3.76463e-16
    c3465 (\35\:U \160\:GNDA) capacitor c=1.3611e-15
    c3466 (\46\:D1 \1251\:GNDA) capacitor c=1.10781e-15
    c3467 (\17\:vv \720\:VDDA) capacitor c=7.17442e-16
    c3468 (\4\:vv \14\:BG_REF) capacitor c=4.71861e-16
    c3469 (\619\:VDDA \19\:vv) capacitor c=9.83357e-16
    c3470 (\203\:GNDA \437\:GNDA) capacitor c=4.42179e-15
    c3471 (\325\:VDDA \37\:VDDA) capacitor c=1.04832e-15
    c3472 (\1362\:GNDA \1403\:GNDA) capacitor c=3.39571e-17
    c3473 (\331\:GNDA \332\:GNDA) capacitor c=6.3759e-17
    c3474 (\116\:U \648\:GNDA) capacitor c=1.0598e-16
    c3475 (\116\:BG_REF \24\:vv) capacitor c=5.24628e-16
    c3476 (\28\:X \1251\:GNDA) capacitor c=4.28823e-16
    c3477 (\1495\:GNDA \1472\:GNDA) capacitor c=3.67072e-17
    c3478 (\230\:GNDA \327\:GNDA) capacitor c=8.75955e-17
    c3479 (\89\:BG_REF \594\:VDDA) capacitor c=6.1755e-17
    c3480 (\16\:vv \279\:VDDA) capacitor c=5.09111e-15
    c3481 (\208\:Vm1 \95\:Vm1) capacitor c=1.82422e-16
    c3482 (\110\:VDDA \9\:VDDA) capacitor c=8.50684e-16
    c3483 (\19\:U \1029\:GNDA) capacitor c=1.3742e-17
    c3484 (\205\:GNDA \63\:U) capacitor c=6.66184e-17
    c3485 (\220\:Vm1 \448\:VDDA) capacitor c=4.6299e-16
    c3486 (\190\:Vm1 \279\:VDDA) capacitor c=3.7428e-16
    c3487 (\746\:GNDA \75\:U) capacitor c=3.72052e-17
    c3488 (\106\:U \1201\:GNDA) capacitor c=3.77148e-17
    c3489 (\7\:Vs \44\:S2) capacitor c=7.76836e-17
    c3490 (\203\:GNDA \431\:GNDA) capacitor c=2.42111e-15
    c3491 (\1535\:GNDA \544\:VDDA) capacitor c=2.81442e-17
    c3492 (\860\:VDDA \33\:BG_REF) capacitor c=1.43076e-16
    c3493 (\260\:Vm1 \102\:S2) capacitor c=5.23191e-16
    c3494 (\2\:BIAS \1\:BIAS) capacitor c=3.872e-16
    c3495 (\20\:vv \544\:VDDA) capacitor c=2.76306e-16
    c3496 (\241\:S \436\:VDDA) capacitor c=4.488e-15
    c3497 (\22\:U \798\:GNDA) capacitor c=4.10562e-17
    c3498 (\270\:Vm1 \279\:VDDA) capacitor c=1.05673e-15
    c3499 (\276\:Vm1 \67\:S2) capacitor c=5.23191e-16
    c3500 (\896\:GNDA \86\:U) capacitor c=6.66184e-17
    c3501 (\2\:net4 \218\:GNDA) capacitor c=7.48643e-16
    c3502 (\1532\:GNDA \1251\:GNDA) capacitor c=8.82555e-16
    c3503 (\203\:VDDA \279\:VDDA) capacitor c=3.48812e-16
    c3504 (\137\:BG_REF \904\:VDDA) capacitor c=5.34096e-16
    c3505 (\214\:Vm1 \491\:VDDA) capacitor c=2.88285e-16
    c3506 (\2\:net18 \53\:GNDA) capacitor c=7.51928e-16
    c3507 (\55\:S2 \279\:VDDA) capacitor c=1.89085e-17
    c3508 (\29\:U \1251\:GNDA) capacitor c=1.08975e-15
    c3509 (\71\:Vo1 \541\:GNDA) capacitor c=3.24746e-17
    c3510 (\70\:U \79\:U) capacitor c=1.69405e-17
    c3511 (\896\:GNDA \1472\:GNDA) capacitor c=4.26136e-15
    c3512 (\187\:GNDA \190\:GNDA) capacitor c=1.62672e-16
    c3513 (\1137\:GNDA \1251\:GNDA) capacitor c=3.11265e-17
    c3514 (\68\:S2 \21\:vv) capacitor c=1.22457e-16
    c3515 (\320\:GNDA \230\:GNDA) capacitor c=5.72337e-16
    c3516 (\10\:U \1309\:GNDA) capacitor c=1.26142e-15
    c3517 (\27\:U \192\:GNDA) capacitor c=1.65824e-15
    c3518 (\1125\:GNDA \1095\:GNDA) capacitor c=6.40312e-17
    c3519 (\249\:Vm1 \548\:VDDA) capacitor c=4.67428e-16
    c3520 (\91\:U \449\:GNDA) capacitor c=1.98382e-16
    c3521 (\249\:S \47\:D1) capacitor c=1.87899e-16
    c3522 (\183\:GNDA \64\:U) capacitor c=3.63621e-17
    c3523 (\348\:VDDA \279\:VDDA) capacitor c=3.30175e-16
    c3524 (\130\:GNDA \14\:D1) capacitor c=5.28186e-16
    c3525 (\217\:S \544\:VDDA) capacitor c=1.22928e-16
    c3526 (\29\:BG_REF \17\:S) capacitor c=4.21143e-16
    c3527 (\548\:VDDA \117\:BG_REF) capacitor c=4.32184e-16
    c3528 (\1515\:GNDA \1251\:GNDA) capacitor c=2.21937e-17
    c3529 (\93\:S \34\:Vo1) capacitor c=7.31484e-16
    c3530 (\207\:GNDA \23\:U) capacitor c=6.66184e-17
    c3531 (\149\:S \768\:GNDA) capacitor c=3.67648e-17
    c3532 (\59\:D1 \19\:Vo1) capacitor c=2.7156e-16
    c3533 (\47\:U \1167\:GNDA) capacitor c=3.83457e-17
    c3534 (\240\:S \555\:VDDA) capacitor c=7.30371e-16
    c3535 (\90\:U \1251\:GNDA) capacitor c=9.03346e-16
    c3536 (\34\:X \2\:net20) capacitor c=1.57454e-16
    c3537 (\120\:BG_REF \279\:VDDA) capacitor c=7.30306e-16
    c3538 (\18\:vv \519\:VDDA) capacitor c=2.14779e-17
    c3539 (\166\:VDDA \272\:Vm1) capacitor c=2.18118e-16
    c3540 (\971\:GNDA \968\:GNDA) capacitor c=7.86382e-17
    c3541 (\272\:Vm1 \77\:S2) capacitor c=3.25934e-16
    c3542 (\591\:GNDA \203\:GNDA) capacitor c=6.01809e-16
    c3543 (\28\:vv \860\:VDDA) capacitor c=7.17442e-16
    c3544 (\587\:VDDA \534\:VDDA) capacitor c=6.35016e-16
    c3545 (\536\:VDDA \88\:BG_REF) capacitor c=5.40782e-16
    c3546 (\29\:S \75\:S2) capacitor c=7.37279e-16
    c3547 (\614\:VDDA \534\:VDDA) capacitor c=1.46163e-15
    c3548 (\539\:GNDA \29\:GNDA) capacitor c=5.03758e-16
    c3549 (\205\:GNDA \1114\:GNDA) capacitor c=1.33732e-17
    c3550 (\192\:GNDA \1226\:GNDA) capacitor c=3.40431e-17
    c3551 (\689\:GNDA \684\:GNDA) capacitor c=2.62674e-16
    c3552 (\28\:S2 \4\:Vs) capacitor c=4.41524e-17
    c3553 (\11\:S \112\:VDDA) capacitor c=1.04579e-17
    c3554 (\21\:S2 \7\:D2) capacitor c=6.13835e-17
    c3555 (\105\:U \539\:GNDA) capacitor c=2.67095e-15
    c3556 (\59\:D1 \1251\:GNDA) capacitor c=1.00318e-15
    c3557 (\19\:Vs \32\:D2) capacitor c=2.44965e-15
    c3558 (\366\:VDDA \279\:VDDA) capacitor c=3.97675e-16
    c3559 (\134\:Vm1 \208\:VDDA) capacitor c=4.78423e-16
    c3560 (\73\:BG_REF \440\:VDDA) capacitor c=3.13598e-16
    c3561 (\105\:S2 \86\:S2) capacitor c=1.23987e-16
    c3562 (\81\:U \1256\:GNDA) capacitor c=4.6967e-17
    c3563 (\251\:S \64\:Vo1) capacitor c=4.82998e-16
    c3564 (\192\:GNDA \165\:GNDA) capacitor c=2.24479e-15
    c3565 (\61\:Vm1 \279\:VDDA) capacitor c=3.95881e-15
    c3566 (\40\:U \1251\:GNDA) capacitor c=7.1556e-17
    c3567 (\1513\:GNDA \59\:D1) capacitor c=9.50997e-16
    c3568 (\28\:S2 \3\:Vs) capacitor c=2.67152e-16
    c3569 (\90\:BG_REF \55\:VDDA) capacitor c=1.33555e-17
    c3570 (\53\:GNDA \2\:net36) capacitor c=2.79163e-16
    c3571 (\117\:U \443\:GNDA) capacitor c=1.47018e-16
    c3572 (\24\:Vs \25\:D2) capacitor c=2.90844e-15
    c3573 (\46\:Vo1 \684\:GNDA) capacitor c=2.67807e-16
    c3574 (\20\:D1 \149\:S) capacitor c=5.91583e-16
    c3575 (\10\:D2 \535\:GNDA) capacitor c=4.06848e-16
    c3576 (\235\:S \279\:VDDA) capacitor c=9.65029e-16
    c3577 (\850\:GNDA \230\:GNDA) capacitor c=5.54167e-16
    c3578 (\8\:Vs \26\:S2) capacitor c=3.03206e-17
    c3579 (\1236\:GNDA \1215\:GNDA) capacitor c=5.35597e-17
    c3580 (\73\:BG_REF \208\:S) capacitor c=1.80203e-16
    c3581 (\537\:VDDA \521\:GNDA) capacitor c=1.71069e-17
    c3582 (\245\:S \148\:S) capacitor c=6.59851e-15
    c3583 (\664\:GNDA \193\:GNDA) capacitor c=1.60646e-16
    c3584 (\686\:GNDA \550\:GNDA) capacitor c=2.34421e-16
    c3585 (\55\:Vo1 \1251\:GNDA) capacitor c=8.69455e-16
    c3586 (\1201\:GNDA \1096\:GNDA) capacitor c=9.29257e-17
    c3587 (\378\:GNDA \603\:GNDA) capacitor c=5.4561e-15
    c3588 (\1140\:GNDA \1117\:GNDA) capacitor c=1.17757e-15
    c3589 (\287\:Vm1 \18\:vv) capacitor c=2.07774e-17
    c3590 (\17\:S2 \12\:D2) capacitor c=2.23925e-16
    c3591 (\768\:GNDA \2\:Vo1) capacitor c=4.43959e-17
    c3592 (\238\:S \499\:VDDA) capacitor c=1.23137e-17
    c3593 (\245\:S \140\:S) capacitor c=2.43511e-16
    c3594 (\80\:U \1172\:GNDA) capacitor c=8.39862e-17
    c3595 (\287\:Vm1 \668\:VDDA) capacitor c=9.80995e-16
    c3596 (\192\:GNDA \1324\:GNDA) capacitor c=3.31844e-17
    c3597 (\26\:D1 \24\:D1) capacitor c=1.24352e-15
    c3598 (\1136\:GNDA \1251\:GNDA) capacitor c=4.19575e-17
    c3599 (\944\:GNDA \684\:GNDA) capacitor c=1.07393e-15
    c3600 (\69\:S2 \20\:vv) capacitor c=4.32352e-15
    c3601 (\1259\:GNDA \1237\:GNDA) capacitor c=6.40312e-17
    c3602 (\77\:S2 \901\:VDDA) capacitor c=2.98223e-16
    c3603 (\45\:S \279\:VDDA) capacitor c=1.38294e-15
    c3604 (\702\:GNDA \1251\:GNDA) capacitor c=9.18724e-16
    c3605 (\12\:vv \27\:S2) capacitor c=1.03727e-17
    c3606 (\487\:VDDA \55\:VDDA) capacitor c=1.86343e-16
    c3607 (\41\:VDDA \279\:VDDA) capacitor c=4.13872e-15
    c3608 (\100\:BG_REF \534\:VDDA) capacitor c=5.94935e-17
    c3609 (\73\:S2 \39\:BG_REF) capacitor c=1.11867e-17
    c3610 (\19\:vv \293\:VDDA) capacitor c=3.31616e-17
    c3611 (\28\:Vo1 \75\:S) capacitor c=1.65953e-15
    c3612 (\46\:Vo1 \56\:Vo1) capacitor c=1.06706e-17
    c3613 (\73\:S2 \279\:VDDA) capacitor c=2.93452e-15
    c3614 (\2\:net9 \66\:GNDA) capacitor c=5.29563e-16
    c3615 (\10\:Vs \2\:Vs) capacitor c=4.58983e-16
    c3616 (\25\:S \251\:VDDA) capacitor c=1.88243e-17
    c3617 (\300\:VDDA \34\:S) capacitor c=1.21882e-16
    c3618 (\109\:U \1300\:GNDA) capacitor c=5.82324e-17
    c3619 (\19\:S \216\:VDDA) capacitor c=1.68039e-17
    c3620 (\51\:BG_REF \206\:S) capacitor c=7.56755e-17
    c3621 (\208\:VDDA \279\:VDDA) capacitor c=3.28871e-16
    c3622 (\17\:U \207\:GNDA) capacitor c=8.49116e-16
    c3623 (\136\:BG_REF \23\:D2) capacitor c=1.91e-16
    c3624 (\2\:net7 \114\:GNDA) capacitor c=5.28429e-16
    c3625 (\99\:U \1009\:GNDA) capacitor c=4.6967e-17
    c3626 (\106\:GNDA \2\:net7) capacitor c=1.85658e-16
    c3627 (\21\:D2 \1543\:GNDA) capacitor c=7.01388e-16
    c3628 (\629\:VDDA \34\:vv) capacitor c=1.03416e-15
    c3629 (\112\:Vm1 \90\:VDDA) capacitor c=3.22227e-16
    c3630 (\995\:GNDA \1251\:GNDA) capacitor c=3.11265e-17
    c3631 (\11\:D2 \13\:BG_REF) capacitor c=1.14229e-16
    c3632 (\13\:S2 \22\:S2) capacitor c=7.30924e-17
    c3633 (\12\:Y \14\:X) capacitor c=1.58085e-17
    c3634 (\207\:GNDA \798\:GNDA) capacitor c=1.33732e-17
    c3635 (\116\:U \455\:GNDA) capacitor c=1.14904e-17
    c3636 (\904\:VDDA \900\:VDDA) capacitor c=1.69924e-15
    c3637 (\32\:BG_REF \279\:VDDA) capacitor c=1.15121e-16
    c3638 (\620\:GNDA \431\:GNDA) capacitor c=4.6967e-17
    c3639 (\19\:vv \52\:BG_REF) capacitor c=3.40015e-17
    c3640 (\197\:VDDA \19\:S) capacitor c=1.2913e-16
    c3641 (\87\:U \1314\:GNDA) capacitor c=1.08835e-16
    c3642 (\43\:Vo1 \41\:Vo1) capacitor c=1.23765e-15
    c3643 (\6\:Vs \10\:D2) capacitor c=7.94406e-16
    c3644 (\249\:Vm1 \27\:vv) capacitor c=3.1613e-16
    c3645 (\24\:vv \38\:BG_REF) capacitor c=3.40015e-17
    c3646 (\905\:GNDA \1345\:GNDA) capacitor c=4.77291e-15
    c3647 (\86\:S2 \38\:S2) capacitor c=6.10449e-17
    c3648 (\202\:Vm1 \279\:VDDA) capacitor c=3.71744e-16
    c3649 (\242\:S \910\:VDDA) capacitor c=2.24321e-15
    c3650 (\28\:GNDA \218\:GNDA) capacitor c=1.27692e-14
    c3651 (\2\:net12 \46\:GNDA) capacitor c=7.68272e-16
    c3652 (\25\:Vo1 \82\:S) capacitor c=1.12529e-16
    c3653 (\34\:Vo1 \101\:S) capacitor c=2.85713e-16
    c3654 (\100\:GNDA \230\:GNDA) capacitor c=2.42217e-17
    c3655 (\1259\:GNDA \1256\:GNDA) capacitor c=8.23837e-17
    c3656 (\29\:D1 \37\:Vo1) capacitor c=5.31736e-16
    c3657 (\482\:GNDA \165\:GNDA) capacitor c=7.86382e-17
    c3658 (\635\:VDDA \138\:BG_REF) capacitor c=7.27997e-16
    c3659 (\19\:vv \279\:VDDA) capacitor c=5.41734e-15
    c3660 (\1362\:GNDA \1122\:GNDA) capacitor c=2.31665e-15
    c3661 (\794\:GNDA \746\:GNDA) capacitor c=5.35597e-17
    c3662 (\905\:GNDA \173\:GNDA) capacitor c=2.29398e-16
    c3663 (\404\:VDDA \78\:BG_REF) capacitor c=5.28406e-16
    c3664 (\104\:BG_REF \216\:S) capacitor c=2.56266e-15
    c3665 (\146\:Vm1 \279\:VDDA) capacitor c=2.28752e-16
    c3666 (\2\:net21 \218\:GNDA) capacitor c=7.13921e-16
    c3667 (\22\:Vo1 \67\:S) capacitor c=2.29306e-16
    c3668 (\69\:U \896\:GNDA) capacitor c=6.43882e-16
    c3669 (\55\:U \784\:GNDA) capacitor c=3.73689e-17
    c3670 (\57\:VDDA \58\:VDDA) capacitor c=6.69821e-16
    c3671 (\88\:S2 \44\:S2) capacitor c=3.60752e-16
    c3672 (\436\:VDDA \900\:VDDA) capacitor c=4.01577e-15
    c3673 (\205\:S \417\:VDDA) capacitor c=9.64128e-17
    c3674 (\19\:D2 \535\:GNDA) capacitor c=3.06344e-16
    c3675 (\94\:U \1096\:GNDA) capacitor c=1.63679e-16
    c3676 (\10\:Y \102\:S) capacitor c=2.11348e-15
    c3677 (\1555\:GNDA \895\:GNDA) capacitor c=2.8851e-16
    c3678 (\426\:VDDA \203\:VDDA) capacitor c=3.86559e-16
    c3679 (\28\:U \160\:GNDA) capacitor c=1.54869e-17
    c3680 (\109\:U \1297\:GNDA) capacitor c=1.3611e-15
    c3681 (\1236\:GNDA \1214\:GNDA) capacitor c=6.40312e-17
    c3682 (\896\:GNDA \83\:U) capacitor c=3.38399e-16
    c3683 (\286\:Vm1 \585\:VDDA) capacitor c=8.31681e-16
    c3684 (\226\:S \581\:VDDA) capacitor c=1.51908e-16
    c3685 (\718\:GNDA \1251\:GNDA) capacitor c=1.7177e-15
    c3686 (\134\:BG_REF \19\:VDDA) capacitor c=1.03845e-17
    c3687 (\34\:X \17\:X) capacitor c=8.06947e-16
    c3688 (\383\:VDDA \279\:VDDA) capacitor c=3.31143e-16
    c3689 (\89\:GNDA \218\:GNDA) capacitor c=2.03748e-15
    c3690 (\118\:U \1200\:GNDA) capacitor c=6.93679e-17
    c3691 (\216\:Vm1 \460\:VDDA) capacitor c=3.537e-16
    c3692 (\49\:VDDA \279\:VDDA) capacitor c=4.32826e-15
    c3693 (\1532\:GNDA \120\:GNDA) capacitor c=3.03152e-16
    c3694 (\1105\:GNDA \968\:GNDA) capacitor c=4.6967e-17
    c3695 (\1300\:GNDA \1273\:GNDA) capacitor c=6.40312e-17
    c3696 (\157\:GNDA \158\:GNDA) capacitor c=4.12292e-16
    c3697 (\16\:U \702\:GNDA) capacitor c=8.4654e-16
    c3698 (\217\:S \534\:VDDA) capacitor c=4.93172e-17
    c3699 (\112\:S2 \24\:Vs) capacitor c=1.84719e-17
    c3700 (\776\:VDDA \279\:VDDA) capacitor c=4.20551e-16
    c3701 (\405\:VDDA \77\:BG_REF) capacitor c=5.37491e-16
    c3702 (\68\:U \839\:GNDA) capacitor c=1.54869e-17
    c3703 (\9\:vv \38\:S2) capacitor c=1.39793e-17
    c3704 (\50\:S2 \44\:S2) capacitor c=6.58874e-16
    c3705 (\52\:U \1024\:GNDA) capacitor c=7.58317e-17
    c3706 (\29\:D1 \7\:X) capacitor c=2.24251e-17
    c3707 (\1006\:GNDA \928\:GNDA) capacitor c=9.29257e-17
    c3708 (\38\:BG_REF \279\:VDDA) capacitor c=1.15424e-16
    c3709 (\203\:GNDA \1251\:GNDA) capacitor c=4.70589e-14
    c3710 (\150\:Vm1 \261\:VDDA) capacitor c=3.46264e-16
    c3711 (\35\:X \71\:U) capacitor c=1.75488e-16
    c3712 (\1302\:GNDA \1320\:GNDA) capacitor c=4.29733e-16
    c3713 (\1293\:GNDA \1294\:GNDA) capacitor c=4.05613e-16
    c3714 (\38\:D1 \102\:S) capacitor c=1.12202e-15
    c3715 (\2\:net9 \2\:net26) capacitor c=4.04113e-17
    c3716 (\1057\:GNDA \1251\:GNDA) capacitor c=4.19575e-17
    c3717 (\88\:S2 \22\:Vs) capacitor c=7.23814e-17
    c3718 (\282\:VDDA \164\:Vm1) capacitor c=4.68211e-16
    c3719 (\815\:GNDA \230\:GNDA) capacitor c=5.04939e-16
    c3720 (\71\:BG_REF \55\:VDDA) capacitor c=1.33555e-17
    c3721 (\205\:GNDA \776\:GNDA) capacitor c=4.10563e-15
    c3722 (\136\:BG_REF \50\:S2) capacitor c=2.81441e-16
    c3723 (\704\:GNDA \800\:GNDA) capacitor c=3.72052e-17
    c3724 (\43\:GNDA \2\:net26) capacitor c=7.42788e-17
    c3725 (\12\:vv \23\:S2) capacitor c=2.85522e-17
    c3726 (\403\:VDDA \279\:VDDA) capacitor c=3.96231e-16
    c3727 (\17\:D1 \102\:S) capacitor c=8.75053e-16
    c3728 (\135\:BG_REF \539\:GNDA) capacitor c=2.75567e-15
    c3729 (\207\:GNDA \5\:U) capacitor c=7.93593e-17
    c3730 (\19\:vv \534\:VDDA) capacitor c=4.51962e-17
    c3731 (\59\:VDDA \279\:VDDA) capacitor c=5.71423e-15
    c3732 (\53\:BG_REF \287\:VDDA) capacitor c=1.36071e-17
    c3733 (\883\:GNDA \659\:GNDA) capacitor c=3.36541e-17
    c3734 (\8\:U \1486\:GNDA) capacitor c=2.70782e-17
    c3735 (\74\:S2 \79\:BG_REF) capacitor c=1.11867e-17
    c3736 (\67\:BG_REF \318\:VDDA) capacitor c=1.23247e-17
    c3737 (\205\:S \604\:VDDA) capacitor c=4.33279e-16
    c3738 (\627\:VDDA \279\:VDDA) capacitor c=3.00922e-16
    c3739 (\117\:U \938\:GNDA) capacitor c=1.31131e-16
    c3740 (\1049\:GNDA \31\:X) capacitor c=3.72052e-17
    c3741 (\87\:BG_REF \12\:vv) capacitor c=9.4657e-16
    c3742 (\192\:GNDA \180\:GNDA) capacitor c=2.31665e-15
    c3743 (\1324\:GNDA \1251\:GNDA) capacitor c=9.29257e-17
    c3744 (\253\:VDDA \279\:VDDA) capacitor c=3.30364e-16
    c3745 (\371\:VDDA \48\:S) capacitor c=5.28947e-16
    c3746 (\499\:VDDA \271\:Vm1) capacitor c=3.9399e-16
    c3747 (\2\:net24 \218\:GNDA) capacitor c=3.74141e-16
    c3748 (\27\:U \594\:VDDA) capacitor c=1.3559e-16
    c3749 (\131\:BG_REF \103\:S2) capacitor c=4.62525e-16
    c3750 (\82\:S2 \18\:Vs) capacitor c=5.17427e-16
    c3751 (\60\:U \1114\:GNDA) capacitor c=4.10562e-17
    c3752 (\539\:GNDA \218\:GNDA) capacitor c=1.37904e-14
    c3753 (\102\:VDDA \665\:VDDA) capacitor c=3.22308e-16
    c3754 (\54\:U \63\:U) capacitor c=1.12841e-16
    c3755 (\34\:S2 \31\:S2) capacitor c=5.67367e-16
    c3756 (\1215\:GNDA \1114\:GNDA) capacitor c=9.29257e-17
    c3757 (\905\:GNDA \170\:GNDA) capacitor c=1.2703e-17
    c3758 (\7\:Vs \4\:vv) capacitor c=1.07978e-17
    c3759 (\101\:S \32\:D1) capacitor c=3.72808e-16
    c3760 (\67\:U \657\:GNDA) capacitor c=1.06939e-15
    c3761 (\583\:VDDA \279\:VDDA) capacitor c=3.30453e-16
    c3762 (\26\:vv \19\:S) capacitor c=1.3147e-17
    c3763 (\45\:S \385\:VDDA) capacitor c=1.88243e-17
    c3764 (\77\:BG_REF \279\:VDDA) capacitor c=1.00128e-15
    c3765 (\31\:BG_REF \250\:VDDA) capacitor c=1.23247e-17
    c3766 (\593\:GNDA \49\:GNDA) capacitor c=2.87014e-17
    c3767 (\162\:GNDA \1251\:GNDA) capacitor c=3.11265e-17
    c3768 (\542\:VDDA \535\:GNDA) capacitor c=1.35282e-17
    c3769 (\24\:Vs \87\:BG_REF) capacitor c=5.05997e-16
    c3770 (\203\:GNDA \413\:GNDA) capacitor c=4.37155e-15
    c3771 (\14\:U \115\:GNDA) capacitor c=6.27077e-17
    c3772 (\167\:GNDA \170\:GNDA) capacitor c=1.62672e-16
    c3773 (\896\:GNDA \20\:U) capacitor c=2.91461e-16
    c3774 (\591\:GNDA \218\:GNDA) capacitor c=1.15343e-15
    c3775 (\2\:net16 \51\:GNDA) capacitor c=9.85041e-17
    c3776 (\1159\:GNDA \1187\:GNDA) capacitor c=2.98799e-16
    c3777 (\80\:S2 \12\:BG_REF) capacitor c=5.41872e-17
    c3778 (\35\:X \620\:GNDA) capacitor c=1.57768e-15
    c3779 (\374\:VDDA \70\:BG_REF) capacitor c=3.8451e-17
    c3780 (\222\:VDDA \27\:VDDA) capacitor c=1.0554e-15
    c3781 (\229\:VDDA \145\:Vm1) capacitor c=4.74597e-16
    c3782 (\38\:D1 \126\:S) capacitor c=1.05935e-16
    c3783 (\87\:U \1256\:GNDA) capacitor c=4.6967e-17
    c3784 (\203\:GNDA \379\:GNDA) capacitor c=2.41352e-15
    c3785 (\118\:U \1362\:GNDA) capacitor c=1.08529e-16
    c3786 (\35\:U \870\:GNDA) capacitor c=4.68028e-17
    c3787 (\44\:BG_REF \279\:VDDA) capacitor c=1.15424e-16
    c3788 (\2\:net1 \109\:GNDA) capacitor c=2.65382e-15
    c3789 (\76\:S2 \33\:vv) capacitor c=6.33575e-15
    c3790 (\148\:S \147\:S) capacitor c=1.86451e-15
    c3791 (\38\:Vm1 \279\:VDDA) capacitor c=3.92626e-15
    c3792 (\573\:VDDA \534\:VDDA) capacitor c=3.95331e-16
    c3793 (\163\:GNDA \58\:U) capacitor c=3.59294e-17
    c3794 (\117\:U \637\:GNDA) capacitor c=3.67511e-17
    c3795 (\101\:S \102\:S) capacitor c=6.70118e-16
    c3796 (\27\:U \870\:GNDA) capacitor c=5.76145e-17
    c3797 (\413\:GNDA \425\:GNDA) capacitor c=9.29257e-17
    c3798 (\23\:U \1251\:GNDA) capacitor c=5.06676e-17
    c3799 (\36\:U \163\:GNDA) capacitor c=3.77148e-17
    c3800 (\214\:Vm1 \279\:VDDA) capacitor c=4.52787e-16
    c3801 (\39\:U \170\:GNDA) capacitor c=1.3611e-15
    c3802 (\37\:U \954\:GNDA) capacitor c=3.88004e-17
    c3803 (\51\:GNDA \218\:GNDA) capacitor c=7.38433e-15
    c3804 (\230\:GNDA \7\:BG_REF) capacitor c=2.44295e-17
    c3805 (\32\:D2 \534\:VDDA) capacitor c=8.42157e-17
    c3806 (\330\:GNDA \218\:GNDA) capacitor c=2.86206e-16
    c3807 (\207\:GNDA \1024\:GNDA) capacitor c=3.39571e-17
    c3808 (\226\:S \110\:VDDA) capacitor c=2.04887e-17
    c3809 (\30\:X \1133\:GNDA) capacitor c=8.85297e-17
    c3810 (\205\:GNDA \1167\:GNDA) capacitor c=3.74308e-15
    c3811 (\91\:U \659\:GNDA) capacitor c=5.64952e-17
    c3812 (\48\:Vo1 \686\:GNDA) capacitor c=1.64557e-16
    c3813 (\944\:GNDA \1251\:GNDA) capacitor c=8.1312e-17
    c3814 (\88\:S2 \27\:S2) capacitor c=2.62294e-17
    c3815 (\86\:S2 \14\:BG_REF) capacitor c=1.28388e-16
    c3816 (\271\:VDDA \279\:VDDA) capacitor c=3.71504e-16
    c3817 (\217\:S \507\:VDDA) capacitor c=1.06321e-17
    c3818 (\66\:S2 \230\:GNDA) capacitor c=1.63858e-17
    c3819 (\55\:Vo1 \149\:S) capacitor c=2.85864e-16
    c3820 (\112\:Vm1 \5\:VDDA) capacitor c=4.55576e-16
    c3821 (\15\:Vs \29\:D2) capacitor c=2.80241e-15
    c3822 (\28\:U \157\:GNDA) capacitor c=3.54052e-16
    c3823 (\561\:GNDA \51\:Vo1) capacitor c=6.82356e-17
    c3824 (\938\:GNDA \1251\:GNDA) capacitor c=3.22349e-17
    c3825 (\54\:U \1294\:GNDA) capacitor c=1.70814e-16
    c3826 (\500\:GNDA \177\:GNDA) capacitor c=6.40312e-17
    c3827 (\94\:U \1122\:GNDA) capacitor c=1.54869e-17
    c3828 (\29\:S2 \14\:BG_REF) capacitor c=5.61473e-17
    c3829 (\72\:U \1238\:GNDA) capacitor c=1.63679e-16
    c3830 (\807\:VDDA \74\:S2) capacitor c=1.92131e-16
    c3831 (\77\:BG_REF \41\:S) capacitor c=6.35844e-16
    c3832 (\43\:U \175\:GNDA) capacitor c=4.6967e-17
    c3833 (\42\:U \178\:GNDA) capacitor c=3.73689e-17
    c3834 (\12\:vv \18\:S2) capacitor c=2.85522e-17
    c3835 (\414\:VDDA \412\:VDDA) capacitor c=4.84335e-16
    c3836 (\133\:BG_REF \51\:VDDA) capacitor c=1.03845e-17
    c3837 (\73\:S2 \230\:GNDA) capacitor c=1.63858e-17
    c3838 (\442\:VDDA \279\:VDDA) capacitor c=3.30986e-16
    c3839 (\9\:S \106\:VDDA) capacitor c=1.04579e-17
    c3840 (\109\:U \1274\:GNDA) capacitor c=1.14364e-16
    c3841 (\1063\:GNDA \1099\:GNDA) capacitor c=4.6967e-17
    c3842 (\24\:Vs \44\:S2) capacitor c=1.20093e-15
    c3843 (\62\:U \1452\:GNDA) capacitor c=1.3699e-16
    c3844 (\896\:GNDA \798\:GNDA) capacitor c=3.76928e-15
    c3845 (\469\:VDDA \467\:VDDA) capacitor c=4.84335e-16
    c3846 (\1345\:GNDA \1432\:GNDA) capacitor c=7.82192e-17
    c3847 (\29\:vv \44\:S2) capacitor c=1.10298e-17
    c3848 (\1251\:GNDA \12\:U) capacitor c=3.72052e-17
    c3849 (\35\:D1 \37\:Vo1) capacitor c=5.31358e-16
    c3850 (\114\:Vm1 \108\:VDDA) capacitor c=4.39105e-16
    c3851 (\890\:GNDA \712\:GNDA) capacitor c=9.29257e-17
    c3852 (\138\:BG_REF \534\:VDDA) capacitor c=2.52228e-15
    c3853 (\28\:vv \36\:S) capacitor c=3.40015e-17
    c3854 (\664\:GNDA \190\:GNDA) capacitor c=4.6967e-17
    c3855 (\983\:GNDA \1063\:GNDA) capacitor c=7.83521e-17
    c3856 (\77\:S2 \230\:GNDA) capacitor c=1.63858e-17
    c3857 (\24\:S2 \4\:Vs) capacitor c=2.50984e-17
    c3858 (\51\:BG_REF \279\:VDDA) capacitor c=7.1071e-16
    c3859 (\647\:VDDA \27\:vv) capacitor c=3.57544e-16
    c3860 (\134\:BG_REF \574\:VDDA) capacitor c=3.52917e-16
    c3861 (\2\:U \1214\:GNDA) capacitor c=1.99665e-16
    c3862 (\101\:S \40\:Vo1) capacitor c=7.35396e-17
    c3863 (\59\:D1 \684\:GNDA) capacitor c=9.04311e-16
    c3864 (\639\:VDDA \18\:vv) capacitor c=3.57024e-16
    c3865 (\2\:net37 \218\:GNDA) capacitor c=4.0583e-16
    c3866 (\66\:U \1374\:GNDA) capacitor c=4.10562e-17
    c3867 (\148\:VDDA \41\:BG_REF) capacitor c=2.50306e-17
    c3868 (\26\:vv \30\:BG_REF) capacitor c=3.40015e-17
    c3869 (\48\:Vo1 \119\:GNDA) capacitor c=3.10946e-17
    c3870 (\155\:S \102\:S) capacitor c=6.90451e-16
    c3871 (\40\:Vo1 \11\:Y) capacitor c=2.24232e-17
    c3872 (\33\:X \19\:Y) capacitor c=6.06488e-16
    c3873 (\205\:S \590\:VDDA) capacitor c=1.54792e-16
    c3874 (\401\:VDDA \74\:BG_REF) capacitor c=3.89918e-17
    c3875 (\134\:VDDA \131\:VDDA) capacitor c=4.55286e-16
    c3876 (\3\:S2 \44\:S2) capacitor c=9.62457e-17
    c3877 (\804\:VDDA \116\:BG_REF) capacitor c=7.24715e-16
    c3878 (\28\:X \1138\:GNDA) capacitor c=7.35167e-17
    c3879 (\23\:D1 \90\:S) capacitor c=1.20806e-16
    c3880 (\286\:Vm1 \68\:S2) capacitor c=5.08078e-16
    c3881 (\116\:VDDA \279\:VDDA) capacitor c=2.81395e-16
    c3882 (\216\:S \230\:GNDA) capacitor c=1.63858e-17
    c3883 (\67\:S2 \489\:VDDA) capacitor c=1.23137e-17
    c3884 (\150\:Vm1 \245\:VDDA) capacitor c=4.78212e-16
    c3885 (\458\:VDDA \279\:VDDA) capacitor c=3.86901e-16
    c3886 (\971\:GNDA \954\:GNDA) capacitor c=4.83144e-17
    c3887 (\5\:Vo1 \7\:Vo1) capacitor c=2.40617e-15
    c3888 (\783\:GNDA \1251\:GNDA) capacitor c=3.11265e-17
    c3889 (\188\:GNDA \183\:GNDA) capacitor c=9.29257e-17
    c3890 (\296\:VDDA \73\:BG_REF) capacitor c=3.23086e-16
    c3891 (\192\:GNDA \1389\:GNDA) capacitor c=3.40469e-17
    c3892 (\28\:D2 \1551\:GNDA) capacitor c=1.97975e-15
    c3893 (\896\:GNDA \3\:U) capacitor c=8.37369e-16
    c3894 (\1362\:GNDA \1355\:GNDA) capacitor c=4.25896e-15
    c3895 (\235\:S \230\:GNDA) capacitor c=1.63858e-17
    c3896 (\17\:D1 \149\:S) capacitor c=5.57765e-17
    c3897 (\235\:S \103\:S2) capacitor c=1.31478e-16
    c3898 (\131\:U \1251\:GNDA) capacitor c=4.2236e-15
    c3899 (\18\:GNDA \218\:GNDA) capacitor c=4.8226e-15
    c3900 (\240\:S \1251\:GNDA) capacitor c=3.71696e-16
    c3901 (\73\:U \896\:GNDA) capacitor c=6.34328e-16
    c3902 (\623\:VDDA \76\:VDDA) capacitor c=7.65014e-16
    c3903 (\25\:Vs \535\:GNDA) capacitor c=2.86809e-16
    c3904 (\2\:net12 \218\:GNDA) capacitor c=4.09869e-16
    c3905 (\89\:BG_REF \150\:VDDA) capacitor c=1.23369e-17
    c3906 (\34\:S2 \5\:S2) capacitor c=1.02562e-16
    c3907 (\1236\:GNDA \1233\:GNDA) capacitor c=8.23837e-17
    c3908 (\60\:U \1082\:GNDA) capacitor c=5.82324e-17
    c3909 (\28\:Vo1 \83\:S) capacitor c=2.29306e-16
    c3910 (\1430\:GNDA \1402\:GNDA) capacitor c=6.40312e-17
    c3911 (\192\:GNDA \515\:GNDA) capacitor c=2.75818e-15
    c3912 (\2\:net13 \2\:net25) capacitor c=4.43875e-16
    c3913 (\493\:VDDA \111\:BG_REF) capacitor c=1.98136e-16
    c3914 (\96\:Vm1 \279\:VDDA) capacitor c=3.92629e-15
    c3915 (\242\:S \230\:GNDA) capacitor c=3.68579e-17
    c3916 (\230\:GNDA \9\:GNDA) capacitor c=1.67593e-16
    c3917 (\74\:U \1251\:GNDA) capacitor c=7.1556e-17
    c3918 (\525\:VDDA \524\:VDDA) capacitor c=2.14491e-16
    c3919 (\250\:GNDA \230\:GNDA) capacitor c=9.41666e-16
    c3920 (\1555\:GNDA \1559\:GNDA) capacitor c=1.6553e-16
    c3921 (\373\:GNDA \385\:GNDA) capacitor c=9.29257e-17
    c3922 (\235\:S \96\:VDDA) capacitor c=1.06321e-17
    c3923 (\896\:GNDA \1096\:GNDA) capacitor c=1.33732e-17
    c3924 (\27\:U \203\:GNDA) capacitor c=1.71797e-15
    c3925 (\883\:GNDA \839\:GNDA) capacitor c=4.6967e-17
    c3926 (\478\:VDDA \279\:VDDA) capacitor c=2.65004e-16
    c3927 (\192\:GNDA \154\:GNDA) capacitor c=4.13455e-15
    c3928 (\27\:U \905\:GNDA) capacitor c=1.76008e-15
    c3929 (\1206\:GNDA \1159\:GNDA) capacitor c=1.13748e-16
    c3930 (\42\:S2 \41\:S2) capacitor c=4.88835e-16
    c3931 (\635\:VDDA \550\:GNDA) capacitor c=4.25945e-17
    c3932 (\109\:S \40\:Vo1) capacitor c=7.37707e-16
    c3933 (\193\:GNDA \515\:GNDA) capacitor c=3.48524e-16
    c3934 (\67\:U \230\:GNDA) capacitor c=1.59223e-16
    c3935 (\66\:S2 \104\:VDDA) capacitor c=1.23137e-17
    c3936 (\134\:BG_REF \242\:S) capacitor c=2.04562e-16
    c3937 (\1203\:GNDA \1244\:GNDA) capacitor c=4.6967e-17
    c3938 (\695\:VDDA \65\:S2) capacitor c=1.78853e-16
    c3939 (\207\:GNDA \1481\:GNDA) capacitor c=2.76477e-15
    c3940 (\53\:U \1048\:GNDA) capacitor c=3.54052e-16
    c3941 (\4\:Vs \44\:S2) capacitor c=1.07086e-15
    c3942 (\634\:GNDA \455\:GNDA) capacitor c=4.6967e-17
    c3943 (\2\:net39 \10\:GNDA) capacitor c=1.49483e-15
    c3944 (\23\:D1 \149\:S) capacitor c=4.79015e-17
    c3945 (\90\:BG_REF \534\:VDDA) capacitor c=4.91263e-17
    c3946 (\210\:Vm1 \487\:VDDA) capacitor c=2.88285e-16
    c3947 (\66\:GNDA \1\:GNDA) capacitor c=7.51512e-16
    c3948 (\217\:S \69\:S2) capacitor c=3.63261e-15
    c3949 (\344\:VDDA \342\:VDDA) capacitor c=4.84335e-16
    c3950 (\90\:U \461\:GNDA) capacitor c=1.42235e-16
    c3951 (\149\:GNDA \154\:GNDA) capacitor c=1.57709e-16
    c3952 (\832\:VDDA \259\:Vm1) capacitor c=6.77888e-16
    c3953 (\79\:BG_REF \227\:S) capacitor c=1.80203e-16
    c3954 (\142\:GNDA \141\:GNDA) capacitor c=1.85272e-16
    c3955 (\140\:Vm1 \214\:VDDA) capacitor c=4.89293e-16
    c3956 (\1362\:GNDA \99\:U) capacitor c=3.3004e-16
    c3957 (\33\:BG_REF \279\:VDDA) capacitor c=9.7877e-16
    c3958 (\22\:Vs \40\:S2) capacitor c=1.26485e-16
    c3959 (\2\:net16 \2\:net33) capacitor c=1.53892e-16
    c3960 (\266\:VDDA \30\:S) capacitor c=5.28947e-16
    c3961 (\28\:U \784\:GNDA) capacitor c=1.98382e-16
    c3962 (\387\:VDDA \75\:BG_REF) capacitor c=1.48876e-17
    c3963 (\25\:D2 \14\:S2) capacitor c=1.28826e-16
    c3964 (\93\:U \1088\:GNDA) capacitor c=7.21959e-17
    c3965 (\119\:S \41\:Vo1) capacitor c=2.90655e-16
    c3966 (\495\:VDDA \279\:VDDA) capacitor c=2.51763e-16
    c3967 (\52\:U \57\:U) capacitor c=1.13692e-16
    c3968 (\49\:Vo1 \812\:GNDA) capacitor c=3.13778e-16
    c3969 (\138\:BG_REF \230\:GNDA) capacitor c=4.86908e-17
    c3970 (\64\:U \1195\:GNDA) capacitor c=5.64553e-17
    c3971 (\65\:BG_REF \351\:VDDA) capacitor c=1.13151e-17
    c3972 (\25\:S2 \12\:BG_REF) capacitor c=8.44e-17
    c3973 (\1537\:GNDA \715\:GNDA) capacitor c=2.98921e-16
    c3974 (\80\:VDDA \79\:VDDA) capacitor c=2.06468e-16
    c3975 (\80\:GNDA \218\:GNDA) capacitor c=8.8042e-15
    c3976 (\265\:VDDA \39\:BG_REF) capacitor c=3.23487e-16
    c3977 (\2\:net26 \2\:net31) capacitor c=4.57962e-17
    c3978 (\476\:GNDA \1251\:GNDA) capacitor c=4.19575e-17
    c3979 (\95\:U \385\:GNDA) capacitor c=1.87372e-16
    c3980 (\459\:VDDA \479\:VDDA) capacitor c=5.18716e-16
    c3981 (\207\:S \88\:VDDA) capacitor c=1.06321e-17
    c3982 (\711\:GNDA \753\:GNDA) capacitor c=1.62672e-16
    c3983 (\68\:S2 \534\:VDDA) capacitor c=4.5184e-17
    c3984 (\723\:VDDA \279\:VDDA) capacitor c=4.18225e-16
    c3985 (\539\:GNDA \49\:GNDA) capacitor c=3.43767e-16
    c3986 (\207\:GNDA \827\:GNDA) capacitor c=3.65641e-16
    c3987 (\539\:GNDA \718\:GNDA) capacitor c=2.31549e-16
    c3988 (\33\:BG_REF \13\:VDDA) capacitor c=3.03102e-17
    c3989 (\50\:U \786\:GNDA) capacitor c=2.80821e-17
    c3990 (\75\:S2 \112\:VDDA) capacitor c=1.2312e-17
    c3991 (\1509\:GNDA \1507\:GNDA) capacitor c=5.78624e-17
    c3992 (\35\:X \2\:net29) capacitor c=1.98076e-16
    c3993 (\236\:Vm1 \230\:GNDA) capacitor c=1.70347e-16
    c3994 (\205\:GNDA \163\:GNDA) capacitor c=3.1596e-17
    c3995 (\40\:Vo1 \118\:S) capacitor c=1.21867e-16
    c3996 (\2\:net12 \2\:net6) capacitor c=4.54929e-17
    c3997 (\534\:VDDA \535\:GNDA) capacitor c=9.46811e-16
    c3998 (\48\:Vo1 \1523\:GNDA) capacitor c=1.2919e-16
    c3999 (\236\:VDDA \272\:Vm1) capacitor c=2.18118e-16
    c4000 (\631\:VDDA \84\:VDDA) capacitor c=2.28881e-16
    c4001 (\149\:S \102\:S) capacitor c=2.19254e-15
    c4002 (\2\:net3 \1\:GNDA) capacitor c=7.73393e-17
    c4003 (\100\:BG_REF \66\:S2) capacitor c=4.62525e-16
    c4004 (\1362\:GNDA \1238\:GNDA) capacitor c=3.39571e-17
    c4005 (\736\:GNDA \230\:GNDA) capacitor c=3.30836e-16
    c4006 (\118\:Vm1 \279\:VDDA) capacitor c=6.11746e-16
    c4007 (\78\:S2 \23\:S2) capacitor c=3.71919e-17
    c4008 (\270\:Vm1 \230\:GNDA) capacitor c=1.62862e-16
    c4009 (\40\:Vo1 \117\:S) capacitor c=3.6496e-16
    c4010 (\23\:D1 \25\:Vo1) capacitor c=5.29864e-16
    c4011 (\317\:GNDA \230\:GNDA) capacitor c=1.27698e-15
    c4012 (\135\:BG_REF \28\:GNDA) capacitor c=2.89417e-16
    c4013 (\21\:vv \225\:VDDA) capacitor c=3.31616e-17
    c4014 (\88\:BG_REF \49\:VDDA) capacitor c=1.0909e-17
    c4015 (\259\:Vm1 \28\:vv) capacitor c=3.1837e-16
    c4016 (\51\:U \783\:GNDA) capacitor c=3.54052e-16
    c4017 (\142\:VDDA \37\:BG_REF) capacitor c=2.50306e-17
    c4018 (\203\:GNDA \712\:GNDA) capacitor c=3.39571e-17
    c4019 (\269\:VDDA \53\:BG_REF) capacitor c=5.34531e-16
    c4020 (\643\:VDDA \279\:VDDA) capacitor c=2.97267e-16
    c4021 (\47\:D1 \146\:S) capacitor c=6.12674e-16
    c4022 (\115\:GNDA \230\:GNDA) capacitor c=2.4092e-17
    c4023 (\34\:vv \50\:BG_REF) capacitor c=3.31616e-17
    c4024 (\118\:GNDA \122\:GNDA) capacitor c=1.56371e-17
    c4025 (\55\:BG_REF \279\:VDDA) capacitor c=7.10697e-16
    c4026 (\13\:Vs \136\:BG_REF) capacitor c=6.0736e-16
    c4027 (\137\:BG_REF \44\:S2) capacitor c=1.51396e-16
    c4028 (\2\:net28 \218\:GNDA) capacitor c=4.05448e-16
    c4029 (\20\:GNDA \21\:GNDA) capacitor c=3.27241e-16
    c4030 (\59\:U \1079\:GNDA) capacitor c=8.85297e-17
    c4031 (\488\:GNDA \167\:GNDA) capacitor c=6.40312e-17
    c4032 (\17\:vv \202\:VDDA) capacitor c=3.40015e-17
    c4033 (\216\:Vm1 \444\:VDDA) capacitor c=4.6299e-16
    c4034 (\68\:S2 \5\:VDDA) capacitor c=1.34744e-17
    c4035 (\160\:Vm1 \50\:Vm1) capacitor c=8.82743e-16
    c4036 (\142\:VDDA \279\:VDDA) capacitor c=3.29352e-16
    c4037 (\238\:S \76\:S2) capacitor c=6.20947e-15
    c4038 (\21\:S \68\:S2) capacitor c=7.37279e-16
    c4039 (\28\:vv \95\:VDDA) capacitor c=3.49326e-17
    c4040 (\1535\:GNDA \1251\:GNDA) capacitor c=1.11369e-16
    c4041 (\118\:GNDA \1251\:GNDA) capacitor c=2.867e-16
    c4042 (\8\:X \8\:Y) capacitor c=1.18252e-17
    c4043 (\28\:D2 \64\:S2) capacitor c=4.29426e-17
    c4044 (\2\:net17 \100\:GNDA) capacitor c=3.01123e-15
    c4045 (\234\:VDDA \49\:BG_REF) capacitor c=5.30343e-16
    c4046 (\436\:VDDA \901\:VDDA) capacitor c=4.00421e-15
    c4047 (\295\:VDDA \32\:S) capacitor c=5.29488e-16
    c4048 (\138\:BG_REF \569\:VDDA) capacitor c=9.56863e-17
    c4049 (\276\:Vm1 \279\:VDDA) capacitor c=1.18873e-15
    c4050 (\2\:net38 \2\:net23) capacitor c=3.88073e-17
    c4051 (\44\:U \193\:GNDA) capacitor c=5.25176e-17
    c4052 (\20\:vv \534\:VDDA) capacitor c=1.39978e-16
    c4053 (\1140\:GNDA \1088\:GNDA) capacitor c=1.08531e-16
    c4054 (\242\:S \572\:VDDA) capacitor c=7.30557e-16
    c4055 (\7\:VDDA \279\:VDDA) capacitor c=5.71111e-15
    c4056 (\61\:U \1250\:GNDA) capacitor c=3.54052e-16
    c4057 (\121\:BG_REF \236\:S) capacitor c=2.92617e-15
    c4058 (\2\:net41 \218\:GNDA) capacitor c=3.67749e-16
    c4059 (\51\:U \205\:GNDA) capacitor c=8.51466e-16
    c4060 (\203\:GNDA \385\:GNDA) capacitor c=4.37453e-15
    c4061 (\65\:BG_REF \23\:S) capacitor c=2.74589e-16
    c4062 (\17\:D1 \15\:D1) capacitor c=1.24248e-15
    c4063 (\212\:GNDA \535\:GNDA) capacitor c=2.24844e-16
    c4064 (\196\:Vm1 \358\:VDDA) capacitor c=4.68098e-16
    c4065 (\66\:S2 \205\:S) capacitor c=1.34062e-15
    c4066 (\31\:D2 \78\:S2) capacitor c=6.08872e-16
    c4067 (\480\:VDDA \79\:BG_REF) capacitor c=1.56999e-16
    c4068 (\797\:GNDA \839\:GNDA) capacitor c=1.62672e-16
    c4069 (\826\:GNDA \784\:GNDA) capacitor c=5.35597e-17
    c4070 (\19\:Vs \1251\:GNDA) capacitor c=1.05555e-15
    c4071 (\158\:VDDA \279\:VDDA) capacitor c=3.93776e-16
    c4072 (\61\:U \1452\:GNDA) capacitor c=5.76316e-17
    c4073 (\101\:BG_REF \208\:S) capacitor c=2.92617e-15
    c4074 (\34\:vv \268\:VDDA) capacitor c=3.31616e-17
    c4075 (\25\:S2 \7\:D2) capacitor c=5.88198e-16
    c4076 (\205\:GNDA \193\:GNDA) capacitor c=3.86831e-17
    c4077 (\122\:GNDA \16\:Vo1) capacitor c=1.18579e-17
    c4078 (\121\:VDDA \28\:BG_REF) capacitor c=5.18673e-16
    c4079 (\36\:Vs \13\:Vs) capacitor c=1.21922e-16
    c4080 (\260\:Vm1 \236\:S) capacitor c=2.40025e-16
    c4081 (\603\:GNDA \391\:GNDA) capacitor c=4.6967e-17
    c4082 (\33\:S \73\:S2) capacitor c=8.01702e-16
    c4083 (\34\:U \158\:GNDA) capacitor c=3.73689e-17
    c4084 (\192\:GNDA \37\:U) capacitor c=3.3004e-16
    c4085 (\90\:BG_REF \279\:VDDA) capacitor c=9.98072e-16
    c4086 (\746\:GNDA \791\:GNDA) capacitor c=3.15482e-16
    c4087 (\34\:vv \82\:VDDA) capacitor c=9.63617e-17
    c4088 (\25\:D2 \80\:S2) capacitor c=5.23516e-16
    c4089 (\2\:Vo2 \539\:GNDA) capacitor c=7.30904e-16
    c4090 (\3\:net30 \218\:GNDA) capacitor c=1.50999e-17
    c4091 (\3\:Vm1 \279\:VDDA) capacitor c=3.95631e-15
    c4092 (\1545\:GNDA \1251\:GNDA) capacitor c=7.16084e-16
    c4093 (\62\:S \3\:S) capacitor c=6.25108e-16
    c4094 (\7\:D1 \1251\:GNDA) capacitor c=6.20126e-16
    c4095 (\136\:S \5\:S) capacitor c=4.78784e-16
    c4096 (\1105\:GNDA \1024\:GNDA) capacitor c=1.11282e-16
    c4097 (\9\:S2 \21\:vv) capacitor c=2.89923e-15
    c4098 (\134\:BG_REF \271\:VDDA) capacitor c=1.0364e-17
    c4099 (\21\:vv \23\:S) capacitor c=1.3147e-17
    c4100 (\140\:S \7\:S) capacitor c=6.47097e-16
    c4101 (\63\:Vo1 \198\:S) capacitor c=1.80891e-16
    c4102 (\67\:U \704\:GNDA) capacitor c=1.07184e-16
    c4103 (\9\:S \279\:VDDA) capacitor c=1.24821e-15
    c4104 (\835\:GNDA \883\:GNDA) capacitor c=4.29192e-16
    c4105 (\85\:U \1405\:GNDA) capacitor c=5.48895e-17
    c4106 (\1401\:GNDA \1373\:GNDA) capacitor c=6.40312e-17
    c4107 (\71\:Vo1 \183\:S) capacitor c=1.63838e-16
    c4108 (\807\:VDDA \249\:Vm1) capacitor c=1.7176e-15
    c4109 (\75\:BG_REF \59\:VDDA) capacitor c=1.33555e-17
    c4110 (\80\:S2 \19\:S2) capacitor c=6.31124e-17
    c4111 (\47\:D1 \149\:S) capacitor c=2.31857e-16
    c4112 (\544\:VDDA \758\:GNDA) capacitor c=8.62053e-17
    c4113 (\17\:U \798\:GNDA) capacitor c=1.98382e-16
    c4114 (\124\:Vm1 \175\:VDDA) capacitor c=4.86828e-16
    c4115 (\47\:U \190\:GNDA) capacitor c=4.6967e-17
    c4116 (\247\:S \1251\:GNDA) capacitor c=6.47102e-16
    c4117 (\1238\:GNDA \103\:U) capacitor c=3.72052e-17
    c4118 (\206\:S \279\:VDDA) capacitor c=2.87886e-15
    c4119 (\21\:vv \74\:VDDA) capacitor c=9.77055e-17
    c4120 (\33\:U \185\:GNDA) capacitor c=3.08821e-16
    c4121 (\37\:Vo1 \114\:S) capacitor c=1.1543e-16
    c4122 (\356\:VDDA \79\:BG_REF) capacitor c=2.87197e-16
    c4123 (\76\:S2 \87\:BG_REF) capacitor c=1.05365e-17
    c4124 (\641\:GNDA \449\:GNDA) capacitor c=1.5605e-16
    c4125 (\333\:VDDA \279\:VDDA) capacitor c=4.00809e-16
    c4126 (\62\:U \207\:GNDA) capacitor c=2.44638e-15
    c4127 (\37\:S \350\:VDDA) capacitor c=1.85729e-17
    c4128 (\1006\:GNDA \1029\:GNDA) capacitor c=3.15482e-16
    c4129 (\226\:S \24\:vv) capacitor c=5.23282e-16
    c4130 (\83\:U \1096\:GNDA) capacitor c=4.10562e-17
    c4131 (\8\:Vs \8\:S2) capacitor c=2.28029e-17
    c4132 (\162\:Vm1 \296\:VDDA) capacitor c=3.50869e-16
    c4133 (\19\:vv \720\:VDDA) capacitor c=6.59825e-17
    c4134 (\99\:U \935\:GNDA) capacitor c=1.29529e-15
    c4135 (\110\:BG_REF \583\:VDDA) capacitor c=7.18821e-16
    c4136 (\905\:GNDA \1018\:GNDA) capacitor c=4.76497e-15
    c4137 (\48\:S \279\:VDDA) capacitor c=1.67328e-16
    c4138 (\1032\:GNDA \1005\:GNDA) capacitor c=6.40312e-17
    c4139 (\118\:U \1221\:GNDA) capacitor c=1.30432e-16
    c4140 (\7\:U \207\:GNDA) capacitor c=8.49054e-16
    c4141 (\67\:U \748\:GNDA) capacitor c=2.78212e-17
    c4142 (\54\:Vo1 \196\:S) capacitor c=9.55063e-16
    c4143 (\1040\:GNDA \1063\:GNDA) capacitor c=4.30376e-16
    c4144 (\17\:S2 \24\:S2) capacitor c=2.29551e-16
    c4145 (\135\:BG_REF \15\:BG_REF) capacitor c=1.22766e-15
    c4146 (\122\:Vm1 \279\:VDDA) capacitor c=3.70454e-16
    c4147 (\136\:BG_REF \25\:D2) capacitor c=1.70547e-16
    c4148 (\251\:S \158\:S) capacitor c=5.56847e-16
    c4149 (\133\:VDDA \426\:VDDA) capacitor c=2.71175e-16
    c4150 (\21\:S2 \8\:D2) capacitor c=2.36055e-17
    c4151 (\93\:U \1362\:GNDA) capacitor c=1.07594e-15
    c4152 (\491\:VDDA \59\:VDDA) capacitor c=8.50906e-16
    c4153 (\2\:net40 \23\:GNDA) capacitor c=3.12467e-15
    c4154 (\3\:U \1233\:GNDA) capacitor c=1.49234e-17
    c4155 (\363\:VDDA \64\:BG_REF) capacitor c=5.28947e-16
    c4156 (\103\:S2 \49\:BG_REF) capacitor c=1.11867e-17
    c4157 (\101\:BG_REF \18\:vv) capacitor c=5.14498e-16
    c4158 (\17\:vv \134\:VDDA) capacitor c=3.31616e-17
    c4159 (\71\:S2 \21\:vv) capacitor c=4.30036e-15
    c4160 (\101\:U \1012\:GNDA) capacitor c=5.82324e-17
    c4161 (\207\:GNDA \1114\:GNDA) capacitor c=3.69784e-15
    c4162 (\33\:U \183\:GNDA) capacitor c=1.35858e-16
    c4163 (\745\:GNDA \791\:GNDA) capacitor c=1.62672e-16
    c4164 (\21\:S \245\:VDDA) capacitor c=1.88243e-17
    c4165 (\65\:S2 \279\:VDDA) capacitor c=2.80554e-15
    c4166 (\118\:Vm1 \9\:Vm1) capacitor c=1.79353e-16
    c4167 (\1362\:GNDA \753\:GNDA) capacitor c=2.31665e-15
    c4168 (\203\:GNDA \91\:U) capacitor c=1.46279e-15
    c4169 (\37\:S \279\:VDDA) capacitor c=8.29648e-16
    c4170 (\226\:S \9\:VDDA) capacitor c=1.03845e-17
    c4171 (\28\:BG_REF \7\:VDDA) capacitor c=2.14804e-17
    c4172 (\204\:VDDA \202\:VDDA) capacitor c=4.84335e-16
    c4173 (\52\:S2 \44\:S2) capacitor c=7.53064e-16
    c4174 (\807\:VDDA \227\:S) capacitor c=3.82852e-16
    c4175 (\25\:VDDA \279\:VDDA) capacitor c=4.14252e-15
    c4176 (\130\:Vm1 \181\:VDDA) capacitor c=4.86828e-16
    c4177 (\152\:VDDA \272\:Vm1) capacitor c=3.9399e-16
    c4178 (\20\:vv \39\:S) capacitor c=1.3147e-17
    c4179 (\24\:S2 \2\:S2) capacitor c=2.95867e-17
    c4180 (\58\:D1 \166\:S) capacitor c=6.17986e-16
    c4181 (\32\:U \1159\:GNDA) capacitor c=1.98382e-16
    c4182 (\83\:BG_REF \84\:BG_REF) capacitor c=5.22064e-16
    c4183 (\539\:GNDA \203\:GNDA) capacitor c=6.71894e-15
    c4184 (\2\:net7 \218\:GNDA) capacitor c=4.24246e-16
    c4185 (\137\:BG_REF \534\:VDDA) capacitor c=2.98782e-15
    c4186 (\22\:Vs \47\:S2) capacitor c=2.33917e-16
    c4187 (\212\:Vm1 \456\:VDDA) capacitor c=3.537e-16
    c4188 (\199\:VDDA \279\:VDDA) capacitor c=3.94466e-16
    c4189 (\54\:U \1309\:GNDA) capacitor c=5.2224e-17
    c4190 (\12\:U \1481\:GNDA) capacitor c=4.6967e-17
    c4191 (\2\:net26 \46\:GNDA) capacitor c=2.65876e-15
    c4192 (\55\:S2 \554\:VDDA) capacitor c=4.79162e-16
    c4193 (\149\:S \539\:GNDA) capacitor c=4.46268e-16
    c4194 (\23\:D1 \3\:X) capacitor c=2.24251e-17
    c4195 (\16\:vv \537\:VDDA) capacitor c=4.74616e-16
    c4196 (\86\:U \1314\:GNDA) capacitor c=3.77148e-17
    c4197 (\544\:VDDA \279\:VDDA) capacitor c=3.40021e-16
    c4198 (\1057\:GNDA \1033\:GNDA) capacitor c=6.40312e-17
    c4199 (\4\:vv \34\:S2) capacitor c=6.8305e-17
    c4200 (\125\:S \102\:S) capacitor c=4.44057e-16
    c4201 (\71\:U \1138\:GNDA) capacitor c=1.62775e-16
    c4202 (\34\:vv \860\:VDDA) capacitor c=5.63619e-17
    c4203 (\2\:net15 \85\:GNDA) capacitor c=7.12846e-15
    c4204 (\186\:Vm1 \279\:VDDA) capacitor c=3.70995e-16
    c4205 (\22\:Vs \44\:S2) capacitor c=8.90522e-16
    c4206 (\19\:D2 \1251\:GNDA) capacitor c=6.36777e-16
    c4207 (\10\:D1 \1251\:GNDA) capacitor c=1.40929e-15
    c4208 (\1402\:GNDA \1403\:GNDA) capacitor c=4.12292e-16
    c4209 (\6\:S2 \44\:S2) capacitor c=5.3737e-16
    c4210 (\207\:S \534\:VDDA) capacitor c=4.5184e-17
    c4211 (\245\:GNDA \684\:GNDA) capacitor c=1.29495e-17
    c4212 (\539\:GNDA \768\:GNDA) capacitor c=2.93012e-16
    c4213 (\28\:Vo1 \85\:S) capacitor c=2.8649e-16
    c4214 (\80\:BG_REF \279\:VDDA) capacitor c=1.15424e-16
    c4215 (\317\:VDDA \65\:BG_REF) capacitor c=2.93628e-16
    c4216 (\2\:net35 \218\:GNDA) capacitor c=4.36408e-16
    c4217 (\118\:U \203\:GNDA) capacitor c=4.73061e-15
    c4218 (\28\:vv \196\:VDDA) capacitor c=3.31616e-17
    c4219 (\248\:Vm1 \279\:VDDA) capacitor c=1.01335e-15
    c4220 (\539\:GNDA \6\:vv) capacitor c=1.86251e-16
    c4221 (\60\:S2 \535\:GNDA) capacitor c=5.27719e-17
    c4222 (\93\:Vm1 \94\:Vm1) capacitor c=6.44978e-16
    c4223 (\45\:BG_REF \279\:VDDA) capacitor c=7.10839e-16
    c4224 (\77\:S2 \910\:VDDA) capacitor c=5.0707e-16
    c4225 (\15\:BG_REF \29\:GNDA) capacitor c=6.80454e-16
    c4226 (\29\:U \905\:GNDA) capacitor c=3.37209e-16
    c4227 (\2\:net27 \93\:GNDA) capacitor c=1.71295e-15
    c4228 (\2\:net8 \2\:net25) capacitor c=4.04113e-17
    c4229 (\40\:U \175\:GNDA) capacitor c=8.85297e-17
    c4230 (\1137\:GNDA \1138\:GNDA) capacitor c=4.05657e-16
    c4231 (\983\:GNDA \948\:GNDA) capacitor c=9.29257e-17
    c4232 (\669\:GNDA \521\:GNDA) capacitor c=8.60436e-16
    c4233 (\12\:Y \102\:S) capacitor c=1.26862e-15
    c4234 (\52\:D1 \63\:Vo1) capacitor c=2.56475e-15
    c4235 (\45\:U \193\:GNDA) capacitor c=1.1051e-16
    c4236 (\1012\:GNDA \995\:GNDA) capacitor c=6.40312e-17
    c4237 (\35\:BG_REF \173\:VDDA) capacitor c=2.93937e-16
    c4238 (\8\:Vs \52\:S2) capacitor c=1.34359e-17
    c4239 (\121\:BG_REF \27\:vv) capacitor c=5.14497e-16
    c4240 (\1152\:GNDA \1068\:GNDA) capacitor c=9.29257e-17
    c4241 (\44\:U \190\:GNDA) capacitor c=1.54869e-17
    c4242 (\100\:VDDA \272\:Vm1) capacitor c=2.25333e-16
    c4243 (\1314\:GNDA \1332\:GNDA) capacitor c=3.14499e-16
    c4244 (\12\:Vs \896\:GNDA) capacitor c=3.50712e-16
    c4245 (\192\:GNDA \168\:GNDA) capacitor c=3.76911e-15
    c4246 (\242\:S \635\:VDDA) capacitor c=1.94517e-17
    c4247 (\783\:GNDA \823\:GNDA) capacitor c=1.62672e-16
    c4248 (\127\:VDDA \34\:BG_REF) capacitor c=5.18673e-16
    c4249 (\537\:GNDA \535\:GNDA) capacitor c=2.40663e-16
    c4250 (\13\:Vs \83\:BG_REF) capacitor c=3.3401e-16
    c4251 (\2\:net6 \218\:GNDA) capacitor c=3.75713e-16
    c4252 (\728\:GNDA \4\:Vo1) capacitor c=1.87252e-17
    c4253 (\732\:GNDA \391\:GNDA) capacitor c=4.6967e-17
    c4254 (\110\:BG_REF \279\:VDDA) capacitor c=7.30306e-16
    c4255 (\34\:vv \631\:VDDA) capacitor c=3.75302e-16
    c4256 (\125\:S \40\:Vo1) capacitor c=2.60434e-16
    c4257 (\13\:Vs \1251\:GNDA) capacitor c=2.90351e-16
    c4258 (\144\:Vm1 \279\:VDDA) capacitor c=3.71316e-16
    c4259 (\142\:Vm1 \33\:Vm1) capacitor c=4.99678e-17
    c4260 (\205\:GNDA \1074\:GNDA) capacitor c=3.02961e-15
    c4261 (\104\:BG_REF \221\:S) capacitor c=1.31478e-16
    c4262 (\896\:GNDA \1294\:GNDA) capacitor c=3.22597e-17
    c4263 (\71\:S2 \776\:VDDA) capacitor c=4.14992e-16
    c4264 (\50\:U \776\:GNDA) capacitor c=1.07184e-16
    c4265 (\55\:S2 \1251\:GNDA) capacitor c=3.43878e-16
    c4266 (\544\:VDDA \534\:VDDA) capacitor c=6.33842e-16
    c4267 (\39\:BG_REF \179\:VDDA) capacitor c=3.14461e-16
    c4268 (\373\:GNDA \379\:GNDA) capacitor c=3.34263e-16
    c4269 (\31\:Vo1 \87\:S) capacitor c=3.34161e-16
    c4270 (\896\:GNDA \1054\:GNDA) capacitor c=2.31665e-15
    c4271 (\2\:net15 \93\:GNDA) capacitor c=4.98168e-17
    c4272 (\541\:GNDA \1251\:GNDA) capacitor c=2.4088e-16
    c4273 (\649\:VDDA \260\:Vm1) capacitor c=5.32105e-16
    c4274 (\20\:U \1034\:GNDA) capacitor c=4.69538e-17
    c4275 (\376\:VDDA \279\:VDDA) capacitor c=3.71677e-16
    c4276 (\2\:net4 \2\:net15) capacitor c=3.50496e-16
    c4277 (\1362\:GNDA \70\:U) capacitor c=1.13492e-15
    c4278 (\593\:GNDA \218\:GNDA) capacitor c=1.4813e-16
    c4279 (\43\:VDDA \279\:VDDA) capacitor c=3.79329e-15
    c4280 (\205\:GNDA \1105\:GNDA) capacitor c=4.453e-16
    c4281 (\284\:VDDA \67\:BG_REF) capacitor c=2.93949e-16
    c4282 (\28\:D2 \1251\:GNDA) capacitor c=1.04902e-15
    c4283 (\655\:VDDA \137\:BG_REF) capacitor c=6.76042e-16
    c4284 (\69\:S2 \534\:VDDA) capacitor c=6.77331e-17
    c4285 (\18\:BG_REF \550\:GNDA) capacitor c=7.86944e-16
    c4286 (\19\:Y \1251\:GNDA) capacitor c=5.10316e-16
    c4287 (\368\:VDDA \65\:BG_REF) capacitor c=5.36988e-16
    c4288 (\8\:BIAS \1251\:GNDA) capacitor c=1.05028e-15
    c4289 (\221\:S \279\:VDDA) capacitor c=1.14863e-15
    c4290 (\203\:GNDA \996\:GNDA) capacitor c=3.39571e-17
    c4291 (\106\:VDDA \5\:VDDA) capacitor c=8.50684e-16
    c4292 (\35\:Vm1 \36\:Vm1) capacitor c=6.3799e-16
    c4293 (\26\:vv \11\:S) capacitor c=1.3147e-17
    c4294 (\9\:BG_REF \7\:Vo1) capacitor c=2.06628e-16
    c4295 (\28\:X \29\:X) capacitor c=2.42755e-16
    c4296 (\366\:GNDA \597\:GNDA) capacitor c=4.30888e-16
    c4297 (\207\:GNDA \51\:U) capacitor c=1.46275e-15
    c4298 (\132\:Vm1 \23\:Vm1) capacitor c=1.78161e-16
    c4299 (\34\:X \2\:net2) capacitor c=4.65264e-16
    c4300 (\73\:U \1314\:GNDA) capacitor c=1.52412e-16
    c4301 (\4\:D1 \1251\:GNDA) capacitor c=2.02809e-15
    c4302 (\1268\:GNDA \1250\:GNDA) capacitor c=6.40312e-17
    c4303 (\32\:U \500\:GNDA) capacitor c=6.78232e-17
    c4304 (\25\:vv \525\:VDDA) capacitor c=1.87765e-17
    c4305 (\812\:GNDA \149\:S) capacitor c=2.11409e-16
    c4306 (\53\:GNDA \218\:GNDA) capacitor c=7.39788e-15
    c4307 (\1555\:GNDA \1251\:GNDA) capacitor c=2.05023e-16
    c4308 (\12\:vv \1251\:GNDA) capacitor c=4.0053e-17
    c4309 (\332\:GNDA \218\:GNDA) capacitor c=2.92417e-16
    c4310 (\71\:BG_REF \437\:VDDA) capacitor c=1.36071e-17
    c4311 (\401\:VDDA \73\:BG_REF) capacitor c=5.37491e-16
    c4312 (\695\:VDDA \206\:S) capacitor c=3.82852e-16
    c4313 (\217\:S \59\:VDDA) capacitor c=1.03845e-17
    c4314 (\72\:S2 \546\:VDDA) capacitor c=2.34783e-16
    c4315 (\364\:VDDA \64\:BG_REF) capacitor c=3.8451e-17
    c4316 (\240\:S \38\:D1) capacitor c=2.00456e-16
    c4317 (\68\:S2 \279\:VDDA) capacitor c=2.97944e-15
    c4318 (\77\:U \961\:GNDA) capacitor c=1.09512e-16
    c4319 (\304\:VDDA \58\:BG_REF) capacitor c=3.79103e-17
    c4320 (\16\:GNDA \18\:GNDA) capacitor c=2.40375e-16
    c4321 (\232\:VDDA \279\:VDDA) capacitor c=3.91235e-16
    c4322 (\168\:Vm1 \58\:Vm1) capacitor c=8.83803e-16
    c4323 (\54\:U \1195\:GNDA) capacitor c=1.81769e-16
    c4324 (\482\:GNDA \163\:GNDA) capacitor c=4.83144e-17
    c4325 (\157\:GNDA \160\:GNDA) capacitor c=1.62672e-16
    c4326 (\236\:S \550\:VDDA) capacitor c=1.6314e-16
    c4327 (\2\:BIAS \1251\:GNDA) capacitor c=1.45536e-15
    c4328 (\2\:vv \27\:S2) capacitor c=5.10166e-17
    c4329 (\12\:BIAS \1251\:GNDA) capacitor c=4.61416e-16
    c4330 (\206\:S \66\:S2) capacitor c=2.22721e-16
    c4331 (\28\:BG_REF \279\:VDDA) capacitor c=1.15121e-16
    c4332 (\89\:U \1430\:GNDA) capacitor c=5.82324e-17
    c4333 (\203\:GNDA \363\:GNDA) capacitor c=4.43247e-15
    c4334 (\77\:U \1054\:GNDA) capacitor c=4.6967e-17
    c4335 (\230\:GNDA \158\:S) capacitor c=6.13374e-16
    c4336 (\43\:GNDA \2\:net20) capacitor c=4.98168e-17
    c4337 (\174\:Vm1 \313\:VDDA) capacitor c=4.61843e-16
    c4338 (\29\:D1 \89\:S) capacitor c=7.86134e-17
    c4339 (\32\:D1 \102\:S) capacitor c=1.10105e-15
    c4340 (\31\:X \1233\:GNDA) capacitor c=4.6967e-17
    c4341 (\19\:vv \36\:BG_REF) capacitor c=3.40015e-17
    c4342 (\64\:U \1192\:GNDA) capacitor c=1.26142e-15
    c4343 (\107\:Vm1 \108\:Vm1) capacitor c=6.50917e-16
    c4344 (\138\:GNDA \134\:GNDA) capacitor c=1.26822e-17
    c4345 (\198\:Vm1 \279\:VDDA) capacitor c=3.71744e-16
    c4346 (\51\:VDDA \279\:VDDA) capacitor c=3.93862e-15
    c4347 (\45\:U \669\:GNDA) capacitor c=2.11632e-15
    c4348 (\245\:VDDA \25\:BG_REF) capacitor c=2.8742e-16
    c4349 (\2\:Vs \1251\:GNDA) capacitor c=1.84889e-15
    c4350 (\81\:U \1172\:GNDA) capacitor c=1.33645e-15
    c4351 (\25\:BG_REF \174\:VDDA) capacitor c=1.1294e-17
    c4352 (\2\:net25 \218\:GNDA) capacitor c=3.97262e-16
    c4353 (\138\:GNDA \1251\:GNDA) capacitor c=3.83478e-16
    c4354 (\89\:BG_REF \1\:VDDA) capacitor c=1.39504e-17
    c4355 (\286\:VDDA \79\:BG_REF) capacitor c=2.84857e-16
    c4356 (\695\:VDDA \287\:Vm1) capacitor c=1.72117e-15
    c4357 (\25\:S \279\:VDDA) capacitor c=8.29043e-16
    c4358 (\32\:D2 \44\:S2) capacitor c=7.83109e-17
    c4359 (\226\:S \804\:VDDA) capacitor c=3.90385e-16
    c4360 (\2\:net22 \23\:GNDA) capacitor c=8.80795e-16
    c4361 (\62\:U \203\:GNDA) capacitor c=1.90433e-17
    c4362 (\192\:Vm1 \370\:VDDA) capacitor c=3.47479e-16
    c4363 (\249\:S \53\:D1) capacitor c=3.15989e-16
    c4364 (\748\:VDDA \112\:Vm1) capacitor c=2.41182e-16
    c4365 (\500\:GNDA \180\:GNDA) capacitor c=8.23837e-17
    c4366 (\27\:vv \550\:VDDA) capacitor c=2.94422e-16
    c4367 (\649\:VDDA \76\:S2) capacitor c=2.71236e-16
    c4368 (\641\:VDDA \521\:VDDA) capacitor c=2.29189e-16
    c4369 (\225\:Vm1 \507\:VDDA) capacitor c=3.22227e-16
    c4370 (\182\:Vm1 \337\:VDDA) capacitor c=3.49531e-16
    c4371 (\37\:BG_REF \15\:S) capacitor c=1.35616e-15
    c4372 (\148\:Vm1 \38\:Vm1) capacitor c=8.81838e-16
    c4373 (\591\:VDDA \534\:VDDA) capacitor c=4.10547e-16
    c4374 (\944\:GNDA \7\:Vo1) capacitor c=3.9155e-17
    c4375 (\18\:vv \502\:VDDA) capacitor c=3.31616e-17
    c4376 (\34\:vv \163\:VDDA) capacitor c=3.31616e-17
    c4377 (\1362\:GNDA \1201\:GNDA) capacitor c=3.74307e-15
    c4378 (\27\:S \68\:S2) capacitor c=7.37279e-16
    c4379 (\224\:VDDA \48\:BG_REF) capacitor c=3.89918e-17
    c4380 (\242\:S \436\:VDDA) capacitor c=2.10671e-15
    c4381 (\44\:Vo1 \728\:GNDA) capacitor c=1.16481e-16
    c4382 (\11\:BG_REF \44\:S2) capacitor c=9.0147e-17
    c4383 (\1140\:GNDA \1009\:GNDA) capacitor c=4.6967e-17
    c4384 (\35\:X \591\:GNDA) capacitor c=8.40991e-16
    c4385 (\44\:S2 \675\:GNDA) capacitor c=5.39957e-17
    c4386 (\235\:VDDA \240\:VDDA) capacitor c=4.75166e-16
    c4387 (\16\:GNDA \218\:GNDA) capacitor c=6.79045e-17
    c4388 (\137\:BG_REF \427\:VDDA) capacitor c=9.96943e-17
    c4389 (\720\:VDDA \279\:VDDA) capacitor c=4.19786e-16
    c4390 (\623\:VDDA \73\:S2) capacitor c=1.14197e-16
    c4391 (\1166\:GNDA \1167\:GNDA) capacitor c=4.05613e-16
    c4392 (\2\:U \1251\:GNDA) capacitor c=2.52774e-16
    c4393 (\28\:X \81\:U) capacitor c=6.74589e-17
    c4394 (\54\:U \10\:U) capacitor c=1.23367e-15
    c4395 (\771\:GNDA \684\:GNDA) capacitor c=3.54087e-16
    c4396 (\192\:GNDA \43\:U) capacitor c=3.38399e-16
    c4397 (\158\:Vm1 \279\:VDDA) capacitor c=3.71056e-16
    c4398 (\169\:VDDA \167\:VDDA) capacitor c=4.84335e-16
    c4399 (\38\:D1 \13\:X) capacitor c=2.39703e-17
    c4400 (\39\:U \165\:GNDA) capacitor c=4.6967e-17
    c4401 (\31\:U \494\:GNDA) capacitor c=6.78232e-17
    c4402 (\22\:Vs \539\:GNDA) capacitor c=3.46801e-17
    c4403 (\69\:S2 \22\:vv) capacitor c=1.24156e-16
    c4404 (\539\:GNDA \760\:GNDA) capacitor c=7.13778e-17
    c4405 (\133\:BG_REF \499\:VDDA) capacitor c=2.04887e-17
    c4406 (\276\:Vm1 \18\:vv) capacitor c=2.99174e-16
    c4407 (\39\:BG_REF \33\:S) capacitor c=3.14505e-16
    c4408 (\156\:Vm1 \46\:Vm1) capacitor c=8.82898e-16
    c4409 (\539\:GNDA \15\:BG_REF) capacitor c=1.37797e-16
    c4410 (\83\:BG_REF \718\:GNDA) capacitor c=1.7061e-16
    c4411 (\36\:BG_REF \279\:VDDA) capacitor c=1.15424e-16
    c4412 (\321\:VDDA \320\:VDDA) capacitor c=1.82943e-16
    c4413 (\905\:GNDA \1383\:GNDA) capacitor c=5.59855e-15
    c4414 (\5\:Vs \137\:GNDA) capacitor c=9.1708e-16
    c4415 (\14\:Vm1 \279\:VDDA) capacitor c=3.92626e-15
    c4416 (\633\:VDDA \205\:S) capacitor c=7.37821e-16
    c4417 (\590\:VDDA \591\:VDDA) capacitor c=5.13654e-16
    c4418 (\16\:Vo1 \1251\:GNDA) capacitor c=2.39153e-16
    c4419 (\70\:VDDA \69\:VDDA) capacitor c=2.12056e-16
    c4420 (\206\:Vm1 \391\:VDDA) capacitor c=4.77611e-16
    c4421 (\440\:VDDA \439\:VDDA) capacitor c=1.82419e-16
    c4422 (\399\:VDDA \279\:VDDA) capacitor c=3.96231e-16
    c4423 (\1402\:GNDA \1251\:GNDA) capacitor c=3.11265e-17
    c4424 (\20\:U \1251\:GNDA) capacitor c=2.52641e-16
    c4425 (\236\:S \513\:VDDA) capacitor c=1.06321e-17
    c4426 (\1063\:GNDA \998\:GNDA) capacitor c=4.6967e-17
    c4427 (\105\:U \1377\:GNDA) capacitor c=6.15578e-17
    c4428 (\53\:D1 \155\:S) capacitor c=2.3605e-16
    c4429 (\641\:VDDA \69\:S2) capacitor c=1.0092e-16
    c4430 (\156\:Vm1 \267\:VDDA) capacitor c=3.46264e-16
    c4431 (\623\:VDDA \279\:VDDA) capacitor c=2.97404e-16
    c4432 (\136\:GNDA \135\:GNDA) capacitor c=1.85501e-16
    c4433 (\242\:S \534\:VDDA) capacitor c=2.3399e-16
    c4434 (\53\:U \1114\:GNDA) capacitor c=1.98382e-16
    c4435 (\4\:Vs \60\:S2) capacitor c=1.99484e-16
    c4436 (\249\:VDDA \279\:VDDA) capacitor c=3.25828e-16
    c4437 (\340\:VDDA \345\:VDDA) capacitor c=4.75166e-16
    c4438 (\1362\:GNDA \800\:GNDA) capacitor c=3.65698e-16
    c4439 (\52\:U \971\:GNDA) capacitor c=1.82468e-16
    c4440 (\41\:U \494\:GNDA) capacitor c=5.82324e-17
    c4441 (\260\:Vm1 \27\:vv) capacitor c=2.71173e-16
    c4442 (\121\:BG_REF \65\:VDDA) capacitor c=1.33555e-17
    c4443 (\718\:GNDA \3\:Vo2) capacitor c=3.03526e-17
    c4444 (\501\:VDDA \658\:VDDA) capacitor c=2.25167e-16
    c4445 (\50\:U \207\:GNDA) capacitor c=1.57238e-15
    c4446 (\40\:GNDA \2\:net40) capacitor c=2.63718e-16
    c4447 (\31\:U \1251\:GNDA) capacitor c=9.18805e-16
    c4448 (\476\:GNDA \158\:GNDA) capacitor c=5.35597e-17
    c4449 (\28\:S2 \44\:S2) capacitor c=1.98644e-16
    c4450 (\587\:VDDA \279\:VDDA) capacitor c=3.1235e-16
    c4451 (\541\:GNDA \539\:GNDA) capacitor c=6.35801e-16
    c4452 (\18\:U \961\:GNDA) capacitor c=1.71879e-16
    c4453 (\73\:BG_REF \279\:VDDA) capacitor c=1.98965e-15
    c4454 (\45\:U \535\:GNDA) capacitor c=1.01205e-16
    c4455 (\337\:VDDA \43\:S) capacitor c=1.27935e-16
    c4456 (\212\:GNDA \1557\:GNDA) capacitor c=2.64195e-17
    c4457 (\3\:BG_REF \550\:GNDA) capacitor c=1.11555e-15
    c4458 (\896\:GNDA \82\:U) capacitor c=7.93593e-17
    c4459 (\2\:net3 \66\:GNDA) capacitor c=3.55838e-15
    c4460 (\531\:VDDA \530\:VDDA) capacitor c=2.11124e-16
    c4461 (\93\:U \1009\:GNDA) capacitor c=1.54869e-17
    c4462 (\641\:VDDA \276\:Vm1) capacitor c=5.81842e-16
    c4463 (\73\:S2 \29\:BG_REF) capacitor c=1.11867e-17
    c4464 (\74\:S2 \495\:VDDA) capacitor c=1.23137e-17
    c4465 (\48\:U \1251\:GNDA) capacitor c=7.15634e-17
    c4466 (\43\:D1 \149\:S) capacitor c=1.00186e-15
    c4467 (\269\:VDDA \279\:VDDA) capacitor c=3.98521e-16
    c4468 (\896\:GNDA \89\:U) capacitor c=3.38399e-16
    c4469 (\1362\:GNDA \1034\:GNDA) capacitor c=3.39571e-17
    c4470 (\79\:BG_REF \63\:VDDA) capacitor c=1.33555e-17
    c4471 (\241\:S \427\:VDDA) capacitor c=3.01829e-16
    c4472 (\61\:U \1251\:GNDA) capacitor c=1.33797e-15
    c4473 (\62\:U \1495\:GNDA) capacitor c=5.5274e-17
    c4474 (\111\:S \33\:D1) capacitor c=2.90655e-16
    c4475 (\44\:S2 \535\:GNDA) capacitor c=3.7525e-16
    c4476 (\207\:GNDA \1238\:GNDA) capacitor c=1.33732e-17
    c4477 (\784\:GNDA \22\:U) capacitor c=3.72052e-17
    c4478 (\10\:Y \34\:Vo1) capacitor c=1.77348e-17
    c4479 (\413\:GNDA \419\:GNDA) capacitor c=3.30954e-16
    c4480 (\118\:Vm1 \162\:VDDA) capacitor c=3.38176e-16
    c4481 (\23\:D1 \21\:D1) capacitor c=1.24248e-15
    c4482 (\807\:VDDA \117\:BG_REF) capacitor c=1.10524e-15
    c4483 (\9\:GNDA \218\:GNDA) capacitor c=3.69331e-15
    c4484 (\1034\:GNDA \101\:U) capacitor c=3.72052e-17
    c4485 (\237\:S \103\:S2) capacitor c=6.48125e-15
    c4486 (\495\:VDDA \64\:VDDA) capacitor c=6.64563e-16
    c4487 (\210\:Vm1 \279\:VDDA) capacitor c=4.52787e-16
    c4488 (\512\:GNDA \187\:GNDA) capacitor c=6.40312e-17
    c4489 (\56\:U \746\:GNDA) capacitor c=4.10562e-17
    c4490 (\344\:GNDA \114\:GNDA) capacitor c=1.464e-17
    c4491 (\184\:Vm1 \323\:VDDA) capacitor c=4.61843e-16
    c4492 (\905\:GNDA \1364\:GNDA) capacitor c=3.5226e-15
    c4493 (\1401\:GNDA \1251\:GNDA) capacitor c=4.19575e-17
    c4494 (\17\:U \791\:GNDA) capacitor c=1.54869e-17
    c4495 (\96\:VDDA \31\:BG_REF) capacitor c=2.22142e-16
    c4496 (\68\:U \659\:GNDA) capacitor c=5.23865e-17
    c4497 (\35\:X \1133\:GNDA) capacitor c=6.19133e-17
    c4498 (\27\:BG_REF \221\:S) capacitor c=6.32027e-16
    c4499 (\79\:U \996\:GNDA) capacitor c=4.10562e-17
    c4500 (\11\:D2 \6\:S2) capacitor c=1.11925e-17
    c4501 (\84\:U \1251\:GNDA) capacitor c=1.1743e-15
    c4502 (\77\:BG_REF \443\:VDDA) capacitor c=1.36071e-17
    c4503 (\203\:GNDA \193\:GNDA) capacitor c=1.13694e-16
    c4504 (\135\:BG_REF \16\:BG_REF) capacitor c=3.73574e-16
    c4505 (\704\:GNDA \203\:GNDA) capacitor c=1.20188e-16
    c4506 (\33\:U \905\:GNDA) capacitor c=3.31709e-16
    c4507 (\79\:BG_REF \285\:VDDA) capacitor c=1.23247e-17
    c4508 (\206\:S \534\:VDDA) capacitor c=4.92369e-17
    c4509 (\138\:BG_REF \242\:S) capacitor c=6.29431e-15
    c4510 (\1181\:GNDA \1203\:GNDA) capacitor c=4.30204e-16
    c4511 (\66\:S2 \43\:BG_REF) capacitor c=1.11867e-17
    c4512 (\905\:GNDA \870\:GNDA) capacitor c=1.43156e-17
    c4513 (\29\:D2 \9\:vv) capacitor c=4.39808e-16
    c4514 (\2\:U \1215\:GNDA) capacitor c=4.70738e-17
    c4515 (\28\:U \154\:GNDA) capacitor c=5.64952e-17
    c4516 (\212\:Vm1 \440\:VDDA) capacitor c=4.6299e-16
    c4517 (\591\:GNDA \70\:GNDA) capacitor c=1.42292e-17
    c4518 (\1535\:GNDA \10\:D2) capacitor c=5.11833e-16
    c4519 (\1200\:GNDA \1251\:GNDA) capacitor c=3.11265e-17
    c4520 (\98\:VDDA \279\:VDDA) capacitor c=3.86108e-16
    c4521 (\22\:vv \506\:VDDA) capacitor c=3.31616e-17
    c4522 (\34\:X \17\:Y) capacitor c=1.23164e-15
    c4523 (\251\:VDDA \31\:BG_REF) capacitor c=2.8742e-16
    c4524 (\33\:S \7\:vv) capacitor c=1.36007e-16
    c4525 (\438\:VDDA \279\:VDDA) capacitor c=3.30986e-16
    c4526 (\1362\:GNDA \96\:U) capacitor c=7.93593e-17
    c4527 (\31\:Vo1 \97\:S) capacitor c=2.23394e-16
    c4528 (\89\:U \1427\:GNDA) capacitor c=1.3611e-15
    c4529 (\476\:VDDA \75\:BG_REF) capacitor c=1.56999e-16
    c4530 (\134\:BG_REF \116\:VDDA) capacitor c=2.04887e-17
    c4531 (\273\:VDDA \426\:VDDA) capacitor c=3.83472e-16
    c4532 (\156\:Vm1 \251\:VDDA) capacitor c=4.78212e-16
    c4533 (\449\:GNDA \461\:GNDA) capacitor c=9.29257e-17
    c4534 (\827\:GNDA \791\:GNDA) capacitor c=4.6967e-17
    c4535 (\4\:Vo2 \1251\:GNDA) capacitor c=5.47761e-16
    c4536 (\292\:VDDA \279\:VDDA) capacitor c=2.75667e-16
    c4537 (\43\:Vo1 \230\:GNDA) capacitor c=1.91049e-16
    c4538 (\768\:GNDA \1251\:GNDA) capacitor c=7.45194e-17
    c4539 (\15\:vv \716\:GNDA) capacitor c=9.25894e-16
    c4540 (\218\:VDDA \49\:BG_REF) capacitor c=2.2657e-17
    c4541 (\133\:BG_REF \411\:VDDA) capacitor c=1.03669e-17
    c4542 (\1175\:GNDA \1137\:GNDA) capacitor c=5.57695e-17
    c4543 (\136\:BG_REF \149\:S) capacitor c=1.38744e-17
    c4544 (\102\:S2 \57\:BG_REF) capacitor c=1.11867e-17
    c4545 (\192\:GNDA \183\:GNDA) capacitor c=3.74935e-15
    c4546 (\300\:VDDA \33\:S) capacitor c=1.28247e-16
    c4547 (\30\:U \488\:GNDA) capacitor c=6.78232e-17
    c4548 (\203\:GNDA \1096\:GNDA) capacitor c=3.86715e-17
    c4549 (\112\:VDDA \279\:VDDA) capacitor c=2.52177e-16
    c4550 (\178\:GNDA \180\:GNDA) capacitor c=3.15482e-16
    c4551 (\116\:U \230\:GNDA) capacitor c=5.55063e-16
    c4552 (\104\:U \1300\:GNDA) capacitor c=6.78232e-17
    c4553 (\1136\:GNDA \1113\:GNDA) capacitor c=6.40312e-17
    c4554 (\454\:VDDA \279\:VDDA) capacitor c=3.86901e-16
    c4555 (\31\:S \315\:VDDA) capacitor c=1.93444e-17
    c4556 (\56\:Vo1 \52\:S) capacitor c=1.14317e-16
    c4557 (\253\:VDDA \53\:BG_REF) capacitor c=1.56294e-17
    c4558 (\205\:GNDA \1006\:GNDA) capacitor c=4.1022e-17
    c4559 (\10\:Vs \1251\:GNDA) capacitor c=4.13982e-17
    c4560 (\2\:net27 \5\:GNDA) capacitor c=1.26289e-17
    c4561 (\1082\:GNDA \1048\:GNDA) capacitor c=6.40312e-17
    c4562 (\104\:U \109\:U) capacitor c=1.69405e-17
    c4563 (\63\:U \1251\:GNDA) capacitor c=5.09198e-17
    c4564 (\86\:S2 \22\:Vs) capacitor c=6.26403e-16
    c4565 (\78\:S2 \12\:vv) capacitor c=4.10737e-16
    c4566 (\494\:GNDA \172\:GNDA) capacitor c=6.40312e-17
    c4567 (\70\:U \1034\:GNDA) capacitor c=1.63679e-16
    c4568 (\166\:S \46\:Vo1) capacitor c=1.02397e-16
    c4569 (\13\:GNDA \14\:GNDA) capacitor c=3.8842e-16
    c4570 (\33\:vv \112\:S2) capacitor c=1.98273e-15
    c4571 (\665\:VDDA \89\:BG_REF) capacitor c=1.35006e-15
    c4572 (\90\:S2 \15\:Vs) capacitor c=7.85023e-16
    c4573 (\214\:VDDA \39\:BG_REF) capacitor c=2.93779e-16
    c4574 (\383\:VDDA \71\:BG_REF) capacitor c=1.48876e-17
    c4575 (\10\:U \1233\:GNDA) capacitor c=4.6967e-17
    c4576 (\294\:VDDA \55\:BG_REF) capacitor c=5.35451e-16
    c4577 (\207\:GNDA \1398\:GNDA) capacitor c=2.31665e-15
    c4578 (\1320\:GNDA \1244\:GNDA) capacitor c=4.6967e-17
    c4579 (\16\:X \16\:Y) capacitor c=1.20742e-17
    c4580 (\637\:GNDA \634\:GNDA) capacitor c=9.29282e-17
    c4581 (\716\:GNDA \6\:vv) capacitor c=3.18689e-16
    c4582 (\47\:U \506\:GNDA) capacitor c=5.64553e-17
    c4583 (\37\:Vo1 \230\:GNDA) capacitor c=1.39447e-16
    c4584 (\142\:GNDA \1251\:GNDA) capacitor c=6.79177e-16
    c4585 (\11\:GNDA \2\:GNDA) capacitor c=2.75073e-16
    c4586 (\331\:VDDA \38\:S) capacitor c=1.21854e-16
    c4587 (\126\:VDDA \279\:VDDA) capacitor c=2.95619e-16
    c4588 (\84\:U \89\:U) capacitor c=1.69405e-17
    c4589 (\124\:VDDA \29\:BG_REF) capacitor c=4.80342e-16
    c4590 (\17\:vv \239\:VDDA) capacitor c=3.31616e-17
    c4591 (\27\:S2 \11\:D2) capacitor c=5.7434e-16
    c4592 (\3\:BIAS \2\:BIAS) capacitor c=3.872e-16
    c4593 (\474\:VDDA \279\:VDDA) capacitor c=2.65004e-16
    c4594 (\577\:VDDA \534\:VDDA) capacitor c=5.68811e-16
    c4595 (\1335\:GNDA \1251\:GNDA) capacitor c=3.1724e-17
    c4596 (\270\:Vm1 \28\:vv) capacitor c=2.66552e-16
    c4597 (\35\:S \321\:VDDA) capacitor c=1.93444e-17
    c4598 (\320\:GNDA \1251\:GNDA) capacitor c=3.06059e-15
    c4599 (\21\:vv \26\:BG_REF) capacitor c=3.40015e-17
    c4600 (\99\:U \753\:GNDA) capacitor c=4.6967e-17
    c4601 (\208\:Vm1 \409\:VDDA) capacitor c=3.4614e-16
    c4602 (\904\:VDDA \279\:VDDA) capacitor c=1.39906e-15
    c4603 (\121\:S \41\:Vo1) capacitor c=3.34161e-16
    c4604 (\2\:net1 \2\:net28) capacitor c=4.775e-17
    c4605 (\304\:VDDA \279\:VDDA) capacitor c=4.01618e-16
    c4606 (\63\:VDDA \64\:VDDA) capacitor c=6.69821e-16
    c4607 (\18\:U \956\:GNDA) capacitor c=2.65899e-16
    c4608 (\812\:GNDA \1251\:GNDA) capacitor c=3.55634e-16
    c4609 (\13\:Vm1 \14\:Vm1) capacitor c=6.39737e-16
    c4610 (\43\:Vo1 \149\:S) capacitor c=5.33376e-16
    c4611 (\12\:Vs \1251\:GNDA) capacitor c=1.00906e-15
    c4612 (\292\:VDDA \271\:Vm1) capacitor c=3.9399e-16
    c4613 (\73\:BG_REF \37\:S) capacitor c=7.23054e-16
    c4614 (\260\:Vm1 \121\:BG_REF) capacitor c=1.52034e-15
    c4615 (\896\:GNDA \1034\:GNDA) capacitor c=3.76983e-15
    c4616 (\48\:Vo1 \1532\:GNDA) capacitor c=3.16627e-15
    c4617 (\1518\:GNDA \13\:D1) capacitor c=4.5031e-16
    c4618 (\2\:net10 \2\:net8) capacitor c=4.49041e-17
    c4619 (\29\:BG_REF \279\:VDDA) capacitor c=9.7876e-16
    c4620 (\31\:BG_REF \145\:VDDA) capacitor c=1.23404e-17
    c4621 (\79\:U \1057\:GNDA) capacitor c=5.82324e-17
    c4622 (\33\:vv \70\:BG_REF) capacitor c=3.31616e-17
    c4623 (\1561\:GNDA \85\:U) capacitor c=1.65215e-16
    c4624 (\230\:VDDA \39\:BG_REF) capacitor c=3.20609e-16
    c4625 (\228\:VDDA \23\:S) capacitor c=1.28281e-16
    c4626 (\491\:VDDA \279\:VDDA) capacitor c=2.51763e-16
    c4627 (\259\:VDDA \51\:BG_REF) capacitor c=5.34531e-16
    c4628 (\1523\:GNDA \46\:D1) capacitor c=1.16762e-15
    c4629 (\2\:Y \173\:S) capacitor c=6.2789e-16
    c4630 (\549\:GNDA \230\:GNDA) capacitor c=3.98937e-16
    c4631 (\32\:GNDA \218\:GNDA) capacitor c=6.74585e-15
    c4632 (\26\:vv \264\:VDDA) capacitor c=3.31616e-17
    c4633 (\1405\:GNDA \1355\:GNDA) capacitor c=1.5907e-16
    c4634 (\192\:VDDA \16\:S) capacitor c=5.28947e-16
    c4635 (\495\:VDDA \63\:VDDA) capacitor c=1.86343e-16
    c4636 (\58\:Vo1 \5\:S) capacitor c=5.9372e-17
    c4637 (\320\:GNDA \218\:GNDA) capacitor c=4.60188e-16
    c4638 (\50\:U \874\:GNDA) capacitor c=5.74856e-17
    c4639 (\860\:VDDA \120\:Vm1) capacitor c=2.39856e-16
    c4640 (\1221\:GNDA \1218\:GNDA) capacitor c=7.84056e-17
    c4641 (\187\:VDDA \272\:Vm1) capacitor c=3.9399e-16
    c4642 (\207\:GNDA \1251\:GNDA) capacitor c=8.85464e-15
    c4643 (\668\:VDDA \279\:VDDA) capacitor c=5.99855e-16
    c4644 (\239\:S \31\:VDDA) capacitor c=1.34744e-17
    c4645 (\1221\:GNDA \1201\:GNDA) capacitor c=4.83033e-17
    c4646 (\69\:BG_REF \236\:S) capacitor c=6.30961e-16
    c4647 (\217\:S \20\:vv) capacitor c=5.11038e-16
    c4648 (\593\:GNDA \3\:GNDA) capacitor c=2.10425e-15
    c4649 (\306\:VDDA \279\:VDDA) capacitor c=3.71677e-16
    c4650 (\33\:U \182\:GNDA) capacitor c=4.09597e-16
    c4651 (\177\:GNDA \1251\:GNDA) capacitor c=3.11265e-17
    c4652 (\210\:VDDA \25\:BG_REF) capacitor c=2.93779e-16
    c4653 (\247\:S \38\:D1) capacitor c=3.78535e-16
    c4654 (\207\:S \66\:S2) capacitor c=6.64253e-15
    c4655 (\131\:BG_REF \534\:VDDA) capacitor c=2.35651e-17
    c4656 (\27\:vv \510\:VDDA) capacitor c=3.31616e-17
    c4657 (\738\:GNDA \883\:GNDA) capacitor c=3.24909e-17
    c4658 (\88\:S2 \41\:S2) capacitor c=2.13672e-17
    c4659 (\144\:Vm1 \36\:Vm1) capacitor c=8.78027e-16
    c4660 (\52\:U \954\:GNDA) capacitor c=1.50519e-16
    c4661 (\33\:X \17\:Y) capacitor c=2.62088e-16
    c4662 (\539\:GNDA \25\:GNDA) capacitor c=3.31226e-17
    c4663 (\23\:D2 \14\:BG_REF) capacitor c=5.3123e-17
    c4664 (\114\:Vm1 \279\:VDDA) capacitor c=6.11746e-16
    c4665 (\446\:VDDA \445\:VDDA) capacitor c=1.82418e-16
    c4666 (\827\:GNDA \704\:GNDA) capacitor c=3.61478e-17
    c4667 (\203\:GNDA \648\:GNDA) capacitor c=3.69467e-16
    c4668 (\8\:Vs \110\:S2) capacitor c=5.38367e-17
    c4669 (\25\:BG_REF \209\:VDDA) capacitor c=1.02632e-17
    c4670 (\513\:VDDA \279\:VDDA) capacitor c=3.77935e-16
    c4671 (\112\:Vm1 \156\:VDDA) capacitor c=3.38176e-16
    c4672 (\25\:vv \68\:BG_REF) capacitor c=3.40015e-17
    c4673 (\2\:net4 \52\:GNDA) capacitor c=6.26877e-16
    c4674 (\8\:U \1251\:GNDA) capacitor c=1.57296e-15
    c4675 (\614\:VDDA \230\:GNDA) capacitor c=1.28567e-15
    c4676 (\120\:BG_REF \26\:vv) capacitor c=5.24628e-16
    c4677 (\194\:S \56\:S) capacitor c=4.68549e-16
    c4678 (\35\:S2 \14\:BG_REF) capacitor c=5.12641e-17
    c4679 (\224\:Vm1 \521\:GNDA) capacitor c=4.05379e-16
    c4680 (\5\:U \1251\:GNDA) capacitor c=7.1556e-17
    c4681 (\34\:vv \84\:VDDA) capacitor c=1.91078e-17
    c4682 (\639\:VDDA \279\:VDDA) capacitor c=2.98147e-16
    c4683 (\20\:D1 \18\:D1) capacitor c=1.24351e-15
    c4684 (\31\:U \1049\:GNDA) capacitor c=1.98382e-16
    c4685 (\27\:S2 \13\:BG_REF) capacitor c=1.14216e-16
    c4686 (\216\:VDDA \31\:BG_REF) capacitor c=2.93779e-16
    c4687 (\327\:VDDA \279\:VDDA) capacitor c=2.75667e-16
    c4688 (\896\:GNDA \1274\:GNDA) capacitor c=1.33732e-17
    c4689 (\138\:Vm1 \29\:Vm1) capacitor c=1.05584e-15
    c4690 (\695\:VDDA \90\:BG_REF) capacitor c=1.10524e-15
    c4691 (\2\:net32 \218\:GNDA) capacitor c=3.92619e-16
    c4692 (\561\:GNDA \684\:GNDA) capacitor c=2.84545e-16
    c4693 (\106\:U \1221\:GNDA) capacitor c=1.3814e-16
    c4694 (\6\:Vs \136\:GNDA) capacitor c=4.57515e-16
    c4695 (\36\:U \482\:GNDA) capacitor c=1.3814e-16
    c4696 (\905\:GNDA \183\:GNDA) capacitor c=2.09344e-16
    c4697 (\33\:BG_REF \148\:VDDA) capacitor c=2.89826e-16
    c4698 (\32\:D2 \57\:S2) capacitor c=7.01403e-17
    c4699 (\33\:U \47\:U) capacitor c=2.5409e-15
    c4700 (\56\:VDDA \279\:VDDA) capacitor c=5.66413e-15
    c4701 (\216\:Vm1 \61\:VDDA) capacitor c=3.04777e-16
    c4702 (\33\:U \1251\:GNDA) capacitor c=1.09308e-15
    c4703 (\320\:GNDA \18\:GNDA) capacitor c=1.26057e-17
    c4704 (\1466\:GNDA \1415\:GNDA) capacitor c=4.6967e-17
    c4705 (\20\:vv \46\:S) capacitor c=3.40015e-17
    c4706 (\29\:BG_REF \9\:VDDA) capacitor c=3.03102e-17
    c4707 (\35\:X \118\:U) capacitor c=7.3339e-16
    c4708 (\51\:Vo1 \902\:GNDA) capacitor c=1.74714e-16
    c4709 (\18\:BG_REF \7\:Vo1) capacitor c=1.46074e-15
    c4710 (\138\:VDDA \279\:VDDA) capacitor c=3.29352e-16
    c4711 (\217\:S \72\:S2) capacitor c=1.31551e-16
    c4712 (\1125\:GNDA \1251\:GNDA) capacitor c=4.19575e-17
    c4713 (\170\:Vm1 \288\:VDDA) capacitor c=4.61668e-16
    c4714 (\47\:D1 \193\:S) capacitor c=9.08101e-17
    c4715 (\34\:Vo1 \26\:D1) capacitor c=5.31661e-16
    c4716 (\198\:Vm1 \86\:Vm1) capacitor c=8.81959e-16
    c4717 (\559\:VDDA \279\:VDDA) capacitor c=2.07642e-16
    c4718 (\192\:GNDA \664\:GNDA) capacitor c=3.69508e-16
    c4719 (\827\:GNDA \786\:GNDA) capacitor c=1.19908e-15
    c4720 (\17\:U \738\:GNDA) capacitor c=5.64952e-17
    c4721 (\1284\:GNDA \47\:U) capacitor c=3.63621e-17
    c4722 (\42\:S2 \31\:S2) capacitor c=6.3261e-17
    c4723 (\33\:X \18\:X) capacitor c=4.2402e-17
    c4724 (\16\:vv \377\:VDDA) capacitor c=3.40015e-17
    c4725 (\2\:net19 \52\:GNDA) capacitor c=2.83008e-15
    c4726 (\140\:S \138\:S) capacitor c=1.20192e-15
    c4727 (\137\:BG_REF \279\:VDDA) capacitor c=5.33041e-15
    c4728 (\51\:Vo1 \1251\:GNDA) capacitor c=1.38785e-15
    c4729 (\1383\:GNDA \183\:GNDA) capacitor c=3.33327e-17
    c4730 (\323\:VDDA \279\:VDDA) capacitor c=3.31309e-16
    c4731 (\69\:U \1251\:GNDA) capacitor c=1.01999e-15
    c4732 (\3\:VDDA \279\:VDDA) capacitor c=5.71111e-15
    c4733 (\19\:vv \748\:VDDA) capacitor c=7.13071e-16
    c4734 (\157\:VDDA \38\:BG_REF) capacitor c=5.28947e-16
    c4735 (\784\:GNDA \823\:GNDA) capacitor c=3.15482e-16
    c4736 (\208\:S \489\:VDDA) capacitor c=2.04858e-17
    c4737 (\315\:VDDA \314\:VDDA) capacitor c=1.82943e-16
    c4738 (\69\:U \935\:GNDA) capacitor c=5.24582e-17
    c4739 (\203\:GNDA \218\:GNDA) capacitor c=5.46975e-15
    c4740 (\276\:Vm1 \101\:BG_REF) capacitor c=1.52034e-15
    c4741 (\44\:S \279\:VDDA) capacitor c=1.67343e-16
    c4742 (\1559\:GNDA \207\:GNDA) capacitor c=1.31478e-15
    c4743 (\240\:S \534\:VDDA) capacitor c=4.22578e-16
    c4744 (\63\:S \62\:S) capacitor c=1.13276e-16
    c4745 (\549\:GNDA \1\:BG_REF) capacitor c=3.70333e-16
    c4746 (\166\:S \102\:S) capacitor c=4.29121e-16
    c4747 (\71\:S2 \24\:vv) capacitor c=1.22457e-16
    c4748 (\53\:D1 \148\:S) capacitor c=6.15531e-16
    c4749 (\154\:VDDA \279\:VDDA) capacitor c=3.93776e-16
    c4750 (\436\:VDDA \427\:VDDA) capacitor c=1.35857e-14
    c4751 (\64\:Vo1 \149\:S) capacitor c=3.26181e-16
    c4752 (\621\:VDDA \21\:vv) capacitor c=9.84124e-16
    c4753 (\108\:U \1274\:GNDA) capacitor c=3.73689e-17
    c4754 (\92\:S2 \50\:S2) capacitor c=4.35151e-16
    c4755 (\1505\:GNDA \1251\:GNDA) capacitor c=2.06763e-16
    c4756 (\22\:Vs \136\:BG_REF) capacitor c=8.5959e-16
    c4757 (\548\:VDDA \535\:GNDA) capacitor c=3.51378e-17
    c4758 (\1324\:GNDA \1495\:GNDA) capacitor c=3.72052e-17
    c4759 (\35\:S2 \39\:S2) capacitor c=4.23043e-17
    c4760 (\228\:VDDA \24\:S) capacitor c=1.23003e-16
    c4761 (\127\:S \141\:S) capacitor c=6.24816e-16
    c4762 (\1024\:GNDA \954\:GNDA) capacitor c=9.29257e-17
    c4763 (\23\:D1 \31\:Vo1) capacitor c=5.31736e-16
    c4764 (\539\:GNDA \26\:GNDA) capacitor c=6.02968e-17
    c4765 (\240\:S \279\:VDDA) capacitor c=1.81953e-15
    c4766 (\84\:U \1427\:GNDA) capacitor c=1.54869e-17
    c4767 (\489\:VDDA \58\:VDDA) capacitor c=6.64563e-16
    c4768 (\14\:Y \102\:S) capacitor c=2.124e-15
    c4769 (\1048\:GNDA \1251\:GNDA) capacitor c=3.11265e-17
    c4770 (\1421\:GNDA \1452\:GNDA) capacitor c=3.3676e-17
    c4771 (\594\:VDDA \230\:GNDA) capacitor c=2.71216e-14
    c4772 (\44\:Vo1 \768\:GNDA) capacitor c=1.17918e-16
    c4773 (\2\:net29 \66\:GNDA) capacitor c=3.24368e-15
    c4774 (\31\:BG_REF \11\:S) capacitor c=1.41855e-15
    c4775 (\2\:net32 \52\:GNDA) capacitor c=2.99493e-16
    c4776 (\34\:vv \534\:VDDA) capacitor c=5.41423e-17
    c4777 (\1362\:GNDA \373\:GNDA) capacitor c=1.33732e-17
    c4778 (\461\:GNDA \467\:GNDA) capacitor c=3.8061e-16
    c4779 (\17\:Y \17\:X) capacitor c=7.16301e-17
    c4780 (\17\:VDDA \279\:VDDA) capacitor c=4.32912e-15
    c4781 (\37\:Vo1 \149\:S) capacitor c=3.94702e-16
    c4782 (\113\:S \111\:S) capacitor c=1.23862e-15
    c4783 (\1314\:GNDA \1238\:GNDA) capacitor c=9.29257e-17
    c4784 (\1527\:GNDA \1251\:GNDA) capacitor c=7.76389e-16
    c4785 (\238\:S \33\:vv) capacitor c=5.12714e-16
    c4786 (\591\:VDDA \230\:GNDA) capacitor c=3.21316e-16
    c4787 (\50\:U \1251\:GNDA) capacitor c=1.70705e-15
    c4788 (\896\:GNDA \883\:GNDA) capacitor c=5.53024e-15
    c4789 (\333\:GNDA \14\:GNDA) capacitor c=2.15048e-17
    c4790 (\63\:Vo1 \265\:S) capacitor c=1.80532e-15
    c4791 (\25\:Vs \26\:D2) capacitor c=2.0047e-15
    c4792 (\238\:S \112\:S2) capacitor c=4.155e-16
    c4793 (\905\:GNDA \190\:GNDA) capacitor c=1.3153e-17
    c4794 (\27\:S \280\:VDDA) capacitor c=1.90814e-17
    c4795 (\34\:vv \897\:VDDA) capacitor c=8.611e-16
    c4796 (\426\:VDDA \89\:BG_REF) capacitor c=3.0611e-15
    c4797 (\1113\:GNDA \1114\:GNDA) capacitor c=3.43209e-16
    c4798 (\7\:Vo1 \684\:GNDA) capacitor c=1.95315e-17
    c4799 (\80\:U \1251\:GNDA) capacitor c=5.5941e-17
    c4800 (\500\:GNDA \178\:GNDA) capacitor c=5.35597e-17
    c4801 (\205\:GNDA \1394\:GNDA) capacitor c=3.53572e-15
    c4802 (\1389\:GNDA \1447\:GNDA) capacitor c=3.63979e-16
    c4803 (\585\:VDDA \230\:GNDA) capacitor c=2.77166e-16
    c4804 (\29\:U \162\:GNDA) capacitor c=4.06727e-16
    c4805 (\112\:S2 \279\:VDDA) capacitor c=6.89309e-16
    c4806 (\22\:S2 \19\:S2) capacitor c=5.67367e-16
    c4807 (\121\:BG_REF \238\:S) capacitor c=1.31405e-16
    c4808 (\88\:S2 \31\:S2) capacitor c=1.46493e-16
    c4809 (\218\:Vm1 \480\:VDDA) capacitor c=2.24131e-16
    c4810 (\26\:D1 \94\:S) capacitor c=1.02879e-16
    c4811 (\329\:VDDA \279\:VDDA) capacitor c=4.01072e-16
    c4812 (\207\:GNDA \31\:X) capacitor c=3.38399e-16
    c4813 (\1018\:GNDA \37\:U) capacitor c=3.59294e-17
    c4814 (\44\:D1 \1251\:GNDA) capacitor c=7.09665e-16
    c4815 (\37\:Vo1 \9\:Y) capacitor c=2.39723e-17
    c4816 (\27\:VDDA \279\:VDDA) capacitor c=3.79413e-15
    c4817 (\77\:U \975\:GNDA) capacitor c=1.29529e-15
    c4818 (\12\:Y \40\:Vo1) capacitor c=3.31464e-17
    c4819 (\313\:VDDA \59\:BG_REF) capacitor c=1.35399e-17
    c4820 (\66\:BG_REF \279\:VDDA) capacitor c=1.15424e-16
    c4821 (\363\:GNDA \373\:GNDA) capacitor c=9.29257e-17
    c4822 (\1130\:GNDA \163\:GNDA) capacitor c=3.3337e-17
    c4823 (\52\:GNDA \2\:net2) capacitor c=2.81971e-17
    c4824 (\124\:U \1364\:GNDA) capacitor c=1.29027e-16
    c4825 (\579\:VDDA \230\:GNDA) capacitor c=1.76907e-16
    c4826 (\124\:GNDA \123\:GNDA) capacitor c=4.26802e-16
    c4827 (\205\:GNDA \1159\:GNDA) capacitor c=4.27024e-15
    c4828 (\54\:Vo1 \194\:S) capacitor c=6.4001e-16
    c4829 (\101\:BG_REF \217\:S) capacitor c=1.31405e-16
    c4830 (\183\:VDDA \279\:VDDA) capacitor c=3.29821e-16
    c4831 (\114\:VDDA \33\:BG_REF) capacitor c=3.86661e-16
    c4832 (\715\:GNDA \534\:VDDA) capacitor c=3.69107e-17
    c4833 (\24\:vv \91\:VDDA) capacitor c=3.48219e-17
    c4834 (\86\:U \1335\:GNDA) capacitor c=1.3814e-16
    c4835 (\57\:U \971\:GNDA) capacitor c=1.3814e-16
    c4836 (\61\:BG_REF \357\:VDDA) capacitor c=1.2524e-17
    c4837 (\10\:U \1294\:GNDA) capacitor c=1.08835e-16
    c4838 (\272\:Vm1 \574\:VDDA) capacitor c=9.72651e-16
    c4839 (\507\:VDDA \105\:BG_REF) capacitor c=2.22142e-16
    c4840 (\573\:VDDA \230\:GNDA) capacitor c=2.14557e-16
    c4841 (\110\:BG_REF \221\:S) capacitor c=2.56266e-15
    c4842 (\33\:vv \373\:VDDA) capacitor c=3.31616e-17
    c4843 (\19\:vv \56\:BG_REF) capacitor c=3.40015e-17
    c4844 (\173\:GNDA \60\:U) capacitor c=3.72052e-17
    c4845 (\27\:vv \279\:VDDA) capacitor c=4.6876e-15
    c4846 (\203\:GNDA \1274\:GNDA) capacitor c=3.39571e-17
    c4847 (\114\:Vm1 \5\:Vm1) capacitor c=1.05955e-15
    c4848 (\1543\:GNDA \19\:Vs) capacitor c=8.31949e-16
    c4849 (\47\:D1 \191\:S) capacitor c=2.42888e-16
    c4850 (\58\:Vo1 \718\:GNDA) capacitor c=9.45511e-17
    c4851 (\45\:U \664\:GNDA) capacitor c=1.10098e-16
    c4852 (\1024\:GNDA \1074\:GNDA) capacitor c=2.43795e-16
    c4853 (\9\:U \1294\:GNDA) capacitor c=3.77148e-17
    c4854 (\67\:BG_REF \388\:VDDA) capacitor c=1.35815e-17
    c4855 (\494\:GNDA \1251\:GNDA) capacitor c=4.19575e-17
    c4856 (\297\:Vm1 \17\:vv) capacitor c=4.2575e-16
    c4857 (\41\:U \1049\:GNDA) capacitor c=4.10562e-17
    c4858 (\16\:vv \534\:VDDA) capacitor c=9.92973e-17
    c4859 (\7\:vv \227\:VDDA) capacitor c=3.31616e-17
    c4860 (\230\:GNDA \2\:net39) capacitor c=1.91504e-16
    c4861 (\218\:Vm1 \64\:VDDA) capacitor c=2.90616e-16
    c4862 (\133\:BG_REF \327\:VDDA) capacitor c=2.04887e-17
    c4863 (\142\:GNDA \18\:D2) capacitor c=4.01703e-16
    c4864 (\195\:VDDA \279\:VDDA) capacitor c=3.94428e-16
    c4865 (\1389\:GNDA \1466\:GNDA) capacitor c=1.23864e-16
    c4866 (\540\:VDDA \279\:VDDA) capacitor c=5.65101e-16
    c4867 (\2\:net33 \52\:GNDA) capacitor c=3.80014e-16
    c4868 (\63\:BG_REF \382\:VDDA) capacitor c=1.35815e-17
    c4869 (\53\:U \1024\:GNDA) capacitor c=8.94854e-17
    c4870 (\11\:GNDA \2\:net35) capacitor c=2.52808e-16
    c4871 (\1362\:GNDA \1088\:GNDA) capacitor c=4.2346e-15
    c4872 (\961\:GNDA \798\:GNDA) capacitor c=9.29257e-17
    c4873 (\128\:Vm1 \19\:Vm1) capacitor c=1.05692e-15
    c4874 (\948\:GNDA \1013\:GNDA) capacitor c=1.2346e-16
    c4875 (\776\:VDDA \27\:BG_REF) capacitor c=1.43076e-16
    c4876 (\14\:S2 \19\:S2) capacitor c=2.25238e-17
    c4877 (\31\:D2 \82\:S2) capacitor c=1.80891e-16
    c4878 (\47\:D1 \71\:Vo1) capacitor c=1.63621e-15
    c4879 (\268\:S \102\:S) capacitor c=5.22137e-16
    c4880 (\1005\:GNDA \1251\:GNDA) capacitor c=3.11265e-17
    c4881 (\53\:D1 \64\:Vo1) capacitor c=3.19051e-15
    c4882 (\19\:vv \13\:S) capacitor c=1.3147e-17
    c4883 (\905\:GNDA \1063\:GNDA) capacitor c=5.59889e-15
    c4884 (\358\:VDDA \279\:VDDA) capacitor c=3.30175e-16
    c4885 (\109\:S \102\:S) capacitor c=5.04542e-16
    c4886 (\28\:D2 \535\:GNDA) capacitor c=3.89353e-16
    c4887 (\73\:U \87\:U) capacitor c=1.3181e-15
    c4888 (\14\:GNDA \218\:GNDA) capacitor c=9.90518e-16
    c4889 (\1159\:GNDA \1049\:GNDA) capacitor c=9.29257e-17
    c4890 (\105\:BG_REF \69\:S2) capacitor c=4.62525e-16
    c4891 (\95\:U \1200\:GNDA) capacitor c=3.40094e-16
    c4892 (\76\:BG_REF \279\:VDDA) capacitor c=1.15424e-16
    c4893 (\18\:vv \473\:VDDA) capacitor c=3.31616e-17
    c4894 (\260\:Vm1 \513\:VDDA) capacitor c=3.22227e-16
    c4895 (\75\:S2 \11\:VDDA) capacitor c=1.34744e-17
    c4896 (\286\:Vm1 \279\:VDDA) capacitor c=1.01336e-15
    c4897 (\66\:S2 \35\:BG_REF) capacitor c=1.11867e-17
    c4898 (\257\:VDDA \31\:VDDA) capacitor c=1.0554e-15
    c4899 (\17\:S \279\:VDDA) capacitor c=1.80638e-15
    c4900 (\1088\:GNDA \996\:GNDA) capacitor c=9.29257e-17
    c4901 (\3\:vv \44\:S2) capacitor c=9.15101e-17
    c4902 (\100\:U \1251\:GNDA) capacitor c=7.1556e-17
    c4903 (\25\:vv \369\:VDDA) capacitor c=3.31616e-17
    c4904 (\19\:GNDA \2\:net22) capacitor c=1.59375e-17
    c4905 (\591\:GNDA \69\:GNDA) capacitor c=1.90805e-17
    c4906 (\192\:GNDA \784\:GNDA) capacitor c=1.33732e-17
    c4907 (\109\:U \1218\:GNDA) capacitor c=4.6967e-17
    c4908 (\26\:S2 \7\:D2) capacitor c=1.86576e-16
    c4909 (\62\:U \205\:GNDA) capacitor c=1.14648e-15
    c4910 (\4\:S \102\:S) capacitor c=3.71357e-16
    c4911 (\91\:U \97\:U) capacitor c=1.69405e-17
    c4912 (\52\:GNDA \2\:net20) capacitor c=1.62593e-16
    c4913 (\134\:BG_REF \77\:S2) capacitor c=4.62525e-16
    c4914 (\1201\:GNDA \610\:GNDA) capacitor c=3.24909e-17
    c4915 (\22\:Vs \9\:vv) capacitor c=3.24822e-16
    c4916 (\914\:VDDA \1251\:GNDA) capacitor c=4.86978e-17
    c4917 (\14\:U \2\:net7) capacitor c=1.88331e-15
    c4918 (\133\:BG_REF \76\:S2) capacitor c=4.62525e-16
    c4919 (\95\:U \1362\:GNDA) capacitor c=5.25693e-16
    c4920 (\1383\:GNDA \1415\:GNDA) capacitor c=4.6967e-17
    c4921 (\2\:net31 \2\:net6) capacitor c=2.23847e-16
    c4922 (\71\:Vm1 \279\:VDDA) capacitor c=3.95881e-15
    c4923 (\647\:VDDA \527\:VDDA) capacitor c=7.6546e-16
    c4924 (\37\:S \67\:S2) capacitor c=7.37279e-16
    c4925 (\7\:U \1452\:GNDA) capacitor c=5.25176e-17
    c4926 (\107\:U \385\:GNDA) capacitor c=3.83457e-17
    c4927 (\1373\:GNDA \1374\:GNDA) capacitor c=4.12292e-16
    c4928 (\321\:VDDA \79\:BG_REF) capacitor c=2.84294e-16
    c4929 (\100\:BG_REF \279\:VDDA) capacitor c=7.75056e-16
    c4930 (\2\:net16 \31\:GNDA) capacitor c=1.55266e-15
    c4931 (\1335\:GNDA \1332\:GNDA) capacitor c=7.84056e-17
    c4932 (\9\:vv \31\:S2) capacitor c=2.85522e-17
    c4933 (\140\:Vm1 \279\:VDDA) capacitor c=3.52561e-16
    c4934 (\4\:S2 \44\:S2) capacitor c=5.30174e-16
    c4935 (\258\:VDDA \52\:BG_REF) capacitor c=5.28947e-16
    c4936 (\71\:U \896\:GNDA) capacitor c=5.42797e-16
    c4937 (\136\:BG_REF \1251\:GNDA) capacitor c=3.62465e-15
    c4938 (\117\:U \92\:U) capacitor c=4.16562e-16
    c4939 (\5\:Vo1 \550\:GNDA) capacitor c=4.22452e-17
    c4940 (\1509\:GNDA \684\:GNDA) capacitor c=5.65943e-16
    c4941 (\88\:GNDA \218\:GNDA) capacitor c=3.4417e-15
    c4942 (\170\:S \149\:S) capacitor c=8.38478e-16
    c4943 (\18\:U \77\:U) capacitor c=1.2352e-15
    c4944 (\90\:VDDA \25\:BG_REF) capacitor c=2.22142e-16
    c4945 (\124\:U \905\:GNDA) capacitor c=8.12854e-15
    c4946 (\34\:X \218\:GNDA) capacitor c=1.34796e-15
    c4947 (\9\:Vo1 \7\:Vo1) capacitor c=3.14415e-15
    c4948 (\67\:U \896\:GNDA) capacitor c=1.13234e-15
    c4949 (\103\:S \35\:Vo1) capacitor c=2.90655e-16
    c4950 (\20\:vv \365\:VDDA) capacitor c=3.31616e-17
    c4951 (\23\:U \959\:GNDA) capacitor c=1.3814e-16
    c4952 (\9\:U \1312\:GNDA) capacitor c=1.3814e-16
    c4953 (\203\:GNDA \634\:GNDA) capacitor c=3.47568e-16
    c4954 (\207\:GNDA \704\:GNDA) capacitor c=3.16606e-17
    c4955 (\1362\:GNDA \798\:GNDA) capacitor c=3.39571e-17
    c4956 (\54\:U \1215\:GNDA) capacitor c=9.66181e-17
    c4957 (\81\:Vm1 \279\:VDDA) capacitor c=3.95842e-15
    c4958 (\10\:BIAS \224\:Vm1) capacitor c=5.79507e-16
    c4959 (\12\:BG_REF \2\:vv) capacitor c=3.46495e-16
    c4960 (\118\:VDDA \23\:BG_REF) capacitor c=4.80342e-16
    c4961 (\43\:D1 \102\:S) capacitor c=1.14121e-15
    c4962 (\25\:BG_REF \9\:S) capacitor c=1.41855e-15
    c4963 (\203\:GNDA \443\:GNDA) capacitor c=2.19127e-15
    c4964 (\207\:S \279\:VDDA) capacitor c=2.8712e-15
    c4965 (\105\:S \35\:Vo1) capacitor c=3.34161e-16
    c4966 (\51\:U \738\:GNDA) capacitor c=5.23865e-17
    c4967 (\204\:S \604\:VDDA) capacitor c=2.63868e-15
    c4968 (\3\:GNDA \70\:GNDA) capacitor c=2.84043e-16
    c4969 (\218\:VDDA \279\:VDDA) capacitor c=3.28871e-16
    c4970 (\239\:S \15\:VDDA) capacitor c=1.34744e-17
    c4971 (\16\:vv \540\:VDDA) capacitor c=2.59934e-16
    c4972 (\102\:S2 \69\:BG_REF) capacitor c=1.11867e-17
    c4973 (\205\:GNDA \158\:GNDA) capacitor c=3.39571e-17
    c4974 (\84\:VDDA \83\:VDDA) capacitor c=2.06502e-16
    c4975 (\97\:Vm1 \98\:Vm1) capacitor c=6.50917e-16
    c4976 (\301\:VDDA \36\:S) capacitor c=5.29488e-16
    c4977 (\239\:VDDA \237\:VDDA) capacitor c=4.84335e-16
    c4978 (\59\:D1 \46\:Vo1) capacitor c=2.12909e-15
    c4979 (\960\:GNDA \1251\:GNDA) capacitor c=3.11265e-17
    c4980 (\27\:BG_REF \142\:VDDA) capacitor c=2.89826e-16
    c4981 (\130\:GNDA \129\:GNDA) capacitor c=4.26739e-16
    c4982 (\226\:VDDA \25\:BG_REF) capacitor c=3.17145e-16
    c4983 (\11\:GNDA \218\:GNDA) capacitor c=5.88395e-15
    c4984 (\85\:S \26\:D1) capacitor c=3.79479e-16
    c4985 (\207\:GNDA \1452\:GNDA) capacitor c=4.20154e-15
    c4986 (\1511\:GNDA \49\:Vo1) capacitor c=7.26196e-16
    c4987 (\43\:S \74\:S2) capacitor c=7.37279e-16
    c4988 (\27\:X \1114\:GNDA) capacitor c=3.54495e-17
    c4989 (\649\:VDDA \271\:Vm1) capacitor c=2.22584e-16
    c4990 (\102\:U \1122\:GNDA) capacitor c=8.85297e-17
    c4991 (\1543\:GNDA \139\:GNDA) capacitor c=2.38353e-16
    c4992 (\22\:vv \477\:VDDA) capacitor c=3.31616e-17
    c4993 (\16\:vv \379\:VDDA) capacitor c=3.31616e-17
    c4994 (\1518\:GNDA \55\:Vo1) capacitor c=4.37162e-17
    c4995 (\472\:VDDA \71\:BG_REF) capacitor c=1.56999e-16
    c4996 (\91\:Vm1 \279\:VDDA) capacitor c=3.95939e-15
    c4997 (\193\:GNDA \188\:GNDA) capacitor c=9.29257e-17
    c4998 (\25\:BG_REF \244\:VDDA) capacitor c=1.23247e-17
    c4999 (\29\:X \1138\:GNDA) capacitor c=3.5916e-17
    c5000 (\129\:S \127\:S) capacitor c=1.238e-15
    c5001 (\3\:BG_REF \7\:Vo1) capacitor c=2.57273e-16
    c5002 (\77\:S2 \534\:VDDA) capacitor c=1.39564e-17
    c5003 (\97\:S \95\:S) capacitor c=1.24168e-15
    c5004 (\133\:BG_REF \397\:VDDA) capacitor c=2.04887e-17
    c5005 (\205\:GNDA \28\:U) capacitor c=1.46275e-15
    c5006 (\34\:vv \279\:VDDA) capacitor c=5.73246e-15
    c5007 (\192\:Vm1 \354\:VDDA) capacitor c=4.79798e-16
    c5008 (\205\:S \665\:VDDA) capacitor c=2.56533e-16
    c5009 (\1527\:GNDA \57\:Vo1) capacitor c=4.79874e-17
    c5010 (\228\:VDDA \279\:VDDA) capacitor c=3.91235e-16
    c5011 (\1551\:GNDA \147\:GNDA) capacitor c=2.38353e-16
    c5012 (\98\:U \935\:GNDA) capacitor c=7.76061e-17
    c5013 (\896\:GNDA \659\:GNDA) capacitor c=3.6172e-17
    c5014 (\2\:net32 \2\:net11) capacitor c=4.47754e-17
    c5015 (\155\:S \149\:S) capacitor c=5.13517e-16
    c5016 (\7\:vv \367\:VDDA) capacitor c=3.31616e-17
    c5017 (\24\:BG_REF \279\:VDDA) capacitor c=1.15121e-16
    c5018 (\137\:BG_REF \555\:VDDA) capacitor c=2.30556e-17
    c5019 (\66\:U \1394\:GNDA) capacitor c=4.6967e-17
    c5020 (\43\:S2 \44\:S2) capacitor c=9.2674e-16
    c5021 (\69\:Vo1 \59\:D1) capacitor c=8.77535e-16
    c5022 (\24\:U \1029\:GNDA) capacitor c=4.6967e-17
    c5023 (\19\:Vo1 \128\:GNDA) capacitor c=3.1005e-16
    c5024 (\162\:VDDA \11\:S) capacitor c=1.2927e-16
    c5025 (\393\:VDDA \279\:VDDA) capacitor c=3.31143e-16
    c5026 (\10\:Y \12\:X) capacitor c=1.63806e-17
    c5027 (\12\:U \1401\:GNDA) capacitor c=5.82324e-17
    c5028 (\19\:S \75\:S2) capacitor c=7.37279e-16
    c5029 (\896\:GNDA \1452\:GNDA) capacitor c=3.45808e-17
    c5030 (\271\:Vm1 \76\:S2) capacitor c=4.64021e-16
    c5031 (\36\:U \1251\:GNDA) capacitor c=5.06676e-17
    c5032 (\33\:vv \62\:BG_REF) capacitor c=3.31616e-17
    c5033 (\103\:U \1218\:GNDA) capacitor c=4.6967e-17
    c5034 (\118\:Vm1 \126\:VDDA) capacitor c=3.44578e-16
    c5035 (\90\:U \203\:GNDA) capacitor c=1.10867e-15
    c5036 (\31\:Vo1 \102\:S) capacitor c=1.01219e-15
    c5037 (\896\:GNDA \1427\:GNDA) capacitor c=2.31665e-15
    c5038 (\62\:S \17\:D1) capacitor c=1.37888e-15
    c5039 (\236\:Vm1 \71\:S2) capacitor c=5.08078e-16
    c5040 (\410\:VDDA \415\:VDDA) capacitor c=4.75166e-16
    c5041 (\4\:vv \5\:S2) capacitor c=1.60829e-17
    c5042 (\901\:VDDA \279\:VDDA) capacitor c=3.87648e-15
    c5043 (\133\:BG_REF \39\:VDDA) capacitor c=1.03845e-17
    c5044 (\332\:VDDA \40\:S) capacitor c=5.28947e-16
    c5045 (\232\:VDDA \31\:BG_REF) capacitor c=3.17145e-16
    c5046 (\21\:S \279\:VDDA) capacitor c=8.29043e-16
    c5047 (\405\:VDDA \78\:BG_REF) capacitor c=3.89918e-17
    c5048 (\22\:vv \544\:VDDA) capacitor c=5.77594e-17
    c5049 (\70\:U \1033\:GNDA) capacitor c=3.54052e-16
    c5050 (\117\:U \1251\:GNDA) capacitor c=3.2732e-15
    c5051 (\225\:Vm1 \69\:S2) capacitor c=5.23191e-16
    c5052 (\69\:Vo1 \166\:S) capacitor c=5.43001e-17
    c5053 (\105\:U \1362\:GNDA) capacitor c=1.08435e-15
    c5054 (\1294\:GNDA \1309\:GNDA) capacitor c=3.14499e-16
    c5055 (\172\:S \102\:S) capacitor c=3.90455e-16
    c5056 (\102\:VDDA \1\:VDDA) capacitor c=1.05213e-15
    c5057 (\163\:VDDA \42\:BG_REF) capacitor c=5.28947e-16
    c5058 (\206\:S \540\:VDDA) capacitor c=1.22928e-16
    c5059 (\205\:GNDA \65\:U) capacitor c=7.93593e-17
    c5060 (\476\:GNDA \157\:GNDA) capacitor c=6.40312e-17
    c5061 (\43\:U \178\:GNDA) capacitor c=1.14364e-16
    c5062 (\540\:VDDA \534\:VDDA) capacitor c=4.93337e-16
    c5063 (\959\:GNDA \1251\:GNDA) capacitor c=3.22349e-17
    c5064 (\80\:U \1138\:GNDA) capacitor c=3.83594e-17
    c5065 (\182\:GNDA \183\:GNDA) capacitor c=4.05613e-16
    c5066 (\116\:U \1362\:GNDA) capacitor c=2.94061e-16
    c5067 (\320\:GNDA \331\:GNDA) capacitor c=4.6315e-17
    c5068 (\918\:VDDA \604\:VDDA) capacitor c=4.32771e-16
    c5069 (\20\:BG_REF \7\:Vo1) capacitor c=1.79865e-15
    c5070 (\205\:GNDA \188\:GNDA) capacitor c=3.39571e-17
    c5071 (\832\:VDDA \120\:BG_REF) capacitor c=7.24715e-16
    c5072 (\236\:S \103\:S2) capacitor c=2.22721e-16
    c5073 (\72\:S2 \7\:vv) capacitor c=2.25878e-15
    c5074 (\89\:U \1403\:GNDA) capacitor c=1.14364e-16
    c5075 (\1362\:GNDA \1218\:GNDA) capacitor c=2.24577e-15
    c5076 (\188\:GNDA \66\:U) capacitor c=3.72052e-17
    c5077 (\237\:S \77\:S2) capacitor c=1.31478e-16
    c5078 (\15\:BG_REF \218\:GNDA) capacitor c=9.13508e-16
    c5079 (\240\:S \32\:D1) capacitor c=2.24645e-16
    c5080 (\26\:D1 \149\:S) capacitor c=4.29883e-16
    c5081 (\76\:U \978\:GNDA) capacitor c=1.3814e-16
    c5082 (\74\:S2 \26\:vv) capacitor c=2.18056e-16
    c5083 (\63\:U \1195\:GNDA) capacitor c=1.3814e-16
    c5084 (\665\:VDDA \279\:VDDA) capacitor c=1.15657e-15
    c5085 (\251\:S \230\:GNDA) capacitor c=1.99523e-17
    c5086 (\39\:BG_REF \7\:vv) capacitor c=7.49403e-17
    c5087 (\32\:U \180\:GNDA) capacitor c=1.54869e-17
    c5088 (\65\:S2 \534\:VDDA) capacitor c=6.7184e-17
    c5089 (\154\:Vm1 \279\:VDDA) capacitor c=3.14134e-16
    c5090 (\160\:Vm1 \278\:VDDA) capacitor c=4.61668e-16
    c5091 (\95\:S2 \42\:S2) capacitor c=1.32406e-17
    c5092 (\27\:vv \481\:VDDA) capacitor c=3.31616e-17
    c5093 (\49\:U \1251\:GNDA) capacitor c=4.10562e-17
    c5094 (\711\:GNDA \1251\:GNDA) capacitor c=3.11265e-17
    c5095 (\47\:BG_REF \207\:S) capacitor c=6.28056e-16
    c5096 (\1345\:GNDA \1284\:GNDA) capacitor c=9.29257e-17
    c5097 (\544\:VDDA \105\:BG_REF) capacitor c=4.80867e-16
    c5098 (\51\:U \823\:GNDA) capacitor c=1.54869e-17
    c5099 (\1203\:GNDA \1099\:GNDA) capacitor c=4.6967e-17
    c5100 (\60\:U \1187\:GNDA) capacitor c=4.6967e-17
    c5101 (\7\:vv \10\:S2) capacitor c=4.48016e-17
    c5102 (\12\:vv \2\:vv) capacitor c=3.34962e-16
    c5103 (\220\:Vm1 \108\:Vm1) capacitor c=8.8327e-16
    c5104 (\92\:U \890\:GNDA) capacitor c=1.61797e-16
    c5105 (\31\:X \1133\:GNDA) capacitor c=1.3611e-15
    c5106 (\97\:U \712\:GNDA) capacitor c=1.14364e-16
    c5107 (\573\:VDDA \279\:VDDA) capacitor c=4.09761e-16
    c5108 (\198\:VDDA \46\:BG_REF) capacitor c=5.28947e-16
    c5109 (\364\:VDDA \63\:BG_REF) capacitor c=5.36988e-16
    c5110 (\413\:VDDA \279\:VDDA) capacitor c=3.48435e-16
    c5111 (\94\:U \413\:GNDA) capacitor c=9.1072e-17
    c5112 (\183\:S \102\:S) capacitor c=9.22255e-16
    c5113 (\225\:Vm1 \544\:VDDA) capacitor c=4.78543e-16
    c5114 (\1274\:GNDA \1297\:GNDA) capacitor c=3.15482e-16
    c5115 (\26\:vv \159\:VDDA) capacitor c=3.31616e-17
    c5116 (\12\:Vs \207\:GNDA) capacitor c=7.35754e-17
    c5117 (\73\:S \71\:S) capacitor c=1.23567e-15
    c5118 (\156\:VDDA \9\:S) capacitor c=1.2927e-16
    c5119 (\619\:VDDA \279\:VDDA) capacitor c=2.98283e-16
    c5120 (\52\:D1 \149\:S) capacitor c=3.63288e-16
    c5121 (\28\:Vo1 \102\:S) capacitor c=7.41749e-16
    c5122 (\126\:Vm1 \193\:VDDA) capacitor c=3.39738e-16
    c5123 (\120\:Vm1 \98\:VDDA) capacitor c=3.22227e-16
    c5124 (\245\:VDDA \279\:VDDA) capacitor c=3.34076e-16
    c5125 (\81\:U \1054\:GNDA) capacitor c=4.6967e-17
    c5126 (\218\:GNDA \461\:GNDA) capacitor c=1.16084e-17
    c5127 (\25\:vv \42\:S) capacitor c=3.40015e-17
    c5128 (\18\:Vs \12\:vv) capacitor c=5.3072e-17
    c5129 (\76\:S2 \553\:VDDA) capacitor c=4.76774e-17
    c5130 (\860\:VDDA \270\:Vm1) capacitor c=6.77484e-16
    c5131 (\8\:U \1452\:GNDA) capacitor c=1.10514e-16
    c5132 (\232\:VDDA \26\:S) capacitor c=1.23003e-16
    c5133 (\17\:U \745\:GNDA) capacitor c=3.54052e-16
    c5134 (\26\:U \1032\:GNDA) capacitor c=5.82324e-17
    c5135 (\16\:BIAS \521\:GNDA) capacitor c=7.43229e-16
    c5136 (\46\:BG_REF \279\:VDDA) capacitor c=1.15424e-16
    c5137 (\32\:BIAS \521\:GNDA) capacitor c=1.39202e-16
    c5138 (\207\:GNDA \954\:GNDA) capacitor c=3.1596e-17
    c5139 (\59\:GNDA \4\:GNDA) capacitor c=4.83976e-16
    c5140 (\48\:Vm1 \279\:VDDA) capacitor c=3.92626e-15
    c5141 (\1274\:GNDA \1201\:GNDA) capacitor c=9.29257e-17
    c5142 (\39\:GNDA \218\:GNDA) capacitor c=7.34655e-15
    c5143 (\591\:VDDA \279\:VDDA) capacitor c=5.95799e-16
    c5144 (\76\:U \975\:GNDA) capacitor c=7.76061e-17
    c5145 (\736\:GNDA \203\:GNDA) capacitor c=2.87726e-16
    c5146 (\499\:VDDA \67\:VDDA) capacitor c=1.06105e-15
    c5147 (\230\:GNDA \163\:S) capacitor c=2.06187e-16
    c5148 (\426\:VDDA \220\:VDDA) capacitor c=6.05841e-16
    c5149 (\99\:U \938\:GNDA) capacitor c=5.64553e-17
    c5150 (\47\:U \185\:GNDA) capacitor c=1.26141e-15
    c5151 (\55\:U \1251\:GNDA) capacitor c=7.1556e-17
    c5152 (\39\:U \168\:GNDA) capacitor c=1.14364e-16
    c5153 (\896\:GNDA \203\:GNDA) capacitor c=7.22969e-16
    c5154 (\133\:BG_REF \43\:VDDA) capacitor c=1.03845e-17
    c5155 (\222\:VDDA \272\:Vm1) capacitor c=3.9399e-16
    c5156 (\91\:U \753\:GNDA) capacitor c=1.54869e-17
    c5157 (\236\:Vm1 \583\:VDDA) capacitor c=8.31376e-16
    c5158 (\202\:Vm1 \387\:VDDA) capacitor c=4.65703e-16
    c5159 (\276\:Vm1 \20\:vv) capacitor c=3.82015e-16
    c5160 (\18\:vv \453\:VDDA) capacitor c=3.31616e-17
    c5161 (\81\:U \1138\:GNDA) capacitor c=1.09005e-16
    c5162 (\25\:Vo1 \71\:S) capacitor c=3.34161e-16
    c5163 (\52\:U \58\:U) capacitor c=1.3175e-15
    c5164 (\31\:D2 \87\:BG_REF) capacitor c=1.45311e-16
    c5165 (\265\:VDDA \279\:VDDA) capacitor c=3.99886e-16
    c5166 (\905\:GNDA \1152\:GNDA) capacitor c=4.80092e-15
    c5167 (\168\:Vm1 \302\:VDDA) capacitor c=3.50869e-16
    c5168 (\206\:S \55\:VDDA) capacitor c=1.03845e-17
    c5169 (\84\:S2 \44\:S2) capacitor c=1.1337e-16
    c5170 (\517\:VDDA \516\:VDDA) capacitor c=2.16884e-16
    c5171 (\34\:X \25\:GNDA) capacitor c=2.59714e-16
    c5172 (\692\:VDDA \89\:BG_REF) capacitor c=6.34989e-16
    c5173 (\2\:net2 \2\:net33) capacitor c=2.49757e-16
    c5174 (\34\:vv \270\:Vm1) capacitor c=1.61097e-16
    c5175 (\71\:U \1137\:GNDA) capacitor c=3.52726e-16
    c5176 (\201\:VDDA \272\:Vm1) capacitor c=2.18118e-16
    c5177 (\90\:S2 \62\:S2) capacitor c=5.23778e-16
    c5178 (\104\:BG_REF \68\:S2) capacitor c=4.62525e-16
    c5179 (\116\:Vm1 \144\:VDDA) capacitor c=4.73118e-16
    c5180 (\235\:S \579\:VDDA) capacitor c=1.2299e-16
    c5181 (\1405\:GNDA \1377\:GNDA) capacitor c=1.21998e-15
    c5182 (\842\:GNDA \1251\:GNDA) capacitor c=4.19575e-17
    c5183 (\58\:Vm1 \279\:VDDA) capacitor c=3.92461e-15
    c5184 (\261\:VDDA \28\:S) capacitor c=1.22443e-16
    c5185 (\109\:GNDA \218\:GNDA) capacitor c=8.18503e-15
    c5186 (\874\:GNDA \823\:GNDA) capacitor c=4.6967e-17
    c5187 (\905\:GNDA \158\:GNDA) capacitor c=2.35258e-16
    c5188 (\18\:U \896\:GNDA) capacitor c=1.81002e-15
    c5189 (\35\:X \203\:GNDA) capacitor c=7.27028e-16
    c5190 (\35\:D1 \14\:X) capacitor c=6.0212e-17
    c5191 (\401\:GNDA \732\:GNDA) capacitor c=4.28545e-16
    c5192 (\192\:GNDA \983\:GNDA) capacitor c=3.40431e-17
    c5193 (\35\:D1 \114\:S) capacitor c=2.29969e-17
    c5194 (\323\:VDDA \61\:BG_REF) capacitor c=1.35399e-17
    c5195 (\2\:net29 \218\:GNDA) capacitor c=3.89334e-16
    c5196 (\72\:S2 \22\:vv) capacitor c=4.21041e-15
    c5197 (\132\:Vm1 \199\:VDDA) capacitor c=3.39738e-16
    c5198 (\3\:U \1236\:GNDA) capacitor c=6.78232e-17
    c5199 (\53\:BG_REF \279\:VDDA) capacitor c=7.1071e-16
    c5200 (\896\:GNDA \835\:GNDA) capacitor c=3.56169e-15
    c5201 (\81\:S \102\:S) capacitor c=5.50867e-16
    c5202 (\35\:X \1362\:GNDA) capacitor c=7.41292e-16
    c5203 (\268\:S \53\:D1) capacitor c=1.84346e-15
    c5204 (\98\:U \938\:GNDA) capacitor c=1.3814e-16
    c5205 (\20\:vv \38\:S) capacitor c=3.40015e-17
    c5206 (\46\:U \506\:GNDA) capacitor c=1.3814e-16
    c5207 (\815\:GNDA \1251\:GNDA) capacitor c=9.32576e-16
    c5208 (\1535\:GNDA \21\:Vs) capacitor c=1.78016e-16
    c5209 (\26\:S \279\:VDDA) capacitor c=1.67328e-16
    c5210 (\238\:S \397\:VDDA) capacitor c=1.23137e-17
    c5211 (\33\:vv \1251\:GNDA) capacitor c=1.55358e-16
    c5212 (\21\:vv \260\:VDDA) capacitor c=3.31616e-17
    c5213 (\1312\:GNDA \1309\:GNDA) capacitor c=7.84056e-17
    c5214 (\33\:U \46\:U) capacitor c=1.12841e-16
    c5215 (\94\:VDDA \279\:VDDA) capacitor c=3.86108e-16
    c5216 (\21\:vv \22\:S) capacitor c=3.40015e-17
    c5217 (\437\:GNDA \443\:GNDA) capacitor c=2.73399e-16
    c5218 (\6\:S \102\:S) capacitor c=4.05109e-16
    c5219 (\669\:GNDA \671\:GNDA) capacitor c=5.78226e-17
    c5220 (\29\:D2 \44\:S2) capacitor c=1.09262e-15
    c5221 (\192\:GNDA \1049\:GNDA) capacitor c=1.33732e-17
    c5222 (\17\:S2 \31\:D2) capacitor c=1.40612e-16
    c5223 (\156\:Vm1 \45\:Vm1) capacitor c=1.82432e-16
    c5224 (\33\:S2 \6\:S2) capacitor c=2.34133e-16
    c5225 (\22\:vv \457\:VDDA) capacitor c=3.31616e-17
    c5226 (\17\:D1 \2\:X) capacitor c=6.0212e-17
    c5227 (\11\:S \75\:S2) capacitor c=1.53949e-15
    c5228 (\194\:S \50\:S) capacitor c=1.71857e-15
    c5229 (\168\:Vm1 \279\:VDDA) capacitor c=3.73713e-16
    c5230 (\33\:vv \338\:VDDA) capacitor c=3.31616e-17
    c5231 (\914\:VDDA \204\:S) capacitor c=2.22872e-17
    c5232 (\203\:GNDA \620\:GNDA) capacitor c=3.89577e-16
    c5233 (\207\:GNDA \25\:Vs) capacitor c=5.76474e-17
    c5234 (\826\:GNDA \783\:GNDA) capacitor c=6.40312e-17
    c5235 (\1505\:GNDA \902\:GNDA) capacitor c=6.35771e-16
    c5236 (\44\:Vo1 \2\:Vo1) capacitor c=1.22666e-17
    c5237 (\89\:BG_REF \591\:VDDA) capacitor c=1.04864e-15
    c5238 (\82\:U \1256\:GNDA) capacitor c=8.85297e-17
    c5239 (\133\:BG_REF \47\:VDDA) capacitor c=1.03845e-17
    c5240 (\108\:VDDA \27\:BG_REF) capacitor c=3.86661e-16
    c5241 (\402\:VDDA \76\:BG_REF) capacitor c=5.28406e-16
    c5242 (\1088\:GNDA \1117\:GNDA) capacitor c=2.97714e-16
    c5243 (\203\:GNDA \391\:GNDA) capacitor c=2.35677e-15
    c5244 (\134\:BG_REF \23\:VDDA) capacitor c=1.03845e-17
    c5245 (\207\:GNDA \1309\:GNDA) capacitor c=2.24573e-15
    c5246 (\905\:GNDA \1181\:GNDA) capacitor c=3.62839e-15
    c5247 (\108\:VDDA \279\:VDDA) capacitor c=2.52177e-16
    c5248 (\684\:GNDA \149\:S) capacitor c=8.81705e-16
    c5249 (\205\:GNDA \823\:GNDA) capacitor c=2.31665e-15
    c5250 (\207\:S \68\:S2) capacitor c=1.31478e-16
    c5251 (\849\:GNDA \684\:GNDA) capacitor c=5.50261e-16
    c5252 (\97\:U \756\:GNDA) capacitor c=5.82324e-17
    c5253 (\30\:U \1024\:GNDA) capacitor c=1.98382e-16
    c5254 (\214\:Vm1 \476\:VDDA) capacitor c=2.24131e-16
    c5255 (\45\:U \594\:VDDA) capacitor c=1.3715e-16
    c5256 (\1215\:GNDA \83\:U) capacitor c=3.72052e-17
    c5257 (\23\:U \956\:GNDA) capacitor c=7.76061e-17
    c5258 (\1362\:GNDA \397\:GNDA) capacitor c=1.33732e-17
    c5259 (\1137\:GNDA \1172\:GNDA) capacitor c=1.62259e-16
    c5260 (\53\:U \1079\:GNDA) capacitor c=1.54869e-17
    c5261 (\550\:GNDA \9\:BG_REF) capacitor c=1.17673e-15
    c5262 (\39\:BG_REF \178\:VDDA) capacitor c=1.23738e-17
    c5263 (\16\:vv \342\:VDDA) capacitor c=3.40015e-17
    c5264 (\18\:Vs \1251\:GNDA) capacitor c=1.53549e-16
    c5265 (\124\:GNDA \1251\:GNDA) capacitor c=9.25965e-16
    c5266 (\6\:U \1238\:GNDA) capacitor c=4.10562e-17
    c5267 (\286\:VDDA \279\:VDDA) capacitor c=3.33085e-16
    c5268 (\188\:Vm1 \366\:VDDA) capacitor c=3.47479e-16
    c5269 (\29\:U \36\:U) capacitor c=1.13692e-16
    c5270 (\205\:GNDA \58\:U) capacitor c=3.30194e-16
    c5271 (\25\:Vo1 \102\:S) capacitor c=1.12615e-15
    c5272 (\896\:GNDA \17\:U) capacitor c=1.46032e-15
    c5273 (\30\:S \279\:VDDA) capacitor c=1.67313e-16
    c5274 (\23\:S2 \44\:S2) capacitor c=2.60087e-17
    c5275 (\2\:net22 \2\:net40) capacitor c=1.56827e-16
    c5276 (\12\:vv \25\:S2) capacitor c=1.43879e-17
    c5277 (\20\:U \207\:GNDA) capacitor c=2.47694e-16
    c5278 (\122\:VDDA \279\:VDDA) capacitor c=2.95619e-16
    c5279 (\48\:Vo1 \1507\:GNDA) capacitor c=2.40811e-16
    c5280 (\77\:U \839\:GNDA) capacitor c=4.6967e-17
    c5281 (\333\:VDDA \65\:BG_REF) capacitor c=3.26283e-16
    c5282 (\28\:vv \125\:VDDA) capacitor c=3.31616e-17
    c5283 (\47\:Vm1 \48\:Vm1) capacitor c=6.45e-16
    c5284 (\554\:VDDA \534\:VDDA) capacitor c=4.27763e-16
    c5285 (\227\:S \495\:VDDA) capacitor c=2.04858e-17
    c5286 (\243\:VDDA \51\:BG_REF) capacitor c=1.56294e-17
    c5287 (\720\:VDDA \297\:Vm1) capacitor c=6.78494e-16
    c5288 (\27\:vv \461\:VDDA) capacitor c=3.31616e-17
    c5289 (\212\:Vm1 \58\:VDDA) capacitor c=2.90616e-16
    c5290 (\58\:S \22\:Vo1) capacitor c=5.64929e-16
    c5291 (\497\:VDDA \81\:BG_REF) capacitor c=1.89197e-16
    c5292 (\863\:VDDA \279\:VDDA) capacitor c=6.41987e-16
    c5293 (\16\:Y \102\:S) capacitor c=1.13739e-15
    c5294 (\300\:VDDA \279\:VDDA) capacitor c=4.01187e-16
    c5295 (\16\:GNDA \15\:GNDA) capacitor c=7.67775e-17
    c5296 (\1335\:GNDA \1314\:GNDA) capacitor c=4.83033e-17
    c5297 (\138\:BG_REF \573\:VDDA) capacitor c=2.92071e-16
    c5298 (\337\:VDDA \79\:BG_REF) capacitor c=3.26283e-16
    c5299 (\183\:S \149\:S) capacitor c=5.31448e-16
    c5300 (\21\:S2 \4\:S2) capacitor c=2.15319e-16
    c5301 (\204\:Vm1 \405\:VDDA) capacitor c=3.4614e-16
    c5302 (\235\:S \26\:vv) capacitor c=5.23282e-16
    c5303 (\39\:BG_REF \213\:VDDA) capacitor c=1.02632e-17
    c5304 (\106\:Vm1 \279\:VDDA) capacitor c=3.92678e-15
    c5305 (\2\:net14 \5\:GNDA) capacitor c=7.20899e-17
    c5306 (\25\:BG_REF \279\:VDDA) capacitor c=1.88281e-15
    c5307 (\352\:VDDA \65\:BG_REF) capacitor c=2.87197e-16
    c5308 (BG_REF \7\:Vo1) capacitor c=2.09596e-16
    c5309 (\835\:VDDA \102\:S2) capacitor c=1.78853e-16
    c5310 (\8\:GNDA \2\:net38) capacitor c=2.43667e-16
    c5311 (\487\:VDDA \279\:VDDA) capacitor c=2.51763e-16
    c5312 (\111\:BG_REF \61\:VDDA) capacitor c=1.33555e-17
    c5313 (\103\:S2 \53\:BG_REF) capacitor c=1.11867e-17
    c5314 (\617\:VDDA \70\:VDDA) capacitor c=7.67705e-16
    c5315 (\34\:vv \54\:BG_REF) capacitor c=3.31616e-17
    c5316 (\7\:vv \41\:S) capacitor c=1.3147e-17
    c5317 (\19\:U \1034\:GNDA) capacitor c=1.51415e-16
    c5318 (\9\:vv \11\:D2) capacitor c=2.85522e-17
    c5319 (\368\:VDDA \66\:BG_REF) capacitor c=3.8451e-17
    c5320 (\47\:D1 \102\:S) capacitor c=1.35398e-15
    c5321 (\24\:U \928\:GNDA) capacitor c=1.09512e-16
    c5322 (\235\:S \112\:VDDA) capacitor c=1.00279e-17
    c5323 (\7\:vv \332\:VDDA) capacitor c=3.31616e-17
    c5324 (\874\:GNDA \818\:GNDA) capacitor c=1.21533e-15
    c5325 (\17\:Vo1 \684\:GNDA) capacitor c=6.37317e-16
    c5326 (\1226\:GNDA \1302\:GNDA) capacitor c=3.19128e-16
    c5327 (\207\:S \104\:VDDA) capacitor c=2.04887e-17
    c5328 (\2\:net37 \52\:GNDA) capacitor c=9.446e-16
    c5329 (\72\:U \1237\:GNDA) capacitor c=3.54052e-16
    c5330 (\17\:vv \131\:VDDA) capacitor c=3.36913e-17
    c5331 (\2\:net15 \218\:GNDA) capacitor c=4.70689e-16
    c5332 (\115\:S \36\:D1) capacitor c=6.24816e-16
    c5333 (\172\:Vm1 \279\:VDDA) capacitor c=2.28752e-16
    c5334 (\170\:Vm1 \59\:Vm1) capacitor c=1.83865e-16
    c5335 (\25\:vv \334\:VDDA) capacitor c=3.31616e-17
    c5336 (\896\:GNDA \746\:GNDA) capacitor c=3.39571e-17
    c5337 (\1362\:GNDA \890\:GNDA) capacitor c=3.74074e-15
    c5338 (\36\:S \279\:VDDA) capacitor c=1.67297e-16
    c5339 (\207\:S \587\:VDDA) capacitor c=1.2299e-16
    c5340 (\73\:S2 \24\:vv) capacitor c=4.41346e-15
    c5341 (\1\:BG_REF \7\:Vo1) capacitor c=5.323e-16
    c5342 (\86\:S2 \7\:Vs) capacitor c=3.70894e-17
    c5343 (\21\:Vs \19\:D2) capacitor c=8.06502e-16
    c5344 (\23\:D2 \47\:S2) capacitor c=6.43399e-16
    c5345 (\110\:Vm1 \279\:VDDA) capacitor c=6.11746e-16
    c5346 (\1048\:GNDA \1049\:GNDA) capacitor c=4.12292e-16
    c5347 (\40\:GNDA \218\:GNDA) capacitor c=5.59904e-15
    c5348 (\34\:D2 \809\:GNDA) capacitor c=5.8392e-16
    c5349 (\21\:vv \748\:VDDA) capacitor c=6.18342e-17
    c5350 (\509\:VDDA \279\:VDDA) capacitor c=3.77935e-16
    c5351 (\205\:GNDA \1421\:GNDA) capacitor c=5.52885e-15
    c5352 (\561\:GNDA \944\:GNDA) capacitor c=2.99672e-16
    c5353 (\2\:Vo1 \1251\:GNDA) capacitor c=3.62094e-16
    c5354 (\116\:VDDA \15\:VDDA) capacitor c=1.05216e-15
    c5355 (\12\:U \1398\:GNDA) capacitor c=1.3611e-15
    c5356 (\112\:Vm1 \120\:VDDA) capacitor c=3.44578e-16
    c5357 (\39\:BG_REF \248\:VDDA) capacitor c=1.23247e-17
    c5358 (\2\:net3 \2\:net30) capacitor c=4.58734e-17
    c5359 (\369\:VDDA \68\:BG_REF) capacitor c=5.28947e-16
    c5360 (\271\:Vm1 \279\:VDDA) capacitor c=2.90568e-15
    c5361 (\69\:GNDA \218\:GNDA) capacitor c=1.23217e-15
    c5362 (\649\:VDDA \33\:vv) capacitor c=3.67035e-16
    c5363 (\648\:GNDA \461\:GNDA) capacitor c=2.01816e-16
    c5364 (\57\:U \968\:GNDA) capacitor c=7.76061e-17
    c5365 (\239\:S \222\:VDDA) capacitor c=1.23137e-17
    c5366 (\64\:U \1187\:GNDA) capacitor c=4.6967e-17
    c5367 (\95\:S \27\:D1) capacitor c=2.90655e-16
    c5368 (\1518\:GNDA \14\:D1) capacitor c=7.21139e-16
    c5369 (\35\:X \1172\:GNDA) capacitor c=2.6036e-16
    c5370 (\182\:Vm1 \279\:VDDA) capacitor c=3.74426e-16
    c5371 (\84\:U \1355\:GNDA) capacitor c=5.76316e-17
    c5372 (\52\:U \1006\:GNDA) capacitor c=1.0229e-16
    c5373 (\6\:X \102\:S) capacitor c=2.13353e-15
    c5374 (\25\:D2 \44\:S2) capacitor c=8.81664e-16
    c5375 (\272\:Vm1 \573\:VDDA) capacitor c=3.9794e-16
    c5376 (\513\:VDDA \121\:BG_REF) capacitor c=2.22142e-16
    c5377 (\896\:GNDA \7\:U) capacitor c=1.46032e-15
    c5378 (\34\:vv \303\:VDDA) capacitor c=3.31616e-17
    c5379 (\1362\:GNDA \108\:U) capacitor c=7.93593e-17
    c5380 (\110\:Vm1 \138\:VDDA) capacitor c=4.73118e-16
    c5381 (\6\:Y \6\:X) capacitor c=6.73517e-16
    c5382 (\12\:vv \22\:S2) capacitor c=1.43879e-17
    c5383 (\158\:GNDA \160\:GNDA) capacitor c=3.15482e-16
    c5384 (\641\:VDDA \20\:vv) capacitor c=3.67505e-16
    c5385 (\93\:U \425\:GNDA) capacitor c=1.98382e-16
    c5386 (\73\:U \1332\:GNDA) capacitor c=2.63004e-16
    c5387 (\34\:vv \901\:VDDA) capacitor c=2.99977e-16
    c5388 (\436\:VDDA \279\:VDDA) capacitor c=7.24954e-15
    c5389 (\4\:U \896\:GNDA) capacitor c=1.8234e-15
    c5390 (\23\:S2 \3\:Vs) capacitor c=5.88198e-16
    c5391 (\896\:GNDA \80\:U) capacitor c=7.51019e-17
    c5392 (\614\:VDDA \279\:VDDA) capacitor c=6.27519e-16
    c5393 (\40\:Vo1 \38\:Vo1) capacitor c=1.24501e-15
    c5394 (\809\:GNDA \521\:GNDA) capacitor c=5.88366e-17
    c5395 (\19\:Vs \140\:GNDA) capacitor c=1.21939e-16
    c5396 (\581\:VDDA \534\:VDDA) capacitor c=2.94367e-16
    c5397 (\659\:GNDA \748\:GNDA) capacitor c=3.40381e-16
    c5398 (\78\:S2 \12\:S2) capacitor c=1.89136e-15
    c5399 (\110\:BG_REF \226\:S) capacitor c=1.31478e-16
    c5400 (\7\:S2 \44\:S2) capacitor c=8.24658e-17
    c5401 (\896\:GNDA \1238\:GNDA) capacitor c=3.76983e-15
    c5402 (\1362\:GNDA \84\:U) capacitor c=1.46276e-15
    c5403 (\254\:S \102\:S) capacitor c=5.02947e-16
    c5404 (\121\:BG_REF \279\:VDDA) capacitor c=9.52457e-16
    c5405 (\22\:S2 \12\:BG_REF) capacitor c=5.15583e-17
    c5406 (\297\:Vm1 \19\:vv) capacitor c=3.1837e-16
    c5407 (\794\:GNDA \745\:GNDA) capacitor c=6.40312e-17
    c5408 (\319\:VDDA \279\:VDDA) capacitor c=3.35043e-16
    c5409 (\237\:S \98\:VDDA) capacitor c=1.06321e-17
    c5410 (\40\:Vo1 \102\:S) capacitor c=8.97905e-16
    c5411 (\19\:VDDA \279\:VDDA) capacitor c=3.94382e-15
    c5412 (\136\:Vm1 \226\:VDDA) capacitor c=3.384e-16
    c5413 (\35\:X \94\:U) capacitor c=8.24529e-17
    c5414 (\194\:S \102\:S) capacitor c=5.28433e-16
    c5415 (\40\:S \279\:VDDA) capacitor c=1.67343e-16
    c5416 (\2\:net22 \40\:GNDA) capacitor c=2.98908e-15
    c5417 (\124\:Vm1 \15\:Vm1) capacitor c=1.05798e-15
    c5418 (\21\:Vs \535\:GNDA) capacitor c=3.07593e-17
    c5419 (\17\:vv \89\:BG_REF) capacitor c=5.12323e-16
    c5420 (\204\:S \614\:VDDA) capacitor c=5.76098e-16
    c5421 (\168\:VDDA \279\:VDDA) capacitor c=3.4975e-16
    c5422 (\116\:U \218\:GNDA) capacitor c=5.5421e-15
    c5423 (\52\:U \207\:GNDA) capacitor c=2.37443e-15
    c5424 (\25\:BG_REF \5\:VDDA) capacitor c=3.03102e-17
    c5425 (\723\:VDDA \67\:S2) capacitor c=1.65576e-16
    c5426 (\1300\:GNDA \1297\:GNDA) capacitor c=8.23837e-17
    c5427 (\905\:GNDA \1466\:GNDA) capacitor c=5.54487e-15
    c5428 (\15\:Vs \95\:S2) capacitor c=7.62019e-16
    c5429 (\203\:GNDA \94\:U) capacitor c=1.67921e-15
    c5430 (\20\:vv \330\:VDDA) capacitor c=3.31616e-17
    c5431 (\344\:GNDA \230\:GNDA) capacitor c=1.13219e-16
    c5432 (\55\:Vo1 \684\:GNDA) capacitor c=4.84486e-16
    c5433 (\72\:U \1256\:GNDA) capacitor c=1.54869e-17
    c5434 (\206\:S \503\:VDDA) capacitor c=1.06321e-17
    c5435 (\92\:S2 \44\:S2) capacitor c=7.24568e-17
    c5436 (\653\:VDDA \614\:VDDA) capacitor c=3.13116e-16
    c5437 (\278\:VDDA \277\:VDDA) capacitor c=1.82419e-16
    c5438 (\397\:GNDA \732\:GNDA) capacitor c=9.57673e-17
    c5439 (\330\:GNDA \331\:GNDA) capacitor c=6.3759e-17
    c5440 (\12\:BG_REF \44\:S2) capacitor c=9.60048e-16
    c5441 (\625\:VDDA \78\:VDDA) capacitor c=2.28848e-16
    c5442 (\236\:S \279\:VDDA) capacitor c=2.79669e-15
    c5443 (\33\:X \1251\:GNDA) capacitor c=8.26534e-16
    c5444 (\158\:GNDA \56\:U) capacitor c=3.72052e-17
    c5445 (\275\:Vm1 \540\:VDDA) capacitor c=4.6663e-16
    c5446 (\14\:U \116\:GNDA) capacitor c=8.32829e-16
    c5447 (\25\:D2 \55\:S2) capacitor c=6.84913e-17
    c5448 (\28\:vv \20\:S) capacitor c=3.40015e-17
    c5449 (\279\:S \17\:D1) capacitor c=2.0674e-16
    c5450 (\15\:S \212\:VDDA) capacitor c=1.68039e-17
    c5451 (\74\:VDDA \73\:VDDA) capacitor c=2.12022e-16
    c5452 (\207\:GNDA \1006\:GNDA) capacitor c=3.77096e-15
    c5453 (\35\:U \784\:GNDA) capacitor c=4.10562e-17
    c5454 (\335\:VDDA \42\:S) capacitor c=1.21854e-16
    c5455 (\2\:Y \102\:S) capacitor c=3.37058e-15
    c5456 (\92\:S2 \23\:D2) capacitor c=3.09326e-16
    c5457 (\457\:VDDA \477\:VDDA) capacitor c=5.18716e-16
    c5458 (\68\:S2 \106\:VDDA) capacitor c=1.2312e-17
    c5459 (\116\:BG_REF \534\:VDDA) capacitor c=2.67775e-17
    c5460 (\132\:Vm1 \279\:VDDA) capacitor c=3.70454e-16
    c5461 (\73\:S2 \804\:VDDA) capacitor c=4.01714e-16
    c5462 (\28\:U \35\:U) capacitor c=1.69405e-17
    c5463 (\88\:U \1403\:GNDA) capacitor c=3.73689e-17
    c5464 (\1113\:GNDA \1133\:GNDA) capacitor c=1.17563e-16
    c5465 (\12\:D2 \44\:S2) capacitor c=6.1777e-16
    c5466 (\29\:D2 \1251\:GNDA) capacitor c=5.14288e-16
    c5467 (\715\:GNDA \1251\:GNDA) capacitor c=1.69131e-16
    c5468 (\207\:GNDA \203\:GNDA) capacitor c=8.15448e-16
    c5469 (\539\:GNDA \2\:Vo1) capacitor c=1.92412e-17
    c5470 (\216\:S \90\:VDDA) capacitor c=1.06321e-17
    c5471 (\1195\:GNDA \1192\:GNDA) capacitor c=7.84056e-17
    c5472 (\102\:S2 \279\:VDDA) capacitor c=2.82277e-15
    c5473 (\5\:U \1233\:GNDA) capacitor c=8.85297e-17
    c5474 (\27\:U \818\:GNDA) capacitor c=2.78212e-17
    c5475 (\22\:Vo1 \69\:S) capacitor c=3.03027e-16
    c5476 (\104\:U \363\:GNDA) capacitor c=5.76316e-17
    c5477 (\178\:Vm1 \333\:VDDA) capacitor c=3.49531e-16
    c5478 (\343\:VDDA \279\:VDDA) capacitor c=3.49532e-16
    c5479 (\24\:U \956\:GNDA) capacitor c=1.29529e-15
    c5480 (\222\:S \72\:S2) capacitor c=3.63261e-15
    c5481 (\33\:vv \87\:BG_REF) capacitor c=3.57828e-16
    c5482 (\333\:VDDA \39\:S) capacitor c=1.27935e-16
    c5483 (\36\:U \165\:GNDA) capacitor c=7.76061e-17
    c5484 (\2\:net17 \218\:GNDA) capacitor c=3.9307e-16
    c5485 (\61\:U \1265\:GNDA) capacitor c=1.54869e-17
    c5486 (\192\:GNDA \1152\:GNDA) capacitor c=3.40431e-17
    c5487 (\97\:S \102\:S) capacitor c=5.47779e-16
    c5488 (\103\:S2 \114\:VDDA) capacitor c=1.23137e-17
    c5489 (\62\:S \15\:D1) capacitor c=3.34161e-16
    c5490 (\21\:D2 \1551\:GNDA) capacitor c=5.97121e-16
    c5491 (\64\:BG_REF \279\:VDDA) capacitor c=1.15424e-16
    c5492 (\52\:D1 \102\:S) capacitor c=1.07996e-15
    c5493 (\3\:D1 \1251\:GNDA) capacitor c=2.02238e-15
    c5494 (\27\:Vs \1251\:GNDA) capacitor c=6.67935e-16
    c5495 (\63\:U \1167\:GNDA) capacitor c=3.77148e-17
    c5496 (\132\:GNDA \1251\:GNDA) capacitor c=9.16821e-16
    c5497 (\133\:BG_REF \306\:VDDA) capacitor c=1.03669e-17
    c5498 (\77\:S2 \138\:BG_REF) capacitor c=4.92429e-16
    c5499 (\179\:VDDA \279\:VDDA) capacitor c=3.30782e-16
    c5500 (\10\:D2 \1251\:GNDA) capacitor c=1.18738e-15
    c5501 (\768\:GNDA \3\:Vo1) capacitor c=8.75631e-17
    c5502 (\230\:GNDA \332\:GNDA) capacitor c=1.96359e-17
    c5503 (\203\:GNDA \610\:GNDA) capacitor c=1.491e-16
    c5504 (\712\:GNDA \659\:GNDA) capacitor c=9.29257e-17
    c5505 (\554\:VDDA \279\:VDDA) capacitor c=3.47301e-16
    c5506 (\192\:GNDA \870\:GNDA) capacitor c=3.24386e-15
    c5507 (\549\:GNDA \1251\:GNDA) capacitor c=1.58422e-15
    c5508 (\69\:S2 \75\:BG_REF) capacitor c=1.11867e-17
    c5509 (\118\:U \366\:GNDA) capacitor c=2.80383e-17
    c5510 (\22\:vv \279\:VDDA) capacitor c=2.80534e-15
    c5511 (\207\:GNDA \21\:U) capacitor c=7.93593e-17
    c5512 (\110\:GNDA \2\:net10) capacitor c=2.48913e-17
    c5513 (\33\:S2 \12\:D2) capacitor c=3.40333e-16
    c5514 (\196\:Vm1 \279\:VDDA) capacitor c=3.70995e-16
    c5515 (\166\:Vm1 \55\:Vm1) capacitor c=1.06747e-15
    c5516 (\2\:net3 \218\:GNDA) capacitor c=4.12671e-16
    c5517 (\5\:BIAS \1251\:GNDA) capacitor c=1.44347e-15
    c5518 (\815\:GNDA \203\:GNDA) capacitor c=4.40031e-16
    c5519 (\16\:vv \344\:VDDA) capacitor c=3.31616e-17
    c5520 (\14\:U \2\:net1) capacitor c=4.27234e-17
    c5521 (\1559\:GNDA \1251\:GNDA) capacitor c=5.07877e-17
    c5522 (\302\:VDDA \79\:BG_REF) capacitor c=3.23086e-16
    c5523 (\43\:Vm1 \279\:VDDA) capacitor c=3.94913e-15
    c5524 (\99\:S \32\:D1) capacitor c=1.65903e-15
    c5525 (\19\:vv \9\:S) capacitor c=1.3147e-17
    c5526 (\222\:Vm1 \1251\:GNDA) capacitor c=1.1595e-15
    c5527 (\5\:D2 \1251\:GNDA) capacitor c=1.65595e-15
    c5528 (\69\:Vo1 \230\:GNDA) capacitor c=2.09353e-16
    c5529 (\152\:Vm1 \41\:Vm1) capacitor c=1.06533e-15
    c5530 (\192\:GNDA \1251\:GNDA) capacitor c=5.73248e-15
    c5531 (\114\:Vm1 \92\:VDDA) capacitor c=3.22227e-16
    c5532 (\905\:GNDA \175\:GNDA) capacitor c=1.24327e-17
    c5533 (\3\:S \102\:S) capacitor c=2.21519e-15
    c5534 (\22\:Vs \23\:D2) capacitor c=2.77672e-15
    c5535 (\191\:VDDA \279\:VDDA) capacitor c=3.94428e-16
    c5536 (\19\:vv \188\:VDDA) capacitor c=3.31616e-17
    c5537 (\465\:VDDA \470\:VDDA) capacitor c=4.75166e-16
    c5538 (\536\:VDDA \279\:VDDA) capacitor c=8.63031e-16
    c5539 (\1006\:GNDA \79\:U) capacitor c=3.72052e-17
    c5540 (\118\:U \1218\:GNDA) capacitor c=2.53643e-16
    c5541 (\6\:D2 \1251\:GNDA) capacitor c=1.90575e-15
    c5542 (\121\:S \43\:Vo1) capacitor c=1.70706e-15
    c5543 (\835\:VDDA \260\:Vm1) capacitor c=1.70833e-15
    c5544 (\1362\:GNDA \935\:GNDA) capacitor c=2.24481e-15
    c5545 (\193\:VDDA \15\:S) capacitor c=1.2913e-16
    c5546 (\1509\:GNDA \243\:GNDA) capacitor c=2.54763e-15
    c5547 (\26\:U \1034\:GNDA) capacitor c=4.10562e-17
    c5548 (\168\:GNDA \170\:GNDA) capacitor c=3.15482e-16
    c5549 (\22\:BIAS \1251\:GNDA) capacitor c=6.15983e-16
    c5550 (\31\:BG_REF \19\:S) capacitor c=7.23825e-16
    c5551 (\40\:Vo1 \38\:D1) capacitor c=1.14749e-15
    c5552 (\112\:S2 \240\:S) capacitor c=1.72321e-15
    c5553 (\354\:VDDA \279\:VDDA) capacitor c=3.33877e-16
    c5554 (\133\:BG_REF \238\:S) capacitor c=6.67218e-15
    c5555 (\235\:S \832\:VDDA) capacitor c=3.83836e-16
    c5556 (\33\:vv \240\:S) capacitor c=5.8336e-16
    c5557 (\896\:GNDA \77\:U) capacitor c=3.3004e-16
    c5558 (\55\:Vm1 \279\:VDDA) capacitor c=3.95712e-15
    c5559 (\93\:U \995\:GNDA) capacitor c=3.54052e-16
    c5560 (\133\:BG_REF \239\:S) capacitor c=2.22721e-16
    c5561 (\36\:Vs \2\:Vs) capacitor c=1.91759e-17
    c5562 (\205\:GNDA \928\:GNDA) capacitor c=1.26043e-17
    c5563 (\18\:vv \45\:S) capacitor c=1.3147e-17
    c5564 (\72\:BG_REF \279\:VDDA) capacitor c=1.15424e-16
    c5565 (\26\:vv \534\:VDDA) capacitor c=4.51962e-17
    c5566 (\77\:U \978\:GNDA) capacitor c=5.64553e-17
    c5567 (\138\:BG_REF \279\:VDDA) capacitor c=4.95233e-15
    c5568 (\555\:VDDA \44\:S2) capacitor c=1.6768e-17
    c5569 (\67\:BG_REF \283\:VDDA) capacitor c=1.23247e-17
    c5570 (\20\:D1 \78\:S) capacitor c=1.12517e-16
    c5571 (\92\:U \889\:GNDA) capacitor c=3.54052e-16
    c5572 (\13\:S \279\:VDDA) capacitor c=8.3006e-16
    c5573 (\4\:D2 \1251\:GNDA) capacitor c=1.90091e-15
    c5574 (\87\:BG_REF \279\:VDDA) capacitor c=6.64578e-17
    c5575 (\82\:S2 \675\:GNDA) capacitor c=6.52819e-17
    c5576 (\136\:GNDA \1251\:GNDA) capacitor c=7.47875e-16
    c5577 (\116\:BG_REF \581\:VDDA) capacitor c=7.12272e-16
    c5578 (\671\:GNDA \521\:GNDA) capacitor c=4.06205e-16
    c5579 (\35\:X \117\:U) capacitor c=7.13489e-16
    c5580 (\28\:U \192\:GNDA) capacitor c=8.51466e-16
    c5581 (\105\:BG_REF \217\:S) capacitor c=2.92617e-15
    c5582 (\842\:GNDA \797\:GNDA) capacitor c=6.40312e-17
    c5583 (\2\:net25 \2\:net29) capacitor c=4.65336e-17
    c5584 (\2\:net11 \85\:GNDA) capacitor c=1.02913e-15
    c5585 (\776\:GNDA \827\:GNDA) capacitor c=3.72052e-17
    c5586 (\489\:VDDA \101\:BG_REF) capacitor c=1.98136e-16
    c5587 (\205\:S \692\:VDDA) capacitor c=1.34305e-16
    c5588 (\128\:GNDA \132\:GNDA) capacitor c=1.08958e-17
    c5589 (\238\:VDDA \426\:VDDA) capacitor c=3.85267e-16
    c5590 (\58\:D1 \69\:Vo1) capacitor c=9.20623e-16
    c5591 (\2\:net13 \66\:GNDA) capacitor c=9.90903e-16
    c5592 (\372\:VDDA \279\:VDDA) capacitor c=3.97675e-16
    c5593 (\7\:vv \17\:S) capacitor c=1.3147e-17
    c5594 (\874\:GNDA \738\:GNDA) capacitor c=3.67155e-17
    c5595 (\65\:S2 \17\:vv) capacitor c=2.26154e-16
    c5596 (\210\:Vm1 \97\:Vm1) capacitor c=1.83024e-16
    c5597 (\67\:Vm1 \279\:VDDA) capacitor c=3.9572e-15
    c5598 (\43\:D1 \63\:Vo1) capacitor c=5.31484e-16
    c5599 (\50\:U \205\:GNDA) capacitor c=1.07975e-15
    c5600 (\19\:vv \87\:VDDA) capacitor c=3.48772e-17
    c5601 (\242\:S \279\:VDDA) capacitor c=3.70159e-15
    c5602 (\227\:VDDA \24\:S) capacitor c=5.28406e-16
    c5603 (\25\:BG_REF \13\:S) capacitor c=7.23825e-16
    c5604 (\25\:GNDA \17\:X) capacitor c=3.44642e-16
    c5605 (\896\:GNDA \207\:GNDA) capacitor c=1.1541e-16
    c5606 (\119\:GNDA \1251\:GNDA) capacitor c=1.16097e-17
    c5607 (\82\:S2 \4\:Vs) capacitor c=1.65373e-16
    c5608 (\136\:Vm1 \279\:VDDA) capacitor c=3.74601e-16
    c5609 (\30\:X \1114\:GNDA) capacitor c=3.73689e-17
    c5610 (\203\:GNDA \1472\:GNDA) capacitor c=1.13694e-16
    c5611 (\541\:GNDA \4\:Vo1) capacitor c=1.91666e-17
    c5612 (\32\:D1 \107\:S) capacitor c=2.28667e-16
    c5613 (\7\:U \1251\:GNDA) capacitor c=1.17224e-15
    c5614 (\43\:GNDA \218\:GNDA) capacitor c=5.10816e-15
    c5615 (\363\:GNDA \366\:GNDA) capacitor c=3.80126e-16
    c5616 (\555\:VDDA \554\:VDDA) capacitor c=5.04147e-16
    c5617 (\625\:VDDA \75\:S2) capacitor c=8.32171e-17
    c5618 (\294\:VDDA \56\:BG_REF) capacitor c=3.79103e-17
    c5619 (\24\:vv \76\:VDDA) capacitor c=9.90866e-17
    c5620 (\8\:GNDA \2\:net17) capacitor c=2.52808e-16
    c5621 (\462\:VDDA \79\:BG_REF) capacitor c=2.34161e-16
    c5622 (\835\:VDDA \236\:S) capacitor c=3.82852e-16
    c5623 (\47\:S \279\:VDDA) capacitor c=1.38294e-15
    c5624 (\15\:Vs \27\:Vs) capacitor c=1.1856e-17
    c5625 (\103\:U \1125\:GNDA) capacitor c=5.82324e-17
    c5626 (\32\:BG_REF \11\:VDDA) capacitor c=2.14804e-17
    c5627 (\75\:U \842\:GNDA) capacitor c=5.82324e-17
    c5628 (\207\:GNDA \1495\:GNDA) capacitor c=3.60641e-16
    c5629 (\362\:VDDA \271\:Vm1) capacitor c=3.9399e-16
    c5630 (\34\:vv \42\:BG_REF) capacitor c=3.31616e-17
    c5631 (\77\:Vm1 \279\:VDDA) capacitor c=3.95842e-15
    c5632 (\125\:GNDA \1251\:GNDA) capacitor c=1.23214e-17
    c5633 (\1250\:GNDA \1251\:GNDA) capacitor c=4.43419e-16
    c5634 (\8\:U \203\:GNDA) capacitor c=1.17686e-17
    c5635 (\19\:U \1251\:GNDA) capacitor c=6.97733e-16
    c5636 (\78\:S2 \15\:S2) capacitor c=6.31124e-17
    c5637 (\103\:S2 \577\:VDDA) capacitor c=4.5184e-17
    c5638 (\77\:S2 \279\:VDDA) capacitor c=3.35475e-15
    c5639 (\3\:U \1238\:GNDA) capacitor c=1.53042e-16
    c5640 (\32\:U \43\:U) capacitor c=1.69405e-17
    c5641 (\238\:S \51\:VDDA) capacitor c=1.34744e-17
    c5642 (\205\:GNDA \32\:U) capacitor c=1.12459e-15
    c5643 (\7\:vv \297\:VDDA) capacitor c=3.31616e-17
    c5644 (\297\:Vm1 \89\:BG_REF) capacitor c=1.54378e-15
    c5645 (\17\:U \22\:U) capacitor c=1.69405e-17
    c5646 (\85\:S \102\:S) capacitor c=5.03051e-16
    c5647 (\214\:VDDA \279\:VDDA) capacitor c=3.32577e-16
    c5648 (\31\:S2 \41\:S2) capacitor c=7.77606e-17
    c5649 (\180\:Vm1 \319\:VDDA) capacitor c=4.74167e-16
    c5650 (\1557\:GNDA \1561\:GNDA) capacitor c=1.65665e-16
    c5651 (\22\:Vs \50\:S2) capacitor c=5.67223e-17
    c5652 (\12\:S2 \15\:S2) capacitor c=2.22026e-17
    c5653 (\18\:vv \72\:BG_REF) capacitor c=3.40015e-17
    c5654 (\114\:GNDA \218\:GNDA) capacitor c=8.21517e-16
    c5655 (\205\:GNDA \1452\:GNDA) capacitor c=3.52199e-17
    c5656 (\597\:GNDA \379\:GNDA) capacitor c=4.6967e-17
    c5657 (\2\:net7 \115\:GNDA) capacitor c=9.33302e-16
    c5658 (\67\:U \1362\:GNDA) capacitor c=1.5712e-15
    c5659 (\849\:GNDA \1251\:GNDA) capacitor c=4.77296e-16
    c5660 (\133\:BG_REF \112\:S2) capacitor c=2.18527e-17
    c5661 (\669\:GNDA \193\:GNDA) capacitor c=1.06381e-17
    c5662 (\239\:S \77\:S2) capacitor c=6.8435e-15
    c5663 (\88\:BG_REF \450\:VDDA) capacitor c=1.17657e-17
    c5664 (\223\:Vm1 \1251\:GNDA) capacitor c=2.99199e-16
    c5665 (\192\:GNDA \170\:GNDA) capacitor c=2.31665e-15
    c5666 (\100\:S2 \44\:S2) capacitor c=3.3915e-16
    c5667 (\88\:U \1251\:GNDA) capacitor c=7.1556e-17
    c5668 (\594\:VDDA \604\:VDDA) capacitor c=1.0739e-14
    c5669 (\44\:U \1251\:GNDA) capacitor c=1.37268e-15
    c5670 (\208\:Vm1 \279\:VDDA) capacitor c=3.71744e-16
    c5671 (\57\:S2 \550\:VDDA) capacitor c=3.41489e-16
    c5672 (\635\:VDDA \569\:VDDA) capacitor c=4.04543e-16
    c5673 (\59\:Vm1 \60\:Vm1) capacitor c=6.46758e-16
    c5674 (\84\:U \1403\:GNDA) capacitor c=1.63679e-16
    c5675 (\31\:D2 \100\:S2) capacitor c=1.52378e-15
    c5676 (\87\:Vm1 \279\:VDDA) capacitor c=3.95777e-15
    c5677 (\4\:BIAS \3\:BIAS) capacitor c=3.872e-16
    c5678 (\26\:D1 \5\:X) capacitor c=2.39703e-17
    c5679 (\47\:S \391\:VDDA) capacitor c=1.88243e-17
    c5680 (\1532\:GNDA \119\:GNDA) capacitor c=2.38454e-16
    c5681 (\1048\:GNDA \1079\:GNDA) capacitor c=1.62672e-16
    c5682 (\26\:vv \279\:VDDA) capacitor c=5.41359e-15
    c5683 (\133\:BG_REF \35\:VDDA) capacitor c=1.03857e-17
    c5684 (\224\:VDDA \279\:VDDA) capacitor c=3.91553e-16
    c5685 (\22\:vv \76\:BG_REF) capacitor c=3.40015e-17
    c5686 (\105\:BG_REF \20\:vv) capacitor c=5.14497e-16
    c5687 (\210\:Vm1 \472\:VDDA) capacitor c=2.24131e-16
    c5688 (\25\:Vm1 \26\:Vm1) capacitor c=6.3799e-16
    c5689 (\239\:S \187\:VDDA) capacitor c=1.23137e-17
    c5690 (\627\:GNDA \419\:GNDA) capacitor c=4.6967e-17
    c5691 (\104\:U \1274\:GNDA) capacitor c=1.63679e-16
    c5692 (\5\:Vs \1251\:GNDA) capacitor c=8.8569e-17
    c5693 (\21\:S2 \44\:S2) capacitor c=3.25954e-16
    c5694 (\17\:S2 \3\:Vs) capacitor c=6.13835e-17
    c5695 (\162\:Vm1 \51\:Vm1) capacitor c=1.06767e-15
    c5696 (\34\:Vo1 \32\:Vo1) capacitor c=1.24459e-15
    c5697 (\70\:U \1251\:GNDA) capacitor c=9.18805e-16
    c5698 (\117\:U \99\:U) capacitor c=1.30963e-15
    c5699 (\207\:GNDA \30\:X) capacitor c=7.93593e-17
    c5700 (\9\:Vm1 \10\:Vm1) capacitor c=6.45654e-16
    c5701 (\265\:VDDA \8\:vv) capacitor c=2.3815e-16
    c5702 (\4\:Y \6\:X) capacitor c=1.63839e-17
    c5703 (\53\:D1 \71\:Vo1) capacitor c=1.04098e-15
    c5704 (\728\:GNDA \2\:Vo1) capacitor c=4.46241e-17
    c5705 (\555\:VDDA \55\:S2) capacitor c=8.51891e-17
    c5706 (\87\:BG_REF \553\:VDDA) capacitor c=3.87597e-16
    c5707 (\27\:vv \80\:BG_REF) capacitor c=3.40015e-17
    c5708 (\389\:VDDA \279\:VDDA) capacitor c=3.31143e-16
    c5709 (\58\:U \1074\:GNDA) capacitor c=4.68028e-17
    c5710 (\130\:Vm1 \22\:Vm1) capacitor c=8.79821e-16
    c5711 (\43\:Vo1 \129\:S) capacitor c=2.24115e-16
    c5712 (\101\:Vm1 \279\:VDDA) capacitor c=3.95929e-15
    c5713 (\64\:Vo1 \155\:S) capacitor c=5.95276e-16
    c5714 (\66\:U \1268\:GNDA) capacitor c=5.82324e-17
    c5715 (\15\:D2 \1251\:GNDA) capacitor c=1.04673e-15
    c5716 (\264\:VDDA \8\:vv) capacitor c=5.28947e-16
    c5717 (\860\:VDDA \279\:VDDA) capacitor c=4.15963e-16
    c5718 (\43\:S \356\:VDDA) capacitor c=1.85729e-17
    c5719 (\651\:VDDA \271\:Vm1) capacitor c=3.86271e-16
    c5720 (\512\:GNDA \1251\:GNDA) capacitor c=4.40701e-17
    c5721 (\8\:U \1495\:GNDA) capacitor c=5.74316e-17
    c5722 (\93\:U \1251\:GNDA) capacitor c=1.35947e-15
    c5723 (\905\:GNDA \193\:GNDA) capacitor c=2.243e-16
    c5724 (\89\:U \1332\:GNDA) capacitor c=4.6967e-17
    c5725 (\199\:VDDA \45\:BG_REF) capacitor c=5.38983e-16
    c5726 (\686\:GNDA \684\:GNDA) capacitor c=2.62668e-16
    c5727 (\42\:BG_REF \279\:VDDA) capacitor c=1.15424e-16
    c5728 (\360\:VDDA \41\:VDDA) capacitor c=1.0621e-15
    c5729 (\136\:Vm1 \210\:VDDA) capacitor c=4.89293e-16
    c5730 (\29\:U \482\:GNDA) capacitor c=1.82468e-16
    c5731 (\24\:Vm1 \279\:VDDA) capacitor c=3.92626e-15
    c5732 (\768\:GNDA \4\:Vo1) capacitor c=1.84432e-17
    c5733 (\1362\:GNDA \425\:GNDA) capacitor c=1.33732e-17
    c5734 (\189\:VDDA \44\:BG_REF) capacitor c=3.8451e-17
    c5735 (\75\:BG_REF \217\:S) capacitor c=4.90797e-16
    c5736 (\493\:VDDA \77\:BG_REF) capacitor c=1.89197e-16
    c5737 (\409\:VDDA \279\:VDDA) capacitor c=3.96231e-16
    c5738 (\523\:VDDA \522\:VDDA) capacitor c=2.08731e-16
    c5739 (\293\:VDDA \56\:BG_REF) capacitor c=5.29488e-16
    c5740 (\29\:S \286\:VDDA) capacitor c=1.90814e-17
    c5741 (\2\:net15 \2\:net11) capacitor c=4.85017e-16
    c5742 (\1293\:GNDA \1251\:GNDA) capacitor c=3.11265e-17
    c5743 (\28\:Vo1 \86\:S) capacitor c=1.19373e-16
    c5744 (\379\:VDDA \377\:VDDA) capacitor c=4.84335e-16
    c5745 (\506\:GNDA \185\:GNDA) capacitor c=7.84056e-17
    c5746 (\56\:Vo1 \149\:S) capacitor c=1.4968e-16
    c5747 (\18\:BG_REF \9\:BG_REF) capacitor c=3.47452e-16
    c5748 (\1430\:GNDA \1427\:GNDA) capacitor c=8.23837e-17
    c5749 (\116\:Vm1 \110\:VDDA) capacitor c=4.39105e-16
    c5750 (\9\:vv \44\:S2) capacitor c=1.13118e-15
    c5751 (\756\:GNDA \711\:GNDA) capacitor c=6.40312e-17
    c5752 (\1012\:GNDA \1009\:GNDA) capacitor c=8.23837e-17
    c5753 (\33\:U \506\:GNDA) capacitor c=1.81769e-16
    c5754 (\17\:vv \274\:VDDA) capacitor c=3.31616e-17
    c5755 (\45\:BG_REF \218\:VDDA) capacitor c=2.98055e-16
    c5756 (\133\:BG_REF \33\:vv) capacitor c=4.46225e-16
    c5757 (\272\:Vm1 \34\:vv) capacitor c=5.15092e-16
    c5758 (\466\:VDDA \271\:Vm1) capacitor c=2.18118e-16
    c5759 (\150\:Vm1 \279\:VDDA) capacitor c=3.74341e-16
    c5760 (\95\:S2 \12\:D2) capacitor c=3.79738e-16
    c5761 (\128\:GNDA \9\:D1) capacitor c=1.62374e-16
    c5762 (\35\:S2 \7\:S2) capacitor c=1.04777e-16
    c5763 (\80\:S2 \22\:S2) capacitor c=7.25997e-17
    c5764 (\44\:Vo1 \1251\:GNDA) capacitor c=3.148e-16
    c5765 (\33\:U \1192\:GNDA) capacitor c=5.23489e-17
    c5766 (\19\:U \1032\:GNDA) capacitor c=6.78232e-17
    c5767 (\70\:GNDA \218\:GNDA) capacitor c=3.1695e-15
    c5768 (\3\:U \207\:GNDA) capacitor c=4.82548e-16
    c5769 (\34\:Vm1 \279\:VDDA) capacitor c=3.92467e-15
    c5770 (\84\:BG_REF \1251\:GNDA) capacitor c=3.69771e-16
    c5771 (\106\:U \1251\:GNDA) capacitor c=5.09198e-17
    c5772 (\1362\:GNDA \109\:U) capacitor c=3.38399e-16
    c5773 (\67\:U \659\:GNDA) capacitor c=1.42235e-16
    c5774 (\577\:VDDA \279\:VDDA) capacitor c=3.30453e-16
    c5775 (\23\:S2 \2\:vv) capacitor c=8.44e-17
    c5776 (\203\:GNDA \597\:GNDA) capacitor c=5.53923e-15
    c5777 (\3\:Vs \44\:S2) capacitor c=1.32088e-16
    c5778 (\35\:X \66\:GNDA) capacitor c=3.87991e-16
    c5779 (\896\:GNDA \890\:GNDA) capacitor c=1.26043e-17
    c5780 (\80\:GNDA \2\:net37) capacitor c=4.97753e-17
    c5781 (\776\:GNDA \203\:GNDA) capacitor c=1.08423e-16
    c5782 (\205\:GNDA \1192\:GNDA) capacitor c=2.24575e-15
    c5783 (\90\:GNDA \2\:net28) capacitor c=2.69496e-17
    c5784 (\149\:GNDA \160\:GNDA) capacitor c=4.6967e-17
    c5785 (\2\:net37 \2\:net19) capacitor c=2.44644e-16
    c5786 (\17\:vv \237\:VDDA) capacitor c=3.40015e-17
    c5787 (\207\:GNDA \1138\:GNDA) capacitor c=1.65032e-17
    c5788 (\67\:S2 \542\:VDDA) capacitor c=2.36318e-16
    c5789 (\270\:Vm1 \131\:BG_REF) capacitor c=1.15294e-15
    c5790 (\19\:Y \102\:S) capacitor c=1.44527e-15
    c5791 (\148\:GNDA \1251\:GNDA) capacitor c=4.0314e-16
    c5792 (\168\:GNDA \163\:GNDA) capacitor c=9.29257e-17
    c5793 (\142\:Vm1 \232\:VDDA) capacitor c=3.384e-16
    c5794 (\65\:BG_REF \316\:VDDA) capacitor c=1.23247e-17
    c5795 (\260\:Vm1 \550\:VDDA) capacitor c=4.61017e-16
    c5796 (\206\:Vm1 \94\:Vm1) capacitor c=8.83019e-16
    c5797 (\723\:VDDA \208\:S) capacitor c=3.82852e-16
    c5798 (\75\:S2 \534\:VDDA) capacitor c=4.5184e-17
    c5799 (\64\:S2 \44\:S2) capacitor c=5.09676e-16
    c5800 (\192\:GNDA \850\:GNDA) capacitor c=1.86015e-16
    c5801 (\33\:U \1167\:GNDA) capacitor c=1.70814e-16
    c5802 (\18\:S \279\:VDDA) capacitor c=1.67398e-16
    c5803 (\105\:S \9\:Y) capacitor c=1.35415e-16
    c5804 (\192\:GNDA \1345\:GNDA) capacitor c=3.40431e-17
    c5805 (\118\:Vm1 \11\:VDDA) capacitor c=4.55576e-16
    c5806 (\55\:GNDA \218\:GNDA) capacitor c=8.5348e-15
    c5807 (\89\:BG_REF \590\:VDDA) capacitor c=3.00519e-16
    c5808 (\205\:GNDA \1049\:GNDA) capacitor c=3.77185e-15
    c5809 (\25\:vv \47\:S) capacitor c=1.3147e-17
    c5810 (\118\:U \539\:GNDA) capacitor c=3.48808e-15
    c5811 (\106\:GNDA \2\:net1) capacitor c=7.60768e-17
    c5812 (\83\:U \1332\:GNDA) capacitor c=4.6967e-17
    c5813 (\723\:VDDA \276\:Vm1) capacitor c=1.71136e-15
    c5814 (\550\:VDDA \121\:BG_REF) capacitor c=4.80867e-16
    c5815 (\220\:Vm1 \279\:VDDA) capacitor c=4.52787e-16
    c5816 (\89\:BG_REF \17\:VDDA) capacitor c=1.15478e-17
    c5817 (\131\:U \203\:GNDA) capacitor c=4.0127e-15
    c5818 (\21\:vv \155\:VDDA) capacitor c=3.31616e-17
    c5819 (\87\:BG_REF \238\:S) capacitor c=6.30975e-17
    c5820 (\192\:GNDA \185\:GNDA) capacitor c=2.24575e-15
    c5821 (\890\:GNDA \634\:GNDA) capacitor c=3.59294e-17
    c5822 (\2\:net15 \63\:GNDA) capacitor c=1.3296e-15
    c5823 (\1195\:GNDA \1251\:GNDA) capacitor c=3.1724e-17
    c5824 (\1362\:GNDA \659\:GNDA) capacitor c=4.02659e-15
    c5825 (\60\:U \1079\:GNDA) capacitor c=1.3611e-15
    c5826 (\22\:vv \546\:VDDA) capacitor c=2.74941e-16
    c5827 (\41\:U \180\:GNDA) capacitor c=4.6967e-17
    c5828 (\79\:BG_REF \446\:VDDA) capacitor c=3.13598e-16
    c5829 (\124\:U \594\:VDDA) capacitor c=1.59776e-15
    c5830 (\261\:VDDA \279\:VDDA) capacitor c=3.98758e-16
    c5831 (\20\:vv \521\:VDDA) capacitor c=1.04283e-17
    c5832 (\99\:U \437\:GNDA) capacitor c=3.88004e-17
    c5833 (\222\:S \546\:VDDA) capacitor c=1.54116e-16
    c5834 (\148\:Vm1 \37\:Vm1) capacitor c=1.82432e-16
    c5835 (\5\:S \102\:S) capacitor c=2.21779e-15
    c5836 (\188\:Vm1 \75\:Vm1) capacitor c=1.06288e-15
    c5837 (\136\:BG_REF \52\:S2) capacitor c=4.02016e-16
    c5838 (\230\:GNDA \3\:BG_REF) capacitor c=2.99003e-17
    c5839 (\216\:S \68\:S2) capacitor c=3.01544e-15
    c5840 (\31\:X \1029\:GNDA) capacitor c=4.6967e-17
    c5841 (\69\:S \20\:D1) capacitor c=3.68333e-16
    c5842 (\898\:GNDA \1251\:GNDA) capacitor c=1.66066e-16
    c5843 (\51\:BG_REF \207\:S) capacitor c=5.55246e-16
    c5844 (\131\:BG_REF \28\:vv) capacitor c=5.24628e-16
    c5845 (\198\:Vm1 \383\:VDDA) capacitor c=4.65703e-16
    c5846 (\49\:U \515\:GNDA) capacitor c=4.6967e-17
    c5847 (\536\:VDDA \534\:VDDA) capacitor c=3.4967e-16
    c5848 (\1237\:GNDA \1251\:GNDA) capacitor c=3.11265e-17
    c5849 (\1167\:GNDA \1192\:GNDA) capacitor c=3.14499e-16
    c5850 (\448\:VDDA \279\:VDDA) capacitor c=3.30986e-16
    c5851 (\68\:S2 \230\:GNDA) capacitor c=1.63858e-17
    c5852 (\49\:BG_REF \253\:VDDA) capacitor c=3.01353e-16
    c5853 (\31\:U \192\:GNDA) capacitor c=5.47526e-16
    c5854 (\290\:VDDA \33\:VDDA) capacitor c=1.04375e-15
    c5855 (\55\:S2 \44\:S2) capacitor c=1.45962e-15
    c5856 (\40\:S2 \38\:S2) capacitor c=2.24747e-17
    c5857 (\2\:net33 \218\:GNDA) capacitor c=4.17525e-16
    c5858 (\928\:GNDA \746\:GNDA) capacitor c=9.29257e-17
    c5859 (\64\:Vo1 \102\:S) capacitor c=1.27011e-15
    c5860 (\105\:U \1355\:GNDA) capacitor c=1.11161e-16
    c5861 (\38\:D1 \36\:D1) capacitor c=1.24345e-15
    c5862 (\426\:VDDA \88\:BG_REF) capacitor c=3.40397e-15
    c5863 (\107\:S \38\:Vo1) capacitor c=6.24816e-16
    c5864 (\26\:D2 \845\:GNDA) capacitor c=6.88254e-16
    c5865 (\6\:Y \28\:Vo1) capacitor c=1.77348e-17
    c5866 (\138\:BG_REF \572\:VDDA) capacitor c=5.12941e-16
    c5867 (\116\:VDDA \272\:Vm1) capacitor c=3.99943e-16
    c5868 (\923\:VDDA \1251\:GNDA) capacitor c=3.3087e-17
    c5869 (\7\:vv \279\:VDDA) capacitor c=5.27357e-15
    c5870 (\75\:S2 \230\:GNDA) capacitor c=1.63858e-17
    c5871 (\45\:U \1324\:GNDA) capacitor c=1.3699e-16
    c5872 (\66\:S2 \23\:BG_REF) capacitor c=1.11867e-17
    c5873 (\35\:D1 \11\:X) capacitor c=2.24251e-17
    c5874 (\18\:Y \32\:GNDA) capacitor c=7.84816e-16
    c5875 (\53\:U \60\:U) capacitor c=1.69405e-17
    c5876 (\85\:U \1251\:GNDA) capacitor c=1.54751e-15
    c5877 (\1553\:GNDA \11\:Vs) capacitor c=5.09967e-16
    c5878 (\27\:vv \534\:VDDA) capacitor c=2.01495e-16
    c5879 (\207\:GNDA \11\:U) capacitor c=7.93593e-17
    c5880 (\24\:S \279\:VDDA) capacitor c=1.67328e-16
    c5881 (\35\:S \75\:S2) capacitor c=1.17194e-16
    c5882 (\300\:VDDA \67\:BG_REF) capacitor c=3.23086e-16
    c5883 (\4\:X \4\:Y) capacitor c=1.20742e-17
    c5884 (\49\:BG_REF \252\:VDDA) capacitor c=1.35815e-17
    c5885 (\128\:VDDA \34\:BG_REF) capacitor c=4.86031e-17
    c5886 (\90\:VDDA \279\:VDDA) capacitor c=3.86108e-16
    c5887 (\102\:S2 \81\:BG_REF) capacitor c=1.11867e-17
    c5888 (\172\:GNDA \175\:GNDA) capacitor c=1.62672e-16
    c5889 (\205\:S \230\:GNDA) capacitor c=3.68681e-17
    c5890 (\1175\:GNDA \1138\:GNDA) capacitor c=4.92871e-17
    c5891 (\464\:VDDA \279\:VDDA) capacitor c=3.86901e-16
    c5892 (\2\:net26 \2\:net6) capacitor c=4.13306e-17
    c5893 (\34\:X \63\:GNDA) capacitor c=8.41772e-17
    c5894 (\68\:U \842\:GNDA) capacitor c=6.78232e-17
    c5895 (\207\:GNDA \1233\:GNDA) capacitor c=2.31665e-15
    c5896 (\181\:S \102\:S) capacitor c=3.98228e-16
    c5897 (\890\:GNDA \935\:GNDA) capacitor c=3.13925e-16
    c5898 (\905\:GNDA \1203\:GNDA) capacitor c=5.5988e-15
    c5899 (\52\:U \205\:GNDA) capacitor c=1.21811e-15
    c5900 (\73\:U \1251\:GNDA) capacitor c=1.02189e-15
    c5901 (\17\:D1 \74\:S) capacitor c=1.27835e-16
    c5902 (\1500\:GNDA \1472\:GNDA) capacitor c=1.60548e-16
    c5903 (\230\:GNDA \23\:GNDA) capacitor c=1.05042e-16
    c5904 (\26\:vv \299\:VDDA) capacitor c=3.31616e-17
    c5905 (\170\:Vm1 \60\:Vm1) capacitor c=8.82743e-16
    c5906 (\69\:S2 \59\:VDDA) capacitor c=1.34744e-17
    c5907 (\221\:S \230\:GNDA) capacitor c=1.63756e-17
    c5908 (\230\:GNDA \21\:GNDA) capacitor c=5.49422e-17
    c5909 (\42\:U \1251\:GNDA) capacitor c=7.1556e-17
    c5910 (\164\:Vm1 \279\:VDDA) capacitor c=3.51898e-16
    c5911 (\7\:Vs \38\:S2) capacitor c=6.68897e-16
    c5912 (\1057\:GNDA \1054\:GNDA) capacitor c=8.23837e-17
    c5913 (\18\:vv \398\:VDDA) capacitor c=3.31616e-17
    c5914 (\27\:vv \406\:VDDA) capacitor c=3.31616e-17
    c5915 (\604\:VDDA \230\:GNDA) capacitor c=3.57498e-15
    c5916 (\172\:GNDA \173\:GNDA) capacitor c=4.12292e-16
    c5917 (\8\:X \102\:S) capacitor c=1.28119e-15
    c5918 (\2\:net30 \2\:net12) capacitor c=4.49921e-17
    c5919 (\158\:Vm1 \48\:Vm1) capacitor c=8.81838e-16
    c5920 (\22\:vv \402\:VDDA) capacitor c=1.17171e-17
    c5921 (\92\:U \1362\:GNDA) capacitor c=5.22812e-16
    c5922 (\230\:GNDA \11\:GNDA) capacitor c=5.12919e-17
    c5923 (\93\:GNDA \218\:GNDA) capacitor c=2.0138e-14
    c5924 (\32\:D1 \110\:S) capacitor c=1.1546e-16
    c5925 (\1152\:GNDA \41\:U) capacitor c=3.72052e-17
    c5926 (\237\:S \230\:GNDA) capacitor c=1.63858e-17
    c5927 (\54\:Vo1 \52\:S) capacitor c=9.54379e-17
    c5928 (\28\:X \207\:GNDA) capacitor c=2.40493e-16
    c5929 (\42\:D1 \1251\:GNDA) capacitor c=9.59615e-16
    c5930 (\104\:VDDA \279\:VDDA) capacitor c=2.52177e-16
    c5931 (\637\:GNDA \437\:GNDA) capacitor c=6.21092e-17
    c5932 (\50\:U \738\:GNDA) capacitor c=1.42235e-16
    c5933 (\317\:GNDA \1251\:GNDA) capacitor c=2.35722e-16
    c5934 (\46\:Vo1 \771\:GNDA) capacitor c=6.62257e-16
    c5935 (\1364\:GNDA \1383\:GNDA) capacitor c=4.28283e-16
    c5936 (\468\:VDDA \279\:VDDA) capacitor c=4.37765e-16
    c5937 (\225\:Vm1 \20\:vv) capacitor c=2.71173e-16
    c5938 (\220\:Vm1 \497\:VDDA) capacitor c=2.88285e-16
    c5939 (\188\:Vm1 \350\:VDDA) capacitor c=4.79798e-16
    c5940 (\1262\:GNDA \173\:GNDA) capacitor c=3.33463e-17
    c5941 (\192\:Vm1 \79\:Vm1) capacitor c=1.06288e-15
    c5942 (\1236\:GNDA \1251\:GNDA) capacitor c=4.19575e-17
    c5943 (\643\:VDDA \72\:S2) capacitor c=1.14197e-16
    c5944 (\272\:Vm1 \572\:VDDA) capacitor c=5.9541e-16
    c5945 (\643\:VDDA \225\:Vm1) capacitor c=5.74886e-16
    c5946 (\89\:BG_REF \230\:GNDA) capacitor c=3.8494e-17
    c5947 (\149\:GNDA \870\:GNDA) capacitor c=1.04641e-15
    c5948 (\27\:U \230\:GNDA) capacitor c=4.48458e-16
    c5949 (\627\:GNDA \425\:GNDA) capacitor c=1.59406e-16
    c5950 (\241\:S \279\:VDDA) capacitor c=4.19394e-15
    c5951 (\46\:D1 \561\:GNDA) capacitor c=9.71417e-16
    c5952 (\73\:S2 \26\:vv) capacitor c=1.22457e-16
    c5953 (\1294\:GNDA \1215\:GNDA) capacitor c=9.29257e-17
    c5954 (\243\:S \102\:S) capacitor c=5.28442e-16
    c5955 (\282\:VDDA \279\:VDDA) capacitor c=3.35645e-16
    c5956 (\835\:VDDA \121\:BG_REF) capacitor c=1.10524e-15
    c5957 (\118\:U \391\:GNDA) capacitor c=1.86151e-16
    c5958 (\25\:BG_REF \139\:VDDA) capacitor c=1.23404e-17
    c5959 (\73\:U \1201\:GNDA) capacitor c=1.70814e-16
    c5960 (\24\:U \791\:GNDA) capacitor c=4.6967e-17
    c5961 (\261\:VDDA \25\:BG_REF) capacitor c=3.15714e-16
    c5962 (\1507\:GNDA \1251\:GNDA) capacitor c=1.01787e-16
    c5963 (\103\:U \1122\:GNDA) capacitor c=1.3611e-15
    c5964 (\200\:S \172\:S) capacitor c=7.07713e-16
    c5965 (\29\:vv \716\:GNDA) capacitor c=4.79609e-17
    c5966 (\95\:S2 \44\:S2) capacitor c=3.20264e-16
    c5967 (\1403\:GNDA \1427\:GNDA) capacitor c=3.15482e-16
    c5968 (\117\:S \102\:S) capacitor c=5.03801e-16
    c5969 (\10\:S2 \279\:VDDA) capacitor c=2.12084e-16
    c5970 (\52\:U \1251\:GNDA) capacitor c=1.44493e-15
    c5971 (\14\:BG_REF \44\:S2) capacitor c=1.70784e-15
    c5972 (\1312\:GNDA \1294\:GNDA) capacitor c=4.83033e-17
    c5973 (\271\:Vm1 \33\:vv) capacitor c=5.17975e-16
    c5974 (\776\:VDDA \114\:Vm1) capacitor c=2.42507e-16
    c5975 (\540\:VDDA \521\:GNDA) capacitor c=1.34014e-17
    c5976 (\24\:GNDA \218\:GNDA) capacitor c=1.44782e-14
    c5977 (\124\:VDDA \30\:BG_REF) capacitor c=4.86031e-17
    c5978 (\207\:GNDA \1167\:GNDA) capacitor c=3.22597e-17
    c5979 (\539\:GNDA \28\:GNDA) capacitor c=1.72244e-17
    c5980 (\118\:VDDA \279\:VDDA) capacitor c=2.95619e-16
    c5981 (\72\:S2 \25\:vv) capacitor c=1.24156e-16
    c5982 (\193\:VDDA \16\:S) capacitor c=1.22542e-16
    c5983 (\163\:S \69\:Vo1) capacitor c=1.84704e-16
    c5984 (\21\:vv \776\:VDDA) capacitor c=7.15985e-16
    c5985 (\42\:U \180\:GNDA) capacitor c=8.85297e-17
    c5986 (\214\:Vm1 \101\:Vm1) capacitor c=1.06629e-15
    c5987 (\896\:GNDA \1172\:GNDA) capacitor c=2.26384e-15
    c5988 (\205\:GNDA \154\:GNDA) capacitor c=3.40138e-17
    c5989 (\185\:VDDA \21\:VDDA) capacitor c=1.05292e-15
    c5990 (\65\:BG_REF \9\:S2) capacitor c=1.59453e-17
    c5991 (\569\:VDDA \534\:VDDA) capacitor c=2.66327e-16
    c5992 (\14\:U \230\:GNDA) capacitor c=1.50635e-16
    c5993 (\2\:net14 \218\:GNDA) capacitor c=4.04586e-16
    c5994 (\807\:VDDA \279\:VDDA) capacitor c=4.1746e-16
    c5995 (\290\:VDDA \426\:VDDA) capacitor c=5.88719e-16
    c5996 (\641\:GNDA \443\:GNDA) capacitor c=4.68028e-17
    c5997 (\16\:U \1251\:GNDA) capacitor c=1.70063e-15
    c5998 (\1138\:GNDA \1034\:GNDA) capacitor c=9.29257e-17
    c5999 (\296\:VDDA \279\:VDDA) capacitor c=4.0904e-16
    c6000 (\152\:Vm1 \263\:VDDA) capacitor c=3.46264e-16
    c6001 (\144\:VDDA \39\:BG_REF) capacitor c=2.50306e-17
    c6002 (\535\:GNDA \1251\:GNDA) capacitor c=3.9119e-15
    c6003 (\34\:X \32\:GNDA) capacitor c=5.31728e-16
    c6004 (\297\:Vm1 \230\:GNDA) capacitor c=3.52843e-16
    c6005 (\14\:Y \14\:X) capacitor c=6.75281e-16
    c6006 (\116\:BG_REF \226\:S) capacitor c=2.56266e-15
    c6007 (\905\:GNDA \998\:GNDA) capacitor c=3.77442e-15
    c6008 (\34\:vv \910\:VDDA) capacitor c=1.19335e-15
    c6009 (\198\:Vm1 \85\:Vm1) capacitor c=1.82422e-16
    c6010 (\91\:U \712\:GNDA) capacitor c=1.63679e-16
    c6011 (\243\:S \146\:S) capacitor c=6.55901e-15
    c6012 (\1138\:GNDA \1172\:GNDA) capacitor c=3.14542e-16
    c6013 (\132\:GNDA \19\:Vo1) capacitor c=5.04784e-16
    c6014 (\623\:VDDA \24\:vv) capacitor c=9.82979e-16
    c6015 (\4\:Y \102\:S) capacitor c=1.27925e-15
    c6016 (\200\:Vm1 \401\:VDDA) capacitor c=3.4614e-16
    c6017 (\192\:GNDA \35\:U) capacitor c=3.38563e-16
    c6018 (\91\:U \756\:GNDA) capacitor c=6.78232e-17
    c6019 (\144\:GNDA \143\:GNDA) capacitor c=1.8573e-16
    c6020 (\64\:U \1167\:GNDA) capacitor c=1.08835e-16
    c6021 (\178\:GNDA \173\:GNDA) capacitor c=9.29257e-17
    c6022 (\17\:vv \205\:S) capacitor c=4.94389e-16
    c6023 (\248\:Vm1 \230\:GNDA) capacitor c=1.8437e-16
    c6024 (\1511\:GNDA \1251\:GNDA) capacitor c=2.94546e-16
    c6025 (\24\:U \959\:GNDA) capacitor c=5.64553e-17
    c6026 (\2\:net15 \2\:net19) capacitor c=2.76872e-17
    c6027 (\239\:S \152\:VDDA) capacitor c=1.23137e-17
    c6028 (\193\:GNDA \1421\:GNDA) capacitor c=3.24841e-17
    c6029 (\17\:GNDA \18\:GNDA) capacitor c=3.69429e-16
    c6030 (\637\:VDDA \517\:VDDA) capacitor c=7.68015e-16
    c6031 (\521\:GNDA \1251\:GNDA) capacitor c=5.50954e-15
    c6032 (\995\:GNDA \996\:GNDA) capacitor c=4.12292e-16
    c6033 (\59\:U \1251\:GNDA) capacitor c=7.1556e-17
    c6034 (\4\:GNDA \218\:GNDA) capacitor c=4.63584e-16
    c6035 (\196\:Vm1 \83\:Vm1) capacitor c=1.06182e-15
    c6036 (\12\:S2 \11\:S2) capacitor c=4.58151e-16
    c6037 (\649\:VDDA \279\:VDDA) capacitor c=3.01234e-16
    c6038 (\75\:S2 \31\:BG_REF) capacitor c=1.11867e-17
    c6039 (\22\:U \794\:GNDA) capacitor c=5.82324e-17
    c6040 (\286\:Vm1 \19\:vv) capacitor c=2.66552e-16
    c6041 (\657\:GNDA \203\:GNDA) capacitor c=9.03531e-16
    c6042 (\272\:Vm1 \230\:GNDA) capacitor c=2.64894e-16
    c6043 (\35\:S \279\:VDDA) capacitor c=8.29159e-16
    c6044 (\120\:VDDA \26\:BG_REF) capacitor c=4.86031e-17
    c6045 (\664\:GNDA \1324\:GNDA) capacitor c=3.7074e-17
    c6046 (\45\:U \1447\:GNDA) capacitor c=7.7462e-17
    c6047 (\393\:VDDA \81\:BG_REF) capacitor c=1.48876e-17
    c6048 (\251\:S \53\:D1) capacitor c=1.67678e-16
    c6049 (\62\:S \60\:S) capacitor c=1.23714e-15
    c6050 (\1545\:GNDA \9\:D2) capacitor c=5.19552e-16
    c6051 (\25\:Vo1 \81\:S) capacitor c=2.23535e-16
    c6052 (\238\:S \327\:VDDA) capacitor c=1.23137e-17
    c6053 (net12 \31\:GNDA) capacitor c=5.23615e-16
    c6054 (net31 \31\:GNDA) capacitor c=4.98168e-17
    c6055 (net16 \31\:GNDA) capacitor c=4.80417e-15
    c6056 (net2 \31\:GNDA) capacitor c=6.65403e-16
    c6057 (net23 \80\:GNDA) capacitor c=1.96936e-15
    c6058 (net11 \218\:GNDA) capacitor c=4.13042e-16
    c6059 (\2\:net32 net37) capacitor c=2.31537e-17
    c6060 (net8 \2\:net28) capacitor c=8.44662e-17
    c6061 (net3 \2\:net30) capacitor c=4.29235e-17
    c6062 (net33 \52\:GNDA) capacitor c=2.71689e-15
    c6063 (Vs \2\:Vs) capacitor c=5.03374e-16
    c6064 (net41 net33) capacitor c=7.35964e-17
    c6065 (net12 \46\:GNDA) capacitor c=2.00332e-16
    c6066 (net26 \2\:net12) capacitor c=8.44841e-17
    c6067 (S2 \44\:S2) capacitor c=9.62457e-17
    c6068 (net9 net3) capacitor c=8.07657e-17
    c6069 (net27 \218\:GNDA) capacitor c=5.50484e-16
    c6070 (\1\:BG_REF \6\:BG_REF) capacitor c=3.17124e-15
    c6071 (net11 net29) capacitor c=1.41407e-16
    c6072 (net23 \218\:GNDA) capacitor c=4.01607e-16
    c6073 (\94\:GNDA net34) capacitor c=2.07397e-16
    c6074 (net28 \66\:GNDA) capacitor c=2.38976e-16
    c6075 (net11 \2\:net33) capacitor c=2.22608e-17
    c6076 (U \106\:GNDA) capacitor c=7.3903e-16
    c6077 (Vo2 \539\:GNDA) capacitor c=4.90974e-17
    c6078 (\85\:GNDA U) capacitor c=1.85658e-16
    c6079 (net31 \2\:net6) capacitor c=1.94203e-16
    c6080 (net15 \52\:GNDA) capacitor c=3.95942e-15
    c6081 (net38 \218\:GNDA) capacitor c=3.97673e-16
    c6082 (net12 net2) capacitor c=2.20071e-16
    c6083 (\135\:BG_REF net31) capacitor c=2.12339e-17
    c6084 (\59\:GNDA net19) capacitor c=4.98168e-17
    c6085 (\32\:GNDA net20) capacitor c=1.37742e-16
    c6086 (\2\:net38 net34) capacitor c=3.99703e-17
    c6087 (\549\:GNDA \6\:BG_REF) capacitor c=3.07088e-16
    c6088 (net37 \218\:GNDA) capacitor c=3.33814e-16
    c6089 (\26\:GNDA net16) capacitor c=1.18656e-16
    c6090 (net16 net12) capacitor c=7.43544e-17
    c6091 (Vo1 \539\:GNDA) capacitor c=1.04194e-17
    c6092 (net38 \94\:GNDA) capacitor c=2.9976e-15
    c6093 (\230\:GNDA \6\:BG_REF) capacitor c=1.7247e-16
    c6094 (Vo2 Vo1) capacitor c=1.0387e-16
    c6095 (net8 \2\:net13) capacitor c=4.10664e-17
    c6096 (net33 \53\:GNDA) capacitor c=5.93045e-17
    c6097 (\2\:net2 net30) capacitor c=1.24232e-17
    c6098 (net34 \100\:GNDA) capacitor c=3.57536e-16
    c6099 (net22 \2\:net40) capacitor c=2.17556e-16
    c6100 (net41 \18\:GNDA) capacitor c=7.75197e-16
    c6101 (net21 \218\:GNDA) capacitor c=6.2212e-16
    c6102 (\2\:GNDA net39) capacitor c=8.68475e-16
    c6103 (\2\:net40 net24) capacitor c=8.27555e-17
    c6104 (net32 \52\:GNDA) capacitor c=1.3503e-15
    c6105 (net1 \218\:GNDA) capacitor c=4.57511e-16
    c6106 (net25 \66\:GNDA) capacitor c=9.58967e-16
    c6107 (\58\:S S) capacitor c=4.78804e-16
    c6108 (net41 net15) capacitor c=3.70918e-17
    c6109 (net34 \218\:GNDA) capacitor c=3.50963e-16
    c6110 (net9 \2\:net12) capacitor c=4.10664e-17
    c6111 (\106\:GNDA net27) capacitor c=1.37189e-16
    c6112 (\34\:X net33) capacitor c=8.50515e-16
    c6113 (\9\:BG_REF \6\:BG_REF) capacitor c=1.98688e-15
    c6114 (net28 net10) capacitor c=7.08747e-17
    c6115 (net12 \2\:net6) capacitor c=3.73374e-17
    c6116 (net36 \39\:GNDA) capacitor c=1.76365e-15
    c6117 (Vm1 \2\:Vm1) capacitor c=6.45654e-16
    c6118 (\110\:Vm1 Vm1) capacitor c=1.79353e-16
    c6119 (net28 \85\:GNDA) capacitor c=1.61076e-15
    c6120 (net9 \218\:GNDA) capacitor c=4.5759e-16
    c6121 (\39\:GNDA net18) capacitor c=1.89448e-16
    c6122 (\88\:GNDA net8) capacitor c=2.70601e-16
    c6123 (\44\:Vo1 Vo2) capacitor c=6.09349e-17
    c6124 (net34 \8\:GNDA) capacitor c=4.3382e-16
    c6125 (GNDA \1251\:GNDA) capacitor c=1.34385e-15
    c6126 (\2\:net17 net17) capacitor c=2.80613e-17
    c6127 (\34\:X net41) capacitor c=9.61206e-17
    c6128 (\6\:BG_REF \684\:GNDA) capacitor c=1.92057e-17
    c6129 (\2\:net40 net36) capacitor c=4.27037e-17
    c6130 (\20\:BG_REF \6\:BG_REF) capacitor c=1.51431e-15
    c6131 (net18 net41) capacitor c=2.78671e-16
    c6132 (net3 \593\:GNDA) capacitor c=3.66145e-17
    c6133 (net36 \40\:GNDA) capacitor c=2.50282e-16
    c6134 (net16 net2) capacitor c=7.08045e-17
    c6135 (net31 \218\:GNDA) capacitor c=3.59834e-16
    c6136 (net18 \18\:GNDA) capacitor c=2.50907e-16
    c6137 (net29 net13) capacitor c=3.98644e-17
    c6138 (\230\:GNDA net22) capacitor c=1.02822e-16
    c6139 (net20 \39\:GNDA) capacitor c=1.02323e-16
    c6140 (net2 \2\:net33) capacitor c=3.4031e-17
    c6141 (net17 \94\:GNDA) capacitor c=2.19134e-15
    c6142 (net14 \218\:GNDA) capacitor c=4.00996e-16
    c6143 (\2\:net24 net36) capacitor c=7.10693e-17
    c6144 (net2 \51\:GNDA) capacitor c=1.8348e-16
    c6145 (\2\:net24 net40) capacitor c=3.20596e-16
    c6146 (\2\:net34 net17) capacitor c=4.80876e-17
    c6147 (net10 \106\:GNDA) capacitor c=1.23251e-15
    c6148 (net15 \59\:GNDA) capacitor c=4.97753e-17
    c6149 (net7 \2\:net1) capacitor c=3.10595e-17
    c6150 (Vo2 \1251\:GNDA) capacitor c=3.92323e-17
    c6151 (net15 net32) capacitor c=8.1322e-18
    c6152 (net14 \93\:GNDA) capacitor c=2.30725e-15
    c6153 (net1 \109\:GNDA) capacitor c=9.28404e-16
    c6154 (net19 \218\:GNDA) capacitor c=3.42372e-16
    c6155 (net8 net1) capacitor c=8.07657e-17
    c6156 (\2\:net31 net6) capacitor c=2.181e-16
    c6157 (\4\:GNDA net35) capacitor c=1.21954e-16
    c6158 (net1 \110\:GNDA) capacitor c=2.10813e-15
    c6159 (net17 \100\:GNDA) capacitor c=1.31667e-15
    c6160 (\2\:net15 net37) capacitor c=1.92808e-17
    c6161 (net32 \59\:GNDA) capacitor c=4.98168e-17
    c6162 (net10 \218\:GNDA) capacitor c=3.9507e-16
    c6163 (\25\:Vo1 Y) capacitor c=2.39723e-17
    c6164 (GNDA \250\:GNDA) capacitor c=2.55221e-17
    c6165 (\18\:GNDA net39) capacitor c=2.25548e-16
    c6166 (\70\:GNDA net25) capacitor c=1.85658e-16
    c6167 (net11 \63\:GNDA) capacitor c=3.10922e-15
    c6168 (net35 \218\:GNDA) capacitor c=3.60452e-16
    c6169 (net29 \66\:GNDA) capacitor c=5.34636e-16
    c6170 (net26 \2\:net31) capacitor c=4.12724e-17
    c6171 (net21 \94\:GNDA) capacitor c=1.00266e-16
    c6172 (\944\:GNDA \6\:BG_REF) capacitor c=2.64194e-17
    c6173 (net4 \52\:GNDA) capacitor c=3.00435e-15
    c6174 (net8 \90\:GNDA) capacitor c=2.24466e-15
    c6175 (net32 net19) capacitor c=1.40709e-16
    c6176 (\34\:X net40) capacitor c=2.27043e-17
    c6177 (\23\:S2 vv) capacitor c=1.2327e-16
    c6178 (net30 \218\:GNDA) capacitor c=4.16576e-16
    c6179 (net41 \52\:GNDA) capacitor c=6.31797e-16
    c6180 (\2\:net15 net28) capacitor c=1.06128e-16
    c6181 (U \93\:GNDA) capacitor c=4.97753e-17
    c6182 (net8 \218\:GNDA) capacitor c=4.63757e-16
    c6183 (net9 \49\:GNDA) capacitor c=1.87827e-15
    c6184 (net2 \218\:GNDA) capacitor c=4.24167e-16
    c6185 (\3\:BG_REF \6\:BG_REF) capacitor c=2.59448e-15
    c6186 (net13 \85\:GNDA) capacitor c=4.97753e-17
    c6187 (net7 \2\:net10) capacitor c=1.27649e-16
    c6188 (net1 \2\:net10) capacitor c=8.12897e-17
    c6189 (\3\:Vs vv) capacitor c=1.2327e-16
    c6190 (\110\:GNDA net7) capacitor c=4.44394e-16
    c6191 (net41 \53\:GNDA) capacitor c=3.49468e-15
    c6192 (\135\:BG_REF net6) capacitor c=6.09287e-17
    c6193 (net3 \66\:GNDA) capacitor c=9.65795e-16
    c6194 (net7 \218\:GNDA) capacitor c=4.84405e-16
    c6195 (\15\:GNDA net39) capacitor c=1.59375e-17
    c6196 (net12 \2\:net16) capacitor c=1.6179e-16
    c6197 (net1 \2\:net28) capacitor c=3.4988e-17
    c6198 (net3 \49\:GNDA) capacitor c=2.45977e-15
    c6199 (Vo2 \3\:Vo1) capacitor c=1.0383e-16
    c6200 (\34\:X net29) capacitor c=2.81679e-16
    c6201 (net26 \218\:GNDA) capacitor c=4.59983e-16
    c6202 (Vo1 \1251\:GNDA) capacitor c=7.82368e-17
    c6203 (net10 \109\:GNDA) capacitor c=2.36374e-16
    c6204 (net41 \59\:GNDA) capacitor c=3.76706e-16
    c6205 (\55\:S S) capacitor c=4.21131e-16
    c6206 (net15 \63\:GNDA) capacitor c=4.58211e-15
    c6207 (net32 \218\:GNDA) capacitor c=3.68894e-16
    c6208 (net21 \8\:GNDA) capacitor c=8.31032e-16
    c6209 (net41 \218\:GNDA) capacitor c=4.33281e-16
    c6210 (net13 \66\:GNDA) capacitor c=1.22251e-15
    c6211 (\14\:GNDA net39) capacitor c=1.67422e-16
    c6212 (net27 \114\:GNDA) capacitor c=1.92345e-17
    c6213 (net20 \18\:Y) capacitor c=3.37687e-17
    c6214 (net33 \2\:net20) capacitor c=4.3224e-16
    c6215 (\2\:net2 net15) capacitor c=9.65064e-16
    c6216 (net4 \218\:GNDA) capacitor c=7.13925e-16
    c6217 (net23 \52\:GNDA) capacitor c=4.98168e-17
    c6218 (\2\:net11 net29) capacitor c=4.92232e-16
    c6219 (net1 \111\:GNDA) capacitor c=4.3189e-16
    c6220 (\34\:X net4) capacitor c=6.72274e-16
    c6221 (\22\:Vo1 S) capacitor c=1.40703e-16
    c6222 (net14 \100\:GNDA) capacitor c=1.02323e-16
    c6223 (\13\:GNDA net39) capacitor c=1.30117e-17
    c6224 (\2\:net2 net29) capacitor c=2.277e-17
    c6225 (net21 \9\:GNDA) capacitor c=2.96565e-15
    c6226 (net20 \218\:GNDA) capacitor c=3.60112e-16
    c6227 (net38 \80\:GNDA) capacitor c=6.17008e-16
    c6228 (net28 \2\:net8) capacitor c=7.40965e-17
    c6229 (net15 \2\:net33) capacitor c=8.96696e-17
    c6230 (net2 \56\:GNDA) capacitor c=5.74407e-16
    c6231 (net41 \2\:net36) capacitor c=8.18913e-17
    c6232 (net6 \28\:GNDA) capacitor c=1.98144e-15
    c6233 (GNDA \230\:GNDA) capacitor c=5.14199e-16
    c6234 (\2\:net23 net38) capacitor c=7.77488e-17
    c6235 (\230\:GNDA net21) capacitor c=1.93435e-16
    c6236 (\90\:GNDA net1) capacitor c=9.9024e-17
    c6237 (net39 \218\:GNDA) capacitor c=5.81621e-16
    c6238 (\14\:U net10) capacitor c=5.07599e-16
    c6239 (net15 \2\:net11) capacitor c=2.25713e-16
    c6240 (\2\:net37 net19) capacitor c=4.31971e-17
    c6241 (\768\:GNDA Vo2) capacitor c=1.49148e-16
    c6242 (net11 \66\:GNDA) capacitor c=4.98168e-17
    c6243 (\10\:GNDA net21) capacitor c=3.6317e-16
    c6244 (net13 \2\:net29) capacitor c=8.31408e-17
    c6245 (net16 \27\:GNDA) capacitor c=2.12462e-15
    c6246 (net40 net36) capacitor c=4.60745e-17
    c6247 (\16\:BG_REF net31) capacitor c=1.66053e-16
    c6248 (net31 \28\:GNDA) capacitor c=1.01607e-15
    c6249 (net10 U) capacitor c=7.83081e-18
    c6250 (\718\:GNDA Vs) capacitor c=9.37677e-17
    c6251 (net18 \218\:GNDA) capacitor c=3.78847e-16
    c6252 (\14\:U net27) capacitor c=1.24914e-15
    c6253 (\51\:GNDA net11) capacitor c=2.96346e-16
    c6254 (net30 \2\:net16) capacitor c=1.79459e-16
    c6255 (net30 net2) capacitor c=3.25064e-16
    c6256 (\18\:BG_REF \6\:BG_REF) capacitor c=2.98147e-16
    c6257 (\59\:GNDA net23) capacitor c=3.544e-16
    c6258 (net1 net7) capacitor c=8.60372e-17
    c6259 (net20 \42\:GNDA) capacitor c=1.93915e-15
    c6260 (Vo2 \728\:GNDA) capacitor c=1.48402e-16
    c6261 (net27 \116\:GNDA) capacitor c=1.68264e-15
    c6262 (net30 \2\:net9) capacitor c=7.17145e-17
    c6263 (net25 \89\:GNDA) capacitor c=4.25592e-16
    c6264 (\2\:net2 net11) capacitor c=8.0669e-16
    c6265 (\2\:net35 net35) capacitor c=2.75172e-17
    c6266 (net28 \218\:GNDA) capacitor c=4.06291e-16
    c6267 (net30 \56\:GNDA) capacitor c=2.66073e-16
    c6268 (net2 \2\:net16) capacitor c=1.88124e-15
    c6269 (net7 \115\:GNDA) capacitor c=3.52506e-15
    c6270 (net19 net37) capacitor c=1.39931e-16
    c6271 (\2\:net19 net19) capacitor c=2.88602e-17
    c6272 (net15 net4) capacitor c=8.18913e-17
    c6273 (\35\:X net29) capacitor c=5.5981e-16
    c6274 (\728\:GNDA Vo1) capacitor c=8.84603e-17
    c6275 (net2 \43\:GNDA) capacitor c=3.86626e-16
    c6276 (U \218\:GNDA) capacitor c=3.8539e-16
    c6277 (net28 \2\:net25) capacitor c=4.61817e-17
    c6278 (\14\:U U) capacitor c=6.13532e-16
    c6279 (net15 net11) capacitor c=3.68283e-16
    c6280 (\34\:X net32) capacitor c=1.21353e-15
    c6281 (\52\:GNDA net35) capacitor c=4.98168e-17
    c6282 (\2\:net32 net4) capacitor c=7.37907e-16
    c6283 (net12 \218\:GNDA) capacitor c=4.20256e-16
    c6284 (\29\:GNDA net9) capacitor c=2.68851e-16
    c6285 (net40 \23\:GNDA) capacitor c=4.61964e-16
    c6286 (net18 \53\:GNDA) capacitor c=7.54044e-16
    c6287 (net16 \16\:BG_REF) capacitor c=2.00174e-16
    c6288 (net32 net37) capacitor c=4.50298e-17
    c6289 (net15 \218\:GNDA) capacitor c=4.65645e-16
    c6290 (\23\:GNDA net36) capacitor c=7.41497e-17
    c6291 (net26 \29\:GNDA) capacitor c=2.23314e-15
    c6292 (S \102\:S) capacitor c=2.21526e-15
    c6293 (net25 \218\:GNDA) capacitor c=4.58812e-16
    c6294 (net39 \11\:GNDA) capacitor c=7.74971e-16
    c6295 (net29 \2\:net3) capacitor c=4.02594e-17
    c6296 (\15\:BG_REF net6) capacitor c=1.27649e-16
    c6297 (net38 net34) capacitor c=4.70881e-17
    c6298 (net21 \2\:net38) capacitor c=5.40023e-16
    c6299 (net31 net6) capacitor c=1.95439e-16
    c6300 (net9 \55\:GNDA) capacitor c=1.3676e-15
    c6301 (net3 \3\:GNDA) capacitor c=7.90326e-17
    c6302 (net10 net27) capacitor c=7.02026e-17
    c6303 (net30 \51\:GNDA) capacitor c=8.47394e-16
    c6304 (S2 \2\:vv) capacitor c=2.65493e-17
    c6305 (net40 \24\:GNDA) capacitor c=2.92154e-15
    c6306 (\116\:U net7) capacitor c=1.83952e-15
    c6307 (net39 \12\:GNDA) capacitor c=3.09049e-15
    c6308 (net29 \63\:GNDA) capacitor c=2.5022e-15
    c6309 (\24\:GNDA net36) capacitor c=1.9052e-16
    c6310 (net34 \2\:net17) capacitor c=4.68494e-16
    c6311 (net6 \218\:GNDA) capacitor c=3.66312e-16
    c6312 (net25 \2\:net13) capacitor c=8.20024e-17
    c6313 (net24 \218\:GNDA) capacitor c=3.56554e-16
    c6314 (net37 \2\:net4) capacitor c=2.93881e-17
    c6315 (\1532\:GNDA GNDA) capacitor c=1.43546e-17
    c6316 (\1523\:GNDA GNDA) capacitor c=1.43546e-17
    c6317 (net40 \218\:GNDA) capacitor c=3.84591e-16
    c6318 (net26 \46\:GNDA) capacitor c=1.37313e-15
    c6319 (net25 net8) capacitor c=8.33627e-17
    c6320 (net35 \59\:GNDA) capacitor c=3.52304e-15
    c6321 (\42\:GNDA net33) capacitor c=2.58673e-16
    c6322 (\7\:BG_REF \6\:BG_REF) capacitor c=2.0407e-15
    c6323 (net12 \2\:net26) capacitor c=8.09407e-17
    c6324 (net30 \55\:GNDA) capacitor c=2.34359e-16
    c6325 (net3 \1\:GNDA) capacitor c=9.7344e-17
    c6326 (net12 net30) capacitor c=8.23399e-17
    c6327 (net24 \23\:GNDA) capacitor c=1.39019e-16
    c6328 (\18\:S2 S2) capacitor c=1.04621e-16
    c6329 (net22 \218\:GNDA) capacitor c=1.51783e-15
    c6330 (net26 net9) capacitor c=8.07657e-17
    c6331 (net22 \23\:GNDA) capacitor c=3.67785e-15
    c6332 (net18 \2\:net36) capacitor c=6.99581e-17
    c6333 (net12 \43\:GNDA) capacitor c=8.64872e-16
    c6334 (net8 \66\:GNDA) capacitor c=9.93157e-16
    c6335 (net16 \218\:GNDA) capacitor c=4.52569e-16
    c6336 (net36 \218\:GNDA) capacitor c=4.00652e-16
    c6337 (net24 \24\:GNDA) capacitor c=1.06082e-15
    c6338 (\20\:D1 X) capacitor c=2.39703e-17
    c6339 (\15\:S2 S2) capacitor c=1.02549e-16
    c6340 (\24\:GNDA net22) capacitor c=2.84162e-16
    c6341 (\40\:GNDA net18) capacitor c=1.57189e-16
    c6342 (net33 \2\:net41) capacitor c=2.10312e-16
    c6343 (\43\:GNDA net30) capacitor c=1.32889e-16
    c6344 (net10 \2\:net1) capacitor c=7.33035e-17
    c6345 (\6\:BG_REF \550\:GNDA) capacitor c=4.57437e-13
    c6346 (net17 \218\:GNDA) capacitor c=3.37976e-16
    c6347 (\2\:net18 net41) capacitor c=5.45669e-16
    c6348 (net34 net17) capacitor c=1.38889e-16
    c6349 (net33 \218\:GNDA) capacitor c=4.63009e-16
    c6350 (net9 \2\:net30) capacitor c=8.44841e-17
    c6351 (net37 \2\:net19) capacitor c=4.2249e-16
    c6352 (\34\:X net20) capacitor c=8.80314e-16
    c6353 (net4 net37) capacitor c=2.56773e-15
    c6354 (net29 \218\:GNDA) capacitor c=3.83516e-16
    c6355 (net30 \2\:net26) capacitor c=4.72328e-17
    c6356 (net25 \2\:net29) capacitor c=3.79326e-17
    c6357 (\34\:X net15) capacitor c=1.21562e-15
    c6358 (net24 net40) capacitor c=4.17082e-16
    c6359 (D1 \1251\:GNDA) capacitor c=2.02814e-15
    c6360 (\10\:Vs Vs) capacitor c=1.40233e-16
    c6361 (\85\:GNDA net10) capacitor c=1.36779e-16
    c6362 (net19 \52\:GNDA) capacitor c=3.43017e-15
    c6363 (net2 \42\:GNDA) capacitor c=4.97753e-17
    c6364 (\561\:GNDA \6\:BG_REF) capacitor c=3.6021e-16
    c6365 (\2\:net35 net23) capacitor c=6.55736e-17
    c6366 (\4\:Vo1 Vo2) capacitor c=5.74443e-18
    c6367 (net10 \2\:net8) capacitor c=4.63719e-17
    c6368 (net33 \2\:net16) capacitor c=1.80622e-17
    c6369 (net13 \218\:GNDA) capacitor c=3.74254e-16
    c6370 (net38 net17) capacitor c=1.21597e-16
    c6371 (net27 \2\:net7) capacitor c=1.85841e-15
    c6372 (vv \44\:S2) capacitor c=9.0147e-17
    c6373 (net3 \218\:GNDA) capacitor c=4.54185e-16
    c6374 (net30 net11) capacitor c=6.86285e-17
    c6375 (net13 \2\:net25) capacitor c=3.03244e-16
    c6376 (Vo2 \2\:Vo1) capacitor c=5.57307e-17
    c6377 (net37 \52\:GNDA) capacitor c=7.89961e-16
    c6378 (\2\:Vo2 Vo1) capacitor c=9.68336e-18
    c6379 (net14 \2\:net4) capacitor c=3.49913e-17
    c6380 (net32 net4) capacitor c=3.75268e-16
    c6381 (D2 \1251\:GNDA) capacitor c=1.90652e-15
    c6382 (net15 \2\:net41) capacitor c=3.11941e-16
    c6383 (net25 \88\:GNDA) capacitor c=2.05912e-15
    c6384 (\16\:vv \63\:BG_REF) capacitor c=8.56651e-18
    c6385 (\16\:vv \71\:BG_REF) capacitor c=8.56651e-18
    c6386 (\75\:S2 \229\:VDDA) capacitor c=4.89293e-18
    c6387 (\75\:S2 \264\:VDDA) capacitor c=4.89293e-18
    c6388 (\73\:S2 \91\:VDDA) capacitor c=4.89293e-18
    c6389 (\73\:S2 \121\:VDDA) capacitor c=4.89293e-18
    c6390 (\73\:S2 \157\:VDDA) capacitor c=4.89293e-18
    c6391 (\73\:S2 \192\:VDDA) capacitor c=4.89293e-18
    c6392 (\73\:S2 \227\:VDDA) capacitor c=4.89293e-18
    c6393 (\73\:S2 \262\:VDDA) capacitor c=4.89293e-18
    c6394 (\71\:S2 \89\:VDDA) capacitor c=4.89293e-18
    c6395 (\71\:S2 \119\:VDDA) capacitor c=4.89293e-18
    c6396 (\71\:S2 \155\:VDDA) capacitor c=4.89293e-18
    c6397 (\68\:S2 \87\:VDDA) capacitor c=4.89293e-18
    c6398 (\68\:S2 \117\:VDDA) capacitor c=4.89293e-18
    c6399 (\68\:S2 \153\:VDDA) capacitor c=4.89293e-18
    c6400 (\68\:S2 \188\:VDDA) capacitor c=4.89293e-18
    c6401 (\68\:S2 \223\:VDDA) capacitor c=4.89293e-18
    c6402 (\68\:S2 \258\:VDDA) capacitor c=4.89293e-18
    c6403 (\66\:S2 \204\:VDDA) capacitor c=4.89293e-18
    c6404 (\66\:S2 \239\:VDDA) capacitor c=4.89293e-18
    c6405 (\66\:S2 \274\:VDDA) capacitor c=4.89293e-18
    c6406 (\76\:S2 \303\:VDDA) capacitor c=4.89293e-18
    c6407 (\76\:S2 \338\:VDDA) capacitor c=4.89293e-18
    c6408 (\76\:S2 \373\:VDDA) capacitor c=4.89293e-18
    c6409 (\76\:S2 \408\:VDDA) capacitor c=4.89293e-18
    c6410 (\76\:S2 \463\:VDDA) capacitor c=4.89293e-18
    c6411 (\76\:S2 \483\:VDDA) capacitor c=4.89293e-18
    c6412 (\76\:S2 \512\:VDDA) capacitor c=4.89293e-18
    c6413 (\102\:S2 \301\:VDDA) capacitor c=4.89293e-18
    c6414 (\102\:S2 \336\:VDDA) capacitor c=4.89293e-18
    c6415 (\102\:S2 \371\:VDDA) capacitor c=4.89293e-18
    c6416 (\102\:S2 \406\:VDDA) capacitor c=4.89293e-18
    c6417 (\102\:S2 \461\:VDDA) capacitor c=4.89293e-18
    c6418 (\102\:S2 \481\:VDDA) capacitor c=4.89293e-18
    c6419 (\102\:S2 \510\:VDDA) capacitor c=4.89293e-18
    c6420 (\74\:S2 \299\:VDDA) capacitor c=4.89293e-18
    c6421 (\74\:S2 \334\:VDDA) capacitor c=4.89293e-18
    c6422 (\74\:S2 \369\:VDDA) capacitor c=4.89293e-18
    c6423 (\74\:S2 \404\:VDDA) capacitor c=4.89293e-18
    c6424 (\74\:S2 \459\:VDDA) capacitor c=4.89293e-18
    c6425 (\74\:S2 \479\:VDDA) capacitor c=4.89293e-18
    c6426 (\74\:S2 \508\:VDDA) capacitor c=4.89293e-18
    c6427 (\72\:S2 \297\:VDDA) capacitor c=4.89293e-18
    c6428 (\72\:S2 \332\:VDDA) capacitor c=4.89293e-18
    c6429 (\72\:S2 \367\:VDDA) capacitor c=4.89293e-18
    c6430 (\72\:S2 \457\:VDDA) capacitor c=4.89293e-18
    c6431 (\72\:S2 \477\:VDDA) capacitor c=4.89293e-18
    c6432 (\72\:S2 \506\:VDDA) capacitor c=4.89293e-18
    c6433 (\69\:S2 \400\:VDDA) capacitor c=4.89293e-18
    c6434 (\69\:S2 \455\:VDDA) capacitor c=4.89293e-18
    c6435 (\69\:S2 \475\:VDDA) capacitor c=4.89293e-18
    c6436 (\69\:S2 \504\:VDDA) capacitor c=4.89293e-18
    c6437 (\67\:S2 \293\:VDDA) capacitor c=4.89293e-18
    c6438 (\67\:S2 \328\:VDDA) capacitor c=4.89293e-18
    c6439 (\67\:S2 \363\:VDDA) capacitor c=4.89293e-18
    c6440 (\67\:S2 \398\:VDDA) capacitor c=4.89293e-18
    c6441 (\67\:S2 \453\:VDDA) capacitor c=4.89293e-18
    c6442 (\67\:S2 \473\:VDDA) capacitor c=4.89293e-18
    c6443 (\67\:S2 \502\:VDDA) capacitor c=4.89293e-18
    c6444 (\65\:S2 \309\:VDDA) capacitor c=4.89293e-18
    c6445 (\65\:S2 \344\:VDDA) capacitor c=4.89293e-18
    c6446 (\65\:S2 \379\:VDDA) capacitor c=4.89293e-18
    c6447 (\65\:S2 \414\:VDDA) capacitor c=4.89293e-18
    c6448 (\65\:S2 \469\:VDDA) capacitor c=4.89293e-18
    c6449 (\65\:S2 \467\:VDDA) capacitor c=4.89293e-18
    c6450 (\65\:S2 \500\:VDDA) capacitor c=4.89293e-18
    c6451 (\9\:S2 \190\:VDDA) capacitor c=4.89293e-18
    c6452 (\9\:S2 \225\:VDDA) capacitor c=4.89293e-18
    c6453 (\9\:S2 \260\:VDDA) capacitor c=4.89293e-18
    c6454 (\9\:S2 \295\:VDDA) capacitor c=4.89293e-18
    c6455 (\9\:S2 \330\:VDDA) capacitor c=4.89293e-18
    c6456 (\9\:S2 \365\:VDDA) capacitor c=4.89293e-18
    c6457 (\66\:S2 \131\:VDDA) capacitor c=5.21457e-18
    c6458 (\66\:S2 \202\:VDDA) capacitor c=5.31335e-18
    c6459 (\66\:S2 \237\:VDDA) capacitor c=5.31335e-18
    c6460 (\66\:S2 \272\:VDDA) capacitor c=5.31335e-18
    c6461 (\65\:S2 \307\:VDDA) capacitor c=5.31335e-18
    c6462 (\65\:S2 \342\:VDDA) capacitor c=5.31335e-18
    c6463 (\65\:S2 \377\:VDDA) capacitor c=5.31335e-18
    c6464 (\65\:S2 \412\:VDDA) capacitor c=5.31335e-18
    c6465 (\66\:S2 \167\:VDDA) capacitor c=5.31335e-18
    c6466 (\74\:S2 \480\:VDDA) capacitor c=5.46212e-18
    c6467 (\67\:S2 \474\:VDDA) capacitor c=5.46212e-18
    c6468 (\102\:S2 \482\:VDDA) capacitor c=5.46386e-18
    c6469 (\72\:S2 \478\:VDDA) capacitor c=5.46386e-18
    c6470 (\69\:S2 \476\:VDDA) capacitor c=5.46386e-18
    c6471 (\65\:S2 \472\:VDDA) capacitor c=5.46386e-18
    c6472 (\10\:S2 \282\:VDDA) capacitor c=6.06802e-18
    c6473 (\102\:S2 \65\:VDDA) capacitor c=6.13267e-18
    c6474 (\74\:S2 \63\:VDDA) capacitor c=6.13267e-18
    c6475 (\67\:S2 \57\:VDDA) capacitor c=6.13267e-18
    c6476 (\65\:S2 \55\:VDDA) capacitor c=6.13267e-18
    c6477 (\103\:S2 \234\:VDDA) capacitor c=6.41701e-18
    c6478 (\75\:S2 \232\:VDDA) capacitor c=6.41701e-18
    c6479 (\73\:S2 \230\:VDDA) capacitor c=6.41701e-18
    c6480 (\68\:S2 \226\:VDDA) capacitor c=6.41701e-18
    c6481 (\66\:S2 \224\:VDDA) capacitor c=6.41701e-18
    c6482 (\102\:S2 \409\:VDDA) capacitor c=6.41701e-18
    c6483 (\74\:S2 \407\:VDDA) capacitor c=6.41701e-18
    c6484 (\72\:S2 \405\:VDDA) capacitor c=6.41701e-18
    c6485 (\67\:S2 \401\:VDDA) capacitor c=6.41701e-18
    c6486 (\65\:S2 \399\:VDDA) capacitor c=6.41701e-18
    c6487 (\9\:S2 \228\:VDDA) capacitor c=6.41701e-18
    c6488 (\103\:S2 \164\:VDDA) capacitor c=6.50372e-18
    c6489 (\103\:S2 \199\:VDDA) capacitor c=6.50372e-18
    c6490 (\103\:S2 \269\:VDDA) capacitor c=6.50372e-18
    c6491 (\75\:S2 \162\:VDDA) capacitor c=6.50372e-18
    c6492 (\75\:S2 \197\:VDDA) capacitor c=6.50372e-18
    c6493 (\75\:S2 \267\:VDDA) capacitor c=6.50372e-18
    c6494 (\73\:S2 \160\:VDDA) capacitor c=6.50372e-18
    c6495 (\73\:S2 \195\:VDDA) capacitor c=6.50372e-18
    c6496 (\73\:S2 \265\:VDDA) capacitor c=6.50372e-18
    c6497 (\71\:S2 \158\:VDDA) capacitor c=6.50372e-18
    c6498 (\68\:S2 \156\:VDDA) capacitor c=6.50372e-18
    c6499 (\68\:S2 \191\:VDDA) capacitor c=6.50372e-18
    c6500 (\68\:S2 \261\:VDDA) capacitor c=6.50372e-18
    c6501 (\66\:S2 \154\:VDDA) capacitor c=6.50372e-18
    c6502 (\66\:S2 \189\:VDDA) capacitor c=6.50372e-18
    c6503 (\66\:S2 \259\:VDDA) capacitor c=6.50372e-18
    c6504 (\102\:S2 \339\:VDDA) capacitor c=6.50372e-18
    c6505 (\102\:S2 \374\:VDDA) capacitor c=6.50372e-18
    c6506 (\102\:S2 \464\:VDDA) capacitor c=6.50372e-18
    c6507 (\74\:S2 \337\:VDDA) capacitor c=6.50372e-18
    c6508 (\74\:S2 \372\:VDDA) capacitor c=6.50372e-18
    c6509 (\74\:S2 \462\:VDDA) capacitor c=6.50372e-18
    c6510 (\72\:S2 \335\:VDDA) capacitor c=6.50372e-18
    c6511 (\72\:S2 \370\:VDDA) capacitor c=6.50372e-18
    c6512 (\72\:S2 \460\:VDDA) capacitor c=6.50372e-18
    c6513 (\69\:S2 \458\:VDDA) capacitor c=6.50372e-18
    c6514 (\67\:S2 \331\:VDDA) capacitor c=6.50372e-18
    c6515 (\67\:S2 \366\:VDDA) capacitor c=6.50372e-18
    c6516 (\67\:S2 \456\:VDDA) capacitor c=6.50372e-18
    c6517 (\65\:S2 \329\:VDDA) capacitor c=6.50372e-18
    c6518 (\65\:S2 \364\:VDDA) capacitor c=6.50372e-18
    c6519 (\65\:S2 \454\:VDDA) capacitor c=6.50372e-18
    c6520 (\9\:S2 \193\:VDDA) capacitor c=6.50372e-18
    c6521 (\9\:S2 \333\:VDDA) capacitor c=6.50372e-18
    c6522 (\9\:S2 \368\:VDDA) capacitor c=6.50372e-18
    c6523 (\9\:S2 \298\:VDDA) capacitor c=6.59044e-18
    c6524 (\103\:S2 \98\:VDDA) capacitor c=6.64874e-18
    c6525 (\75\:S2 \96\:VDDA) capacitor c=6.64874e-18
    c6526 (\73\:S2 \94\:VDDA) capacitor c=6.64874e-18
    c6527 (\71\:S2 \92\:VDDA) capacitor c=6.64874e-18
    c6528 (\68\:S2 \90\:VDDA) capacitor c=6.64874e-18
    c6529 (\102\:S2 \513\:VDDA) capacitor c=6.64874e-18
    c6530 (\74\:S2 \511\:VDDA) capacitor c=6.64874e-18
    c6531 (\72\:S2 \509\:VDDA) capacitor c=6.64874e-18
    c6532 (\69\:S2 \507\:VDDA) capacitor c=6.64874e-18
    c6533 (\67\:S2 \505\:VDDA) capacitor c=6.64874e-18
    c6534 (\65\:S2 \503\:VDDA) capacitor c=6.64874e-18
    c6535 (\66\:S2 \88\:VDDA) capacitor c=6.64874e-18
    c6536 (\77\:S2 \15\:VDDA) capacitor c=6.65158e-18
    c6537 (\77\:S2 \19\:VDDA) capacitor c=6.65158e-18
    c6538 (\77\:S2 \23\:VDDA) capacitor c=6.65158e-18
    c6539 (\77\:S2 \27\:VDDA) capacitor c=6.65158e-18
    c6540 (\77\:S2 \31\:VDDA) capacitor c=6.65158e-18
    c6541 (\77\:S2 \35\:VDDA) capacitor c=6.65158e-18
    c6542 (\76\:S2 \39\:VDDA) capacitor c=6.65158e-18
    c6543 (\76\:S2 \43\:VDDA) capacitor c=6.65158e-18
    c6544 (\76\:S2 \47\:VDDA) capacitor c=6.65158e-18
    c6545 (\76\:S2 \51\:VDDA) capacitor c=6.65158e-18
    c6546 (\76\:S2 \67\:VDDA) capacitor c=6.65158e-18
    c6547 (\69\:S2 \542\:VDDA) capacitor c=6.79585e-18
    c6548 (\112\:S2 \534\:VDDA) capacitor c=6.84377e-18
    c6549 (\102\:S2 \66\:VDDA) capacitor c=7.34168e-18
    c6550 (\74\:S2 \64\:VDDA) capacitor c=7.34168e-18
    c6551 (\67\:S2 \58\:VDDA) capacitor c=7.34168e-18
    c6552 (\65\:S2 \56\:VDDA) capacitor c=7.34168e-18
    c6553 (\75\:S2 \181\:VDDA) capacitor c=7.36915e-18
    c6554 (\68\:S2 \175\:VDDA) capacitor c=7.36915e-18
    c6555 (\103\:S2 \288\:VDDA) capacitor c=7.36915e-18
    c6556 (\66\:S2 \278\:VDDA) capacitor c=7.36915e-18
    c6557 (\75\:S2 \216\:VDDA) capacitor c=7.36915e-18
    c6558 (\68\:S2 \210\:VDDA) capacitor c=7.36915e-18
    c6559 (\9\:S2 \212\:VDDA) capacitor c=7.36915e-18
    c6560 (\103\:S2 \148\:VDDA) capacitor c=7.37089e-18
    c6561 (\103\:S2 \183\:VDDA) capacitor c=7.37089e-18
    c6562 (\103\:S2 \218\:VDDA) capacitor c=7.37089e-18
    c6563 (\103\:S2 \253\:VDDA) capacitor c=7.37089e-18
    c6564 (\75\:S2 \146\:VDDA) capacitor c=7.37089e-18
    c6565 (\75\:S2 \251\:VDDA) capacitor c=7.37089e-18
    c6566 (\75\:S2 \286\:VDDA) capacitor c=7.37089e-18
    c6567 (\73\:S2 \144\:VDDA) capacitor c=7.37089e-18
    c6568 (\73\:S2 \179\:VDDA) capacitor c=7.37089e-18
    c6569 (\73\:S2 \214\:VDDA) capacitor c=7.37089e-18
    c6570 (\73\:S2 \249\:VDDA) capacitor c=7.37089e-18
    c6571 (\73\:S2 \284\:VDDA) capacitor c=7.37089e-18
    c6572 (\71\:S2 \142\:VDDA) capacitor c=7.37089e-18
    c6573 (\68\:S2 \140\:VDDA) capacitor c=7.37089e-18
    c6574 (\68\:S2 \245\:VDDA) capacitor c=7.37089e-18
    c6575 (\68\:S2 \280\:VDDA) capacitor c=7.37089e-18
    c6576 (\66\:S2 \138\:VDDA) capacitor c=7.37089e-18
    c6577 (\66\:S2 \173\:VDDA) capacitor c=7.37089e-18
    c6578 (\66\:S2 \208\:VDDA) capacitor c=7.37089e-18
    c6579 (\66\:S2 \243\:VDDA) capacitor c=7.37089e-18
    c6580 (\102\:S2 \323\:VDDA) capacitor c=7.37089e-18
    c6581 (\102\:S2 \358\:VDDA) capacitor c=7.37089e-18
    c6582 (\102\:S2 \393\:VDDA) capacitor c=7.37089e-18
    c6583 (\102\:S2 \448\:VDDA) capacitor c=7.37089e-18
    c6584 (\74\:S2 \321\:VDDA) capacitor c=7.37089e-18
    c6585 (\74\:S2 \356\:VDDA) capacitor c=7.37089e-18
    c6586 (\74\:S2 \391\:VDDA) capacitor c=7.37089e-18
    c6587 (\74\:S2 \446\:VDDA) capacitor c=7.37089e-18
    c6588 (\72\:S2 \319\:VDDA) capacitor c=7.37089e-18
    c6589 (\72\:S2 \354\:VDDA) capacitor c=7.37089e-18
    c6590 (\72\:S2 \389\:VDDA) capacitor c=7.37089e-18
    c6591 (\72\:S2 \444\:VDDA) capacitor c=7.37089e-18
    c6592 (\69\:S2 \442\:VDDA) capacitor c=7.37089e-18
    c6593 (\67\:S2 \315\:VDDA) capacitor c=7.37089e-18
    c6594 (\67\:S2 \350\:VDDA) capacitor c=7.37089e-18
    c6595 (\67\:S2 \385\:VDDA) capacitor c=7.37089e-18
    c6596 (\67\:S2 \440\:VDDA) capacitor c=7.37089e-18
    c6597 (\65\:S2 \313\:VDDA) capacitor c=7.37089e-18
    c6598 (\65\:S2 \348\:VDDA) capacitor c=7.37089e-18
    c6599 (\65\:S2 \383\:VDDA) capacitor c=7.37089e-18
    c6600 (\65\:S2 \438\:VDDA) capacitor c=7.37089e-18
    c6601 (\9\:S2 \177\:VDDA) capacitor c=7.37089e-18
    c6602 (\9\:S2 \247\:VDDA) capacitor c=7.37089e-18
    c6603 (\9\:S2 \317\:VDDA) capacitor c=7.37089e-18
    c6604 (\9\:S2 \352\:VDDA) capacitor c=7.37089e-18
    c6605 (\9\:S2 \387\:VDDA) capacitor c=7.37089e-18
    c6606 (\9\:S2 \263\:VDDA) capacitor c=7.88945e-18
    c6607 (\57\:S2 \279\:VDDA) capacitor c=9.13172e-18
    c6608 (\67\:S2 \540\:VDDA) capacitor c=9.51514e-18
    c6609 (\26\:vv \11\:VDDA) capacitor c=7.29329e-18
    c6610 (\24\:vv \9\:VDDA) capacitor c=7.29329e-18
    c6611 (\21\:vv \7\:VDDA) capacitor c=7.29329e-18
    c6612 (\19\:vv \5\:VDDA) capacitor c=7.29329e-18
    c6613 (\27\:vv \65\:VDDA) capacitor c=7.29329e-18
    c6614 (\25\:vv \63\:VDDA) capacitor c=7.29329e-18
    c6615 (\22\:vv \61\:VDDA) capacitor c=7.29329e-18
    c6616 (\20\:vv \59\:VDDA) capacitor c=7.29329e-18
    c6617 (\18\:vv \57\:VDDA) capacitor c=7.29329e-18
    c6618 (\16\:vv \55\:VDDA) capacitor c=7.29329e-18
    c6619 (\239\:S \271\:VDDA) capacitor c=6.6449e-18
    c6620 (\238\:S \306\:VDDA) capacitor c=6.6449e-18
    c6621 (\238\:S \341\:VDDA) capacitor c=6.6449e-18
    c6622 (\238\:S \376\:VDDA) capacitor c=6.6449e-18
    c6623 (\238\:S \411\:VDDA) capacitor c=6.6449e-18
    c6624 (\238\:S \466\:VDDA) capacitor c=6.6449e-18
    c6625 (\238\:S \515\:VDDA) capacitor c=6.6449e-18
    c6626 (\239\:S \100\:VDDA) capacitor c=6.6449e-18
    c6627 (\238\:S \35\:VDDA) capacitor c=6.73607e-18
    c6628 (\239\:S \35\:VDDA) capacitor c=6.73718e-18
    c6629 (\207\:S \118\:VDDA) capacitor c=7.07726e-18
    c6630 (\237\:S \128\:VDDA) capacitor c=7.07726e-18
    c6631 (\226\:S \124\:VDDA) capacitor c=7.07726e-18
    c6632 (\221\:S \122\:VDDA) capacitor c=7.07726e-18
    c6633 (\11\:S \126\:VDDA) capacitor c=7.07726e-18
    c6634 (\9\:S \120\:VDDA) capacitor c=7.07726e-18
    c6635 (\236\:S \482\:VDDA) capacitor c=8.44529e-18
    c6636 (\222\:S \478\:VDDA) capacitor c=8.44529e-18
    c6637 (\217\:S \476\:VDDA) capacitor c=8.44529e-18
    c6638 (\206\:S \472\:VDDA) capacitor c=8.44529e-18
    c6639 (\237\:S \234\:VDDA) capacitor c=9.81205e-18
    c6640 (\207\:S \224\:VDDA) capacitor c=9.81205e-18
    c6641 (\236\:S \409\:VDDA) capacitor c=9.81205e-18
    c6642 (\206\:S \399\:VDDA) capacitor c=9.81205e-18
    c6643 (\17\:S \230\:VDDA) capacitor c=9.81205e-18
    c6644 (\41\:S \405\:VDDA) capacitor c=9.81205e-18
    c6645 (\39\:S \403\:VDDA) capacitor c=9.81205e-18
    c6646 (\47\:S \407\:VDDA) capacitor c=9.81205e-18
    c6647 (\45\:S \401\:VDDA) capacitor c=9.81205e-18
    c6648 (\237\:S \183\:VDDA) capacitor c=9.88982e-18
    c6649 (\207\:S \173\:VDDA) capacitor c=9.88982e-18
    c6650 (\237\:S \148\:VDDA) capacitor c=9.88982e-18
    c6651 (\207\:S \138\:VDDA) capacitor c=9.88982e-18
    c6652 (\17\:S \144\:VDDA) capacitor c=9.88982e-18
    c6653 (\15\:S \142\:VDDA) capacitor c=9.88982e-18
    c6654 (\237\:S \218\:VDDA) capacitor c=9.88982e-18
    c6655 (\207\:S \208\:VDDA) capacitor c=9.88982e-18
    c6656 (\237\:S \253\:VDDA) capacitor c=9.89215e-18
    c6657 (\207\:S \243\:VDDA) capacitor c=9.89215e-18
    c6658 (\236\:S \323\:VDDA) capacitor c=9.89215e-18
    c6659 (\236\:S \358\:VDDA) capacitor c=9.89215e-18
    c6660 (\236\:S \393\:VDDA) capacitor c=9.89215e-18
    c6661 (\236\:S \448\:VDDA) capacitor c=9.89215e-18
    c6662 (\206\:S \313\:VDDA) capacitor c=9.89215e-18
    c6663 (\206\:S \348\:VDDA) capacitor c=9.89215e-18
    c6664 (\206\:S \383\:VDDA) capacitor c=9.89215e-18
    c6665 (\206\:S \438\:VDDA) capacitor c=9.89215e-18
    c6666 (\11\:S \146\:VDDA) capacitor c=9.89215e-18
    c6667 (\9\:S \140\:VDDA) capacitor c=9.89215e-18
    c6668 (\17\:S \179\:VDDA) capacitor c=9.89215e-18
    c6669 (\17\:S \249\:VDDA) capacitor c=9.89215e-18
    c6670 (\15\:S \177\:VDDA) capacitor c=9.89215e-18
    c6671 (\23\:S \282\:VDDA) capacitor c=9.89215e-18
    c6672 (\33\:S \284\:VDDA) capacitor c=9.89215e-18
    c6673 (\41\:S \389\:VDDA) capacitor c=9.89215e-18
    c6674 (\41\:S \444\:VDDA) capacitor c=9.89215e-18
    c6675 (\39\:S \317\:VDDA) capacitor c=9.89215e-18
    c6676 (\39\:S \387\:VDDA) capacitor c=9.89215e-18
    c6677 (\39\:S \442\:VDDA) capacitor c=9.89215e-18
    c6678 (\47\:S \446\:VDDA) capacitor c=9.89215e-18
    c6679 (\45\:S \440\:VDDA) capacitor c=9.89215e-18
    c6680 (\237\:S \164\:VDDA) capacitor c=9.94704e-18
    c6681 (\237\:S \199\:VDDA) capacitor c=9.94704e-18
    c6682 (\237\:S \269\:VDDA) capacitor c=9.94704e-18
    c6683 (\207\:S \154\:VDDA) capacitor c=9.94704e-18
    c6684 (\207\:S \189\:VDDA) capacitor c=9.94704e-18
    c6685 (\207\:S \259\:VDDA) capacitor c=9.94704e-18
    c6686 (\236\:S \339\:VDDA) capacitor c=9.94704e-18
    c6687 (\236\:S \374\:VDDA) capacitor c=9.94704e-18
    c6688 (\236\:S \464\:VDDA) capacitor c=9.94704e-18
    c6689 (\222\:S \460\:VDDA) capacitor c=9.94704e-18
    c6690 (\217\:S \458\:VDDA) capacitor c=9.94704e-18
    c6691 (\206\:S \329\:VDDA) capacitor c=9.94704e-18
    c6692 (\206\:S \364\:VDDA) capacitor c=9.94704e-18
    c6693 (\206\:S \454\:VDDA) capacitor c=9.94704e-18
    c6694 (\17\:S \160\:VDDA) capacitor c=9.94704e-18
    c6695 (\15\:S \158\:VDDA) capacitor c=9.94704e-18
    c6696 (\23\:S \263\:VDDA) capacitor c=9.94704e-18
    c6697 (\33\:S \265\:VDDA) capacitor c=9.94704e-18
    c6698 (\41\:S \370\:VDDA) capacitor c=9.94704e-18
    c6699 (\39\:S \368\:VDDA) capacitor c=9.94704e-18
    c6700 (\47\:S \462\:VDDA) capacitor c=9.94704e-18
    c6701 (\45\:S \456\:VDDA) capacitor c=9.94704e-18
    c6702 (\15\:D1 \2\:X) capacitor c=7.65847e-18
    c6703 (\8\:Y \32\:Vo1) capacitor c=4.28593e-18
    c6704 (\2\:Y \20\:Vo1) capacitor c=6.05227e-18
    c6705 (\10\:X \12\:Y) capacitor c=6.29891e-18
    c6706 (\12\:X \14\:Y) capacitor c=6.29891e-18
    c6707 (\14\:X \16\:Y) capacitor c=6.29891e-18
    c6708 (\44\:U \1265\:GNDA) capacitor c=7.39399e-18
    c6709 (\51\:U \791\:GNDA) capacitor c=7.39399e-18
    c6710 (\53\:U \1133\:GNDA) capacitor c=7.39399e-18
    c6711 (\61\:U \1398\:GNDA) capacitor c=7.39399e-18
    c6712 (\68\:U \753\:GNDA) capacitor c=7.39399e-18
    c6713 (\70\:U \1009\:GNDA) capacitor c=7.39399e-18
    c6714 (\72\:U \1122\:GNDA) capacitor c=7.39399e-18
    c6715 (\84\:U \1297\:GNDA) capacitor c=7.39399e-18
    c6716 (\91\:U \455\:GNDA) capacitor c=7.39399e-18
    c6717 (\93\:U \431\:GNDA) capacitor c=7.39399e-18
    c6718 (\94\:U \401\:GNDA) capacitor c=7.39399e-18
    c6719 (\104\:U \379\:GNDA) capacitor c=7.39399e-18
    c6720 (\95\:U \1218\:GNDA) capacitor c=9.01751e-18
    c6721 (Vo2 GNDA) capacitor c=7.77909e-19
    c6722 (Vo1 GNDA) capacitor c=1.32852e-18
    c6723 (S2 GNDA) capacitor c=1.46358e-17
    c6724 (vv GNDA) capacitor c=1.08065e-17
    c6725 (Y GNDA) capacitor c=2.11009e-19
    c6726 (X GNDA) capacitor c=2.11009e-19
    c6727 (net22 GNDA) capacitor c=3.57905e-20
    c6728 (net39 GNDA) capacitor c=4.05784e-20
    c6729 (net21 GNDA) capacitor c=1.36746e-19
    c6730 (net40 GNDA) capacitor c=7.00371e-20
    c6731 (net35 GNDA) capacitor c=5.7145e-22
    c6732 (net38 GNDA) capacitor c=1.57992e-19
    c6733 (net19 GNDA) capacitor c=6.65729e-20
    c6734 (net33 GNDA) capacitor c=5.7145e-22
    c6735 (net15 GNDA) capacitor c=1.52872e-19
    c6736 (net32 GNDA) capacitor c=1.7466e-21
    c6737 (net27 GNDA) capacitor c=3.79385e-18
    c6738 (net16 GNDA) capacitor c=5.83964e-20
    c6739 (net4 GNDA) capacitor c=7.40704e-18
    c6740 (net2 GNDA) capacitor c=2.01312e-19
    c6741 (net7 GNDA) capacitor c=7.4235e-19
    c6742 (net11 GNDA) capacitor c=1.19609e-19
    c6743 (net26 GNDA) capacitor c=6.19748e-18
    c6744 (net9 GNDA) capacitor c=6.19748e-18
    c6745 (net3 GNDA) capacitor c=6.19748e-18
    c6746 (\6\:BG_REF GNDA) capacitor c=9.60079e-19
    c6747 (\7\:Vo1 GNDA) capacitor c=4.16754e-18
    c6748 (\3\:X GNDA) capacitor c=4.22018e-19
    c6749 (\3\:Y GNDA) capacitor c=4.22018e-19
    c6750 (\5\:Y GNDA) capacitor c=4.22018e-19
    c6751 (\5\:X GNDA) capacitor c=4.22018e-19
    c6752 (\7\:X GNDA) capacitor c=4.22018e-19
    c6753 (\7\:Y GNDA) capacitor c=4.22018e-19
    c6754 (\9\:Y GNDA) capacitor c=4.22018e-19
    c6755 (\9\:X GNDA) capacitor c=4.22018e-19
    c6756 (\11\:X GNDA) capacitor c=4.22018e-19
    c6757 (\11\:Y GNDA) capacitor c=4.22018e-19
    c6758 (\13\:Y GNDA) capacitor c=4.22018e-19
    c6759 (\13\:X GNDA) capacitor c=4.22018e-19
    c6760 (\15\:X GNDA) capacitor c=2.11009e-19
    c6761 (\15\:Y GNDA) capacitor c=2.11009e-19
    c6762 (\3\:S2 GNDA) capacitor c=5.49043e-18
    c6763 (\11\:BG_REF GNDA) capacitor c=9.0885e-18
    c6764 (\3\:vv GNDA) capacitor c=1.25023e-17
    c6765 (\13\:BG_REF GNDA) capacitor c=7.89259e-18
    c6766 (\7\:S2 GNDA) capacitor c=8.14954e-18
    c6767 (\5\:S2 GNDA) capacitor c=1.432e-17
    c6768 (\3\:Vo1 GNDA) capacitor c=1.17786e-18
    c6769 (\2\:Vs GNDA) capacitor c=1.05343e-18
    c6770 (\272\:Vm1 GNDA) capacitor c=6.79572e-18
    c6771 (\134\:BG_REF GNDA) capacitor c=3.90336e-17
    c6772 (\104\:BG_REF GNDA) capacitor c=1.03544e-18
    c6773 (\100\:BG_REF GNDA) capacitor c=8.56368e-18
    c6774 (\89\:BG_REF GNDA) capacitor c=2.65822e-17
    c6775 (\239\:S GNDA) capacitor c=5.46976e-17
    c6776 (\237\:S GNDA) capacitor c=3.19598e-17
    c6777 (\235\:S GNDA) capacitor c=6.08508e-18
    c6778 (\226\:S GNDA) capacitor c=1.78562e-18
    c6779 (\221\:S GNDA) capacitor c=1.78562e-18
    c6780 (\216\:S GNDA) capacitor c=6.08508e-18
    c6781 (\207\:S GNDA) capacitor c=3.5531e-17
    c6782 (\77\:S2 GNDA) capacitor c=5.49299e-17
    c6783 (\103\:S2 GNDA) capacitor c=7.67064e-17
    c6784 (\75\:S2 GNDA) capacitor c=6.15819e-17
    c6785 (\73\:S2 GNDA) capacitor c=4.22153e-17
    c6786 (\71\:S2 GNDA) capacitor c=2.56727e-17
    c6787 (\68\:S2 GNDA) capacitor c=4.51222e-17
    c6788 (\66\:S2 GNDA) capacitor c=3.54608e-17
    c6789 (\34\:vv GNDA) capacitor c=7.82922e-18
    c6790 (\28\:vv GNDA) capacitor c=7.40532e-17
    c6791 (\26\:vv GNDA) capacitor c=3.44419e-17
    c6792 (\24\:vv GNDA) capacitor c=2.1966e-17
    c6793 (\21\:vv GNDA) capacitor c=3.67886e-17
    c6794 (\19\:vv GNDA) capacitor c=3.07879e-17
    c6795 (\17\:vv GNDA) capacitor c=7.40532e-17
    c6796 (\42\:D1 GNDA) capacitor c=1.76909e-19
    c6797 (\46\:D1 GNDA) capacitor c=4.67746e-19
    c6798 (\48\:Vo1 GNDA) capacitor c=7.82469e-18
    c6799 (\51\:Vo1 GNDA) capacitor c=5.41664e-18
    c6800 (\52\:D1 GNDA) capacitor c=3.3425e-19
    c6801 (\914\:VDDA GNDA) capacitor c=5.78682e-18
    c6802 (\655\:VDDA GNDA) capacitor c=5.37766e-18
    c6803 (\653\:VDDA GNDA) capacitor c=9.36828e-18
    c6804 (\651\:VDDA GNDA) capacitor c=5.13676e-18
    c6805 (\647\:VDDA GNDA) capacitor c=6.30789e-18
    c6806 (\645\:VDDA GNDA) capacitor c=6.2376e-18
    c6807 (\643\:VDDA GNDA) capacitor c=6.40375e-18
    c6808 (\641\:VDDA GNDA) capacitor c=6.33163e-18
    c6809 (\639\:VDDA GNDA) capacitor c=6.37955e-18
    c6810 (\637\:VDDA GNDA) capacitor c=1.23645e-17
    c6811 (\249\:Vm1 GNDA) capacitor c=1.54525e-18
    c6812 (\137\:BG_REF GNDA) capacitor c=3.74565e-19
    c6813 (\133\:BG_REF GNDA) capacitor c=3.03006e-17
    c6814 (\121\:BG_REF GNDA) capacitor c=7.37255e-18
    c6815 (\117\:BG_REF GNDA) capacitor c=6.63815e-18
    c6816 (\111\:BG_REF GNDA) capacitor c=7.4684e-18
    c6817 (\105\:BG_REF GNDA) capacitor c=7.2856e-18
    c6818 (\101\:BG_REF GNDA) capacitor c=6.7801e-18
    c6819 (\90\:BG_REF GNDA) capacitor c=6.70844e-18
    c6820 (\88\:BG_REF GNDA) capacitor c=5.06819e-17
    c6821 (\240\:S GNDA) capacitor c=5.13676e-18
    c6822 (\238\:S GNDA) capacitor c=2.85591e-17
    c6823 (\236\:S GNDA) capacitor c=3.55092e-17
    c6824 (\227\:S GNDA) capacitor c=2.69351e-18
    c6825 (\222\:S GNDA) capacitor c=2.67843e-18
    c6826 (\217\:S GNDA) capacitor c=2.67843e-18
    c6827 (\208\:S GNDA) capacitor c=2.69351e-18
    c6828 (\206\:S GNDA) capacitor c=3.47169e-17
    c6829 (\76\:S2 GNDA) capacitor c=2.06794e-17
    c6830 (\102\:S2 GNDA) capacitor c=3.73779e-17
    c6831 (\74\:S2 GNDA) capacitor c=3.73518e-17
    c6832 (\72\:S2 GNDA) capacitor c=4.16291e-17
    c6833 (\69\:S2 GNDA) capacitor c=2.13138e-17
    c6834 (\67\:S2 GNDA) capacitor c=3.79315e-17
    c6835 (\65\:S2 GNDA) capacitor c=1.61245e-17
    c6836 (\33\:vv GNDA) capacitor c=4.10559e-18
    c6837 (\27\:vv GNDA) capacitor c=6.19325e-17
    c6838 (\25\:vv GNDA) capacitor c=3.13563e-17
    c6839 (\22\:vv GNDA) capacitor c=1.33995e-17
    c6840 (\20\:vv GNDA) capacitor c=4.22794e-17
    c6841 (\18\:vv GNDA) capacitor c=3.14155e-17
    c6842 (\16\:vv GNDA) capacitor c=2.87862e-17
    c6843 (\24\:Vs GNDA) capacitor c=6.29843e-18
    c6844 (\18\:Vs GNDA) capacitor c=9.01226e-18
    c6845 (\32\:D2 GNDA) capacitor c=1.54525e-18
    c6846 (\34\:D2 GNDA) capacitor c=1.77318e-17
    c6847 (\31\:D2 GNDA) capacitor c=8.75061e-18
    c6848 (\82\:S2 GNDA) capacitor c=6.6363e-18
    c6849 (\78\:S2 GNDA) capacitor c=6.93213e-18
    c6850 (\80\:S2 GNDA) capacitor c=6.93213e-18
    c6851 (\71\:Vo1 GNDA) capacitor c=1.59065e-18
    c6852 (\58\:Vo1 GNDA) capacitor c=9.58358e-18
    c6853 (\21\:D2 GNDA) capacitor c=5.14428e-18
    c6854 (\105\:S2 GNDA) capacitor c=1.12329e-18
    c6855 (\95\:S2 GNDA) capacitor c=9.85993e-19
    c6856 (\90\:S2 GNDA) capacitor c=5.2376e-18
    c6857 (\86\:S2 GNDA) capacitor c=6.93213e-18
    c6858 (\88\:S2 GNDA) capacitor c=6.93213e-18
    c6859 (\22\:Vs GNDA) capacitor c=7.20044e-19
    c6860 (\23\:D2 GNDA) capacitor c=1.28865e-18
    c6861 (\29\:D2 GNDA) capacitor c=1.05059e-17
    c6862 (\28\:D2 GNDA) capacitor c=5.2376e-18
    c6863 (\34\:X GNDA) capacitor c=2.82231e-17
    c6864 (\35\:X GNDA) capacitor c=5.88333e-18
    c6865 (\573\:VDDA GNDA) capacitor c=7.12137e-18
    c6866 (\587\:VDDA GNDA) capacitor c=1.03544e-18
    c6867 (\590\:VDDA GNDA) capacitor c=8.56368e-18
    c6868 (\569\:VDDA GNDA) capacitor c=1.12244e-17
    c6869 (\76\:VDDA GNDA) capacitor c=5.64591e-19
    c6870 (\74\:VDDA GNDA) capacitor c=4.53209e-19
    c6871 (\72\:VDDA GNDA) capacitor c=5.27464e-19
    c6872 (\86\:VDDA GNDA) capacitor c=8.29742e-18
    c6873 (\128\:VDDA GNDA) capacitor c=4.46589e-18
    c6874 (\126\:VDDA GNDA) capacitor c=4.46589e-18
    c6875 (\124\:VDDA GNDA) capacitor c=4.46589e-18
    c6876 (\122\:VDDA GNDA) capacitor c=4.46589e-18
    c6877 (\120\:VDDA GNDA) capacitor c=4.46589e-18
    c6878 (\118\:VDDA GNDA) capacitor c=4.46589e-18
    c6879 (\130\:VDDA GNDA) capacitor c=1.34406e-17
    c6880 (\133\:VDDA GNDA) capacitor c=7.96346e-18
    c6881 (\33\:BG_REF GNDA) capacitor c=9.36759e-18
    c6882 (\31\:BG_REF GNDA) capacitor c=1.09698e-17
    c6883 (\29\:BG_REF GNDA) capacitor c=9.36759e-18
    c6884 (\27\:BG_REF GNDA) capacitor c=9.36759e-18
    c6885 (\25\:BG_REF GNDA) capacitor c=1.09698e-17
    c6886 (\23\:BG_REF GNDA) capacitor c=9.36759e-18
    c6887 (\136\:VDDA GNDA) capacitor c=6.36875e-18
    c6888 (\166\:VDDA GNDA) capacitor c=6.6449e-18
    c6889 (\41\:BG_REF GNDA) capacitor c=8.99305e-18
    c6890 (\11\:S GNDA) capacitor c=2.02572e-17
    c6891 (\39\:BG_REF GNDA) capacitor c=1.01947e-17
    c6892 (\37\:BG_REF GNDA) capacitor c=1.669e-17
    c6893 (\9\:S GNDA) capacitor c=2.02572e-17
    c6894 (\35\:BG_REF GNDA) capacitor c=8.99305e-18
    c6895 (\171\:VDDA GNDA) capacitor c=6.36875e-18
    c6896 (\181\:VDDA GNDA) capacitor c=2.32671e-18
    c6897 (\175\:VDDA GNDA) capacitor c=2.32671e-18
    c6898 (\201\:VDDA GNDA) capacitor c=6.6449e-18
    c6899 (\45\:BG_REF GNDA) capacitor c=8.99223e-18
    c6900 (\19\:S GNDA) capacitor c=6.86266e-18
    c6901 (\17\:S GNDA) capacitor c=2.29346e-17
    c6902 (\15\:S GNDA) capacitor c=1.63862e-17
    c6903 (\13\:S GNDA) capacitor c=9.47669e-18
    c6904 (\43\:BG_REF GNDA) capacitor c=8.99223e-18
    c6905 (\206\:VDDA GNDA) capacitor c=6.36875e-18
    c6906 (\216\:VDDA GNDA) capacitor c=2.28229e-18
    c6907 (\214\:VDDA GNDA) capacitor c=1.46997e-18
    c6908 (\212\:VDDA GNDA) capacitor c=2.28229e-18
    c6909 (\210\:VDDA GNDA) capacitor c=2.28229e-18
    c6910 (\236\:VDDA GNDA) capacitor c=6.6449e-18
    c6911 (\49\:BG_REF GNDA) capacitor c=8.99141e-18
    c6912 (\25\:S GNDA) capacitor c=7.74906e-18
    c6913 (\23\:S GNDA) capacitor c=1.34047e-17
    c6914 (\21\:S GNDA) capacitor c=1.03631e-17
    c6915 (\47\:BG_REF GNDA) capacitor c=8.99141e-18
    c6916 (\241\:VDDA GNDA) capacitor c=6.36875e-18
    c6917 (\251\:VDDA GNDA) capacitor c=1.864e-18
    c6918 (\247\:VDDA GNDA) capacitor c=1.864e-18
    c6919 (\245\:VDDA GNDA) capacitor c=1.864e-18
    c6920 (\267\:VDDA GNDA) capacitor c=5.02157e-18
    c6921 (\265\:VDDA GNDA) capacitor c=5.9835e-18
    c6922 (\263\:VDDA GNDA) capacitor c=5.9835e-18
    c6923 (\261\:VDDA GNDA) capacitor c=5.02157e-18
    c6924 (\53\:BG_REF GNDA) capacitor c=8.98733e-18
    c6925 (\29\:S GNDA) capacitor c=9.57225e-18
    c6926 (\7\:vv GNDA) capacitor c=2.59922e-17
    c6927 (\9\:S2 GNDA) capacitor c=5.60099e-17
    c6928 (\27\:S GNDA) capacitor c=3.52711e-18
    c6929 (\51\:BG_REF GNDA) capacitor c=8.98733e-18
    c6930 (\276\:VDDA GNDA) capacitor c=6.36875e-18
    c6931 (\292\:VDDA GNDA) capacitor c=1.2312e-17
    c6932 (\17\:Vo1 GNDA) capacitor c=2.21161e-17
    c6933 (\288\:VDDA GNDA) capacitor c=9.88982e-18
    c6934 (\286\:VDDA GNDA) capacitor c=1.95044e-18
    c6935 (\284\:VDDA GNDA) capacitor c=6.06802e-18
    c6936 (\280\:VDDA GNDA) capacitor c=1.95044e-18
    c6937 (\278\:VDDA GNDA) capacitor c=9.88982e-18
    c6938 (\304\:VDDA GNDA) capacitor c=6.58871e-18
    c6939 (\302\:VDDA GNDA) capacitor c=6.58871e-18
    c6940 (\300\:VDDA GNDA) capacitor c=6.58871e-18
    c6941 (\296\:VDDA GNDA) capacitor c=6.58871e-18
    c6942 (\294\:VDDA GNDA) capacitor c=6.58871e-18
    c6943 (\57\:BG_REF GNDA) capacitor c=8.98436e-18
    c6944 (\35\:S GNDA) capacitor c=2.01255e-17
    c6945 (\33\:S GNDA) capacitor c=1.26375e-17
    c6946 (\31\:S GNDA) capacitor c=2.272e-17
    c6947 (\55\:BG_REF GNDA) capacitor c=8.98436e-18
    c6948 (\311\:VDDA GNDA) capacitor c=6.36875e-18
    c6949 (\321\:VDDA GNDA) capacitor c=2.0397e-18
    c6950 (\319\:VDDA GNDA) capacitor c=2.0397e-18
    c6951 (\315\:VDDA GNDA) capacitor c=2.0397e-18
    c6952 (\19\:Vo1 GNDA) capacitor c=8.19962e-19
    c6953 (\61\:BG_REF GNDA) capacitor c=8.98569e-18
    c6954 (\43\:S GNDA) capacitor c=6.47484e-18
    c6955 (\41\:S GNDA) capacitor c=1.95717e-17
    c6956 (\39\:S GNDA) capacitor c=2.43345e-17
    c6957 (\37\:S GNDA) capacitor c=9.08887e-18
    c6958 (\59\:BG_REF GNDA) capacitor c=8.98569e-18
    c6959 (\346\:VDDA GNDA) capacitor c=6.36875e-18
    c6960 (\356\:VDDA GNDA) capacitor c=1.78027e-18
    c6961 (\354\:VDDA GNDA) capacitor c=1.78027e-18
    c6962 (\352\:VDDA GNDA) capacitor c=1.78027e-18
    c6963 (\350\:VDDA GNDA) capacitor c=1.78027e-18
    c6964 (\69\:BG_REF GNDA) capacitor c=8.98814e-18
    c6965 (\47\:S GNDA) capacitor c=2.45232e-17
    c6966 (\67\:BG_REF GNDA) capacitor c=7.18513e-18
    c6967 (\65\:BG_REF GNDA) capacitor c=1.57516e-17
    c6968 (\45\:S GNDA) capacitor c=2.45232e-17
    c6969 (\63\:BG_REF GNDA) capacitor c=4.21637e-19
    c6970 (\381\:VDDA GNDA) capacitor c=6.36875e-18
    c6971 (\391\:VDDA GNDA) capacitor c=1.864e-18
    c6972 (\385\:VDDA GNDA) capacitor c=1.864e-18
    c6973 (\403\:VDDA GNDA) capacitor c=6.41527e-18
    c6974 (\65\:S GNDA) capacitor c=1.15452e-18
    c6975 (\58\:S GNDA) capacitor c=1.15452e-18
    c6976 (\81\:BG_REF GNDA) capacitor c=9.78841e-18
    c6977 (\79\:BG_REF GNDA) capacitor c=1.59913e-17
    c6978 (\77\:BG_REF GNDA) capacitor c=9.78841e-18
    c6979 (\75\:BG_REF GNDA) capacitor c=9.78841e-18
    c6980 (\73\:BG_REF GNDA) capacitor c=1.59913e-17
    c6981 (\71\:BG_REF GNDA) capacitor c=1.22191e-18
    c6982 (\416\:VDDA GNDA) capacitor c=6.36875e-18
    c6983 (\25\:Vo1 GNDA) capacitor c=3.86797e-18
    c6984 (\20\:D1 GNDA) capacitor c=3.93915e-18
    c6985 (\468\:VDDA GNDA) capacitor c=9.43476e-18
    c6986 (\480\:VDDA GNDA) capacitor c=8.44241e-18
    c6987 (\474\:VDDA GNDA) capacitor c=8.44241e-18
    c6988 (\471\:VDDA GNDA) capacitor c=6.36875e-18
    c6989 (\23\:D1 GNDA) capacitor c=5.41516e-18
    c6990 (\501\:VDDA GNDA) capacitor c=8.29742e-18
    c6991 (\31\:Vo1 GNDA) capacitor c=3.86797e-18
    c6992 (\26\:D1 GNDA) capacitor c=3.93169e-18
    c6993 (\559\:VDDA GNDA) capacitor c=3.32456e-18
    c6994 (\523\:VDDA GNDA) capacitor c=5.64591e-19
    c6995 (\521\:VDDA GNDA) capacitor c=4.53209e-19
    c6996 (\519\:VDDA GNDA) capacitor c=5.27464e-19
    c6997 (\29\:D1 GNDA) capacitor c=5.41516e-18
    c6998 (\37\:Vo1 GNDA) capacitor c=3.86797e-18
    c6999 (\32\:D1 GNDA) capacitor c=3.9328e-18
    c7000 (\35\:D1 GNDA) capacitor c=5.41516e-18
    c7001 (\40\:Vo1 GNDA) capacitor c=1.23397e-18
    c7002 (\43\:Vo1 GNDA) capacitor c=3.86797e-18
    c7003 (\38\:D1 GNDA) capacitor c=3.88715e-18
    c7004 (\554\:VDDA GNDA) capacitor c=2.53403e-18
    c7005 (\550\:VDDA GNDA) capacitor c=2.28116e-19
    c7006 (\548\:VDDA GNDA) capacitor c=7.02501e-18
    c7007 (\544\:VDDA GNDA) capacitor c=4.07657e-18
    c7008 (\542\:VDDA GNDA) capacitor c=4.72611e-18
    c7009 (\55\:S2 GNDA) capacitor c=2.06886e-18
    c7010 (\57\:S2 GNDA) capacitor c=5.18246e-18
    c7011 (\87\:BG_REF GNDA) capacitor c=6.97399e-18
    c7012 (\10\:D2 GNDA) capacitor c=1.71855e-19
    c7013 (\143\:S GNDA) capacitor c=1.15452e-18
    c7014 (\136\:S GNDA) capacitor c=1.15452e-18
    c7015 (\12\:vv GNDA) capacitor c=3.21094e-17
    c7016 (\52\:S2 GNDA) capacitor c=2.72359e-18
    c7017 (\60\:S2 GNDA) capacitor c=1.60371e-17
    c7018 (\14\:S2 GNDA) capacitor c=8.59173e-18
    c7019 (\21\:S2 GNDA) capacitor c=1.09792e-18
    c7020 (\17\:S2 GNDA) capacitor c=1.09792e-18
    c7021 (\8\:D2 GNDA) capacitor c=1.05134e-17
    c7022 (\4\:Vs GNDA) capacitor c=1.08187e-17
    c7023 (\151\:S GNDA) capacitor c=3.34873e-19
    c7024 (\8\:Vs GNDA) capacitor c=8.37194e-18
    c7025 (\12\:D2 GNDA) capacitor c=1.82186e-17
    c7026 (\15\:D2 GNDA) capacitor c=4.17537e-20
    c7027 (\37\:S2 GNDA) capacitor c=7.13689e-18
    c7028 (\33\:S2 GNDA) capacitor c=7.35584e-18
    c7029 (\50\:S2 GNDA) capacitor c=8.4612e-19
    c7030 (\62\:S2 GNDA) capacitor c=7.45391e-18
    c7031 (\40\:S2 GNDA) capacitor c=8.46125e-18
    c7032 (\42\:S2 GNDA) capacitor c=3.91354e-19
    c7033 (\4\:Vo2 GNDA) capacitor c=1.0369e-18
    c7034 (\2\:Vo2 GNDA) capacitor c=4.73773e-20
    c7035 (\9\:vv GNDA) capacitor c=3.21549e-17
    c7036 (\15\:vv GNDA) capacitor c=7.55674e-18
    c7037 (\62\:U GNDA) capacitor c=3.76025e-18
    c7038 (\95\:U GNDA) capacitor c=6.41748e-18
    c7039 (\54\:U GNDA) capacitor c=6.11358e-18
    c7040 (\92\:U GNDA) capacitor c=6.41748e-18
    c7041 (\52\:U GNDA) capacitor c=1.20018e-17
    c7042 (\16\:U GNDA) capacitor c=2.78071e-18
    c7043 (\90\:U GNDA) capacitor c=1.96632e-17
    c7044 (\67\:U GNDA) capacitor c=3.7346e-18
    c7045 (\7\:BG_REF GNDA) capacitor c=4.16754e-18
    c7046 (\9\:BG_REF GNDA) capacitor c=5.35314e-18
    c7047 (\13\:VDDA GNDA) capacitor c=7.29329e-18
    c7048 (\11\:VDDA GNDA) capacitor c=1.03845e-17
    c7049 (\5\:VDDA GNDA) capacitor c=1.03845e-17
    c7050 (\3\:VDDA GNDA) capacitor c=7.29329e-18
    c7051 (\21\:VDDA GNDA) capacitor c=3.44045e-18
    c7052 (\25\:VDDA GNDA) capacitor c=2.22618e-18
    c7053 (\29\:VDDA GNDA) capacitor c=4.65473e-18
    c7054 (\33\:VDDA GNDA) capacitor c=2.63093e-18
    c7055 (\37\:VDDA GNDA) capacitor c=3.03569e-18
    c7056 (\41\:VDDA GNDA) capacitor c=4.24997e-18
    c7057 (\45\:VDDA GNDA) capacitor c=1.82142e-18
    c7058 (\2\:X GNDA) capacitor c=1.01669e-17
    c7059 (\2\:Y GNDA) capacitor c=5.3532e-18
    c7060 (\4\:X GNDA) capacitor c=1.1871e-17
    c7061 (\4\:Y GNDA) capacitor c=1.05848e-17
    c7062 (\6\:X GNDA) capacitor c=1.78254e-17
    c7063 (\6\:Y GNDA) capacitor c=1.20879e-17
    c7064 (\8\:X GNDA) capacitor c=1.18867e-17
    c7065 (\8\:Y GNDA) capacitor c=6.29891e-18
    c7066 (\10\:X GNDA) capacitor c=1.15264e-17
    c7067 (\10\:Y GNDA) capacitor c=1.22352e-17
    c7068 (\12\:X GNDA) capacitor c=5.74465e-18
    c7069 (\12\:Y GNDA) capacitor c=3.83718e-18
    c7070 (\14\:X GNDA) capacitor c=1.11062e-17
    c7071 (\14\:Y GNDA) capacitor c=5.77427e-18
    c7072 (\16\:X GNDA) capacitor c=1.56901e-19
    c7073 (\4\:S2 GNDA) capacitor c=9.1259e-18
    c7074 (\2\:S2 GNDA) capacitor c=9.16944e-18
    c7075 (\12\:BG_REF GNDA) capacitor c=1.5753e-17
    c7076 (\2\:vv GNDA) capacitor c=8.54452e-18
    c7077 (\14\:BG_REF GNDA) capacitor c=2.98158e-17
    c7078 (\4\:vv GNDA) capacitor c=1.51241e-17
    c7079 (\8\:S2 GNDA) capacitor c=3.83125e-18
    c7080 (\6\:S2 GNDA) capacitor c=3.62415e-18
    c7081 (\2\:net22 GNDA) capacitor c=3.50185e-20
    c7082 (\2\:net3 GNDA) capacitor c=6.76938e-20
    c7083 (\2\:net35 GNDA) capacitor c=6.51656e-20
    c7084 (\2\:net15 GNDA) capacitor c=6.0464e-20
    c7085 (\2\:net4 GNDA) capacitor c=1.19003e-19
    c7086 (\2\:net7 GNDA) capacitor c=1.26103e-17
    c7087 (\99\:VDDA GNDA) capacitor c=2.47204e-18
    c7088 (\97\:VDDA GNDA) capacitor c=6.18629e-18
    c7089 (\95\:VDDA GNDA) capacitor c=6.18629e-18
    c7090 (\93\:VDDA GNDA) capacitor c=6.18629e-18
    c7091 (\91\:VDDA GNDA) capacitor c=1.29335e-18
    c7092 (\89\:VDDA GNDA) capacitor c=1.29335e-18
    c7093 (\87\:VDDA GNDA) capacitor c=1.29335e-18
    c7094 (\85\:VDDA GNDA) capacitor c=5.78574e-18
    c7095 (\129\:VDDA GNDA) capacitor c=7.01072e-19
    c7096 (\127\:VDDA GNDA) capacitor c=6.18629e-18
    c7097 (\125\:VDDA GNDA) capacitor c=6.18629e-18
    c7098 (\123\:VDDA GNDA) capacitor c=6.18629e-18
    c7099 (\121\:VDDA GNDA) capacitor c=1.29335e-18
    c7100 (\119\:VDDA GNDA) capacitor c=1.29335e-18
    c7101 (\117\:VDDA GNDA) capacitor c=1.29335e-18
    c7102 (\134\:VDDA GNDA) capacitor c=5.78574e-18
    c7103 (\135\:VDDA GNDA) capacitor c=1.27814e-18
    c7104 (\34\:BG_REF GNDA) capacitor c=5.78574e-18
    c7105 (\32\:BG_REF GNDA) capacitor c=6.20616e-18
    c7106 (\30\:BG_REF GNDA) capacitor c=6.20616e-18
    c7107 (\28\:BG_REF GNDA) capacitor c=6.20616e-18
    c7108 (\26\:BG_REF GNDA) capacitor c=6.20616e-18
    c7109 (\24\:BG_REF GNDA) capacitor c=6.20616e-18
    c7110 (\131\:VDDA GNDA) capacitor c=8.9281e-19
    c7111 (\165\:VDDA GNDA) capacitor c=7.01072e-19
    c7112 (\163\:VDDA GNDA) capacitor c=6.18629e-18
    c7113 (\161\:VDDA GNDA) capacitor c=6.18629e-18
    c7114 (\159\:VDDA GNDA) capacitor c=6.18629e-18
    c7115 (\157\:VDDA GNDA) capacitor c=1.29335e-18
    c7116 (\155\:VDDA GNDA) capacitor c=1.29335e-18
    c7117 (\153\:VDDA GNDA) capacitor c=1.29335e-18
    c7118 (\169\:VDDA GNDA) capacitor c=5.78574e-18
    c7119 (\170\:VDDA GNDA) capacitor c=1.27814e-18
    c7120 (\42\:BG_REF GNDA) capacitor c=5.78574e-18
    c7121 (\12\:S GNDA) capacitor c=6.71136e-18
    c7122 (\40\:BG_REF GNDA) capacitor c=7.92737e-18
    c7123 (\38\:BG_REF GNDA) capacitor c=6.20616e-18
    c7124 (\10\:S GNDA) capacitor c=6.71136e-18
    c7125 (\36\:BG_REF GNDA) capacitor c=7.92737e-18
    c7126 (\167\:VDDA GNDA) capacitor c=8.9281e-19
    c7127 (\200\:VDDA GNDA) capacitor c=7.01072e-19
    c7128 (\198\:VDDA GNDA) capacitor c=6.18629e-18
    c7129 (\196\:VDDA GNDA) capacitor c=6.18629e-18
    c7130 (\194\:VDDA GNDA) capacitor c=6.18629e-18
    c7131 (\192\:VDDA GNDA) capacitor c=1.29335e-18
    c7132 (\190\:VDDA GNDA) capacitor c=1.29335e-18
    c7133 (\188\:VDDA GNDA) capacitor c=1.29335e-18
    c7134 (\204\:VDDA GNDA) capacitor c=8.9281e-19
    c7135 (\205\:VDDA GNDA) capacitor c=1.27814e-18
    c7136 (\46\:BG_REF GNDA) capacitor c=5.78574e-18
    c7137 (\20\:S GNDA) capacitor c=6.78331e-18
    c7138 (\18\:S GNDA) capacitor c=6.78331e-18
    c7139 (\16\:S GNDA) capacitor c=6.78331e-18
    c7140 (\14\:S GNDA) capacitor c=6.78331e-18
    c7141 (\44\:BG_REF GNDA) capacitor c=7.92737e-18
    c7142 (\202\:VDDA GNDA) capacitor c=8.9281e-19
    c7143 (\235\:VDDA GNDA) capacitor c=7.01072e-19
    c7144 (\233\:VDDA GNDA) capacitor c=6.18629e-18
    c7145 (\231\:VDDA GNDA) capacitor c=6.18629e-18
    c7146 (\229\:VDDA GNDA) capacitor c=1.29335e-18
    c7147 (\227\:VDDA GNDA) capacitor c=1.29335e-18
    c7148 (\225\:VDDA GNDA) capacitor c=1.29335e-18
    c7149 (\223\:VDDA GNDA) capacitor c=1.29335e-18
    c7150 (\239\:VDDA GNDA) capacitor c=8.9281e-19
    c7151 (\240\:VDDA GNDA) capacitor c=1.27814e-18
    c7152 (\50\:BG_REF GNDA) capacitor c=5.78574e-18
    c7153 (\26\:S GNDA) capacitor c=7.17735e-18
    c7154 (\24\:S GNDA) capacitor c=6.75693e-18
    c7155 (\22\:S GNDA) capacitor c=7.17735e-18
    c7156 (\48\:BG_REF GNDA) capacitor c=7.92737e-18
    c7157 (\237\:VDDA GNDA) capacitor c=8.9281e-19
    c7158 (\270\:VDDA GNDA) capacitor c=7.01072e-19
    c7159 (\268\:VDDA GNDA) capacitor c=6.18629e-18
    c7160 (\266\:VDDA GNDA) capacitor c=6.18629e-18
    c7161 (\264\:VDDA GNDA) capacitor c=1.29335e-18
    c7162 (\262\:VDDA GNDA) capacitor c=1.29335e-18
    c7163 (\260\:VDDA GNDA) capacitor c=1.29335e-18
    c7164 (\258\:VDDA GNDA) capacitor c=1.29335e-18
    c7165 (\274\:VDDA GNDA) capacitor c=8.9281e-19
    c7166 (\275\:VDDA GNDA) capacitor c=1.27814e-18
    c7167 (\54\:BG_REF GNDA) capacitor c=5.78574e-18
    c7168 (\30\:S GNDA) capacitor c=7.26378e-18
    c7169 (\8\:vv GNDA) capacitor c=1.5298e-17
    c7170 (\10\:S2 GNDA) capacitor c=1.30263e-18
    c7171 (\28\:S GNDA) capacitor c=1.12768e-17
    c7172 (\52\:BG_REF GNDA) capacitor c=7.92737e-18
    c7173 (\272\:VDDA GNDA) capacitor c=8.9281e-19
    c7174 (\305\:VDDA GNDA) capacitor c=7.01072e-19
    c7175 (\303\:VDDA GNDA) capacitor c=1.29335e-18
    c7176 (\301\:VDDA GNDA) capacitor c=1.29335e-18
    c7177 (\299\:VDDA GNDA) capacitor c=1.29335e-18
    c7178 (\297\:VDDA GNDA) capacitor c=1.29335e-18
    c7179 (\295\:VDDA GNDA) capacitor c=1.29335e-18
    c7180 (\293\:VDDA GNDA) capacitor c=1.29335e-18
    c7181 (\309\:VDDA GNDA) capacitor c=8.9281e-19
    c7182 (\310\:VDDA GNDA) capacitor c=1.27814e-18
    c7183 (\58\:BG_REF GNDA) capacitor c=5.78574e-18
    c7184 (\36\:S GNDA) capacitor c=7.35305e-18
    c7185 (\34\:S GNDA) capacitor c=7.35305e-18
    c7186 (\32\:S GNDA) capacitor c=6.93264e-18
    c7187 (\56\:BG_REF GNDA) capacitor c=7.92737e-18
    c7188 (\307\:VDDA GNDA) capacitor c=8.9281e-19
    c7189 (\340\:VDDA GNDA) capacitor c=7.01072e-19
    c7190 (\338\:VDDA GNDA) capacitor c=1.29335e-18
    c7191 (\336\:VDDA GNDA) capacitor c=1.29335e-18
    c7192 (\334\:VDDA GNDA) capacitor c=1.29335e-18
    c7193 (\332\:VDDA GNDA) capacitor c=1.29335e-18
    c7194 (\330\:VDDA GNDA) capacitor c=1.29335e-18
    c7195 (\328\:VDDA GNDA) capacitor c=1.29335e-18
    c7196 (\344\:VDDA GNDA) capacitor c=8.9281e-19
    c7197 (\345\:VDDA GNDA) capacitor c=1.27814e-18
    c7198 (\62\:BG_REF GNDA) capacitor c=5.78574e-18
    c7199 (\44\:S GNDA) capacitor c=7.09362e-18
    c7200 (\42\:S GNDA) capacitor c=7.09362e-18
    c7201 (\40\:S GNDA) capacitor c=7.09362e-18
    c7202 (\38\:S GNDA) capacitor c=7.09362e-18
    c7203 (\60\:BG_REF GNDA) capacitor c=7.92737e-18
    c7204 (\342\:VDDA GNDA) capacitor c=8.9281e-19
    c7205 (\375\:VDDA GNDA) capacitor c=7.01072e-19
    c7206 (\373\:VDDA GNDA) capacitor c=1.29335e-18
    c7207 (\371\:VDDA GNDA) capacitor c=1.29335e-18
    c7208 (\369\:VDDA GNDA) capacitor c=1.29335e-18
    c7209 (\367\:VDDA GNDA) capacitor c=1.29335e-18
    c7210 (\365\:VDDA GNDA) capacitor c=1.29335e-18
    c7211 (\363\:VDDA GNDA) capacitor c=1.29335e-18
    c7212 (\379\:VDDA GNDA) capacitor c=8.9281e-19
    c7213 (\380\:VDDA GNDA) capacitor c=1.27814e-18
    c7214 (\70\:BG_REF GNDA) capacitor c=5.78574e-18
    c7215 (\48\:S GNDA) capacitor c=7.17735e-18
    c7216 (\68\:BG_REF GNDA) capacitor c=7.92737e-18
    c7217 (\66\:BG_REF GNDA) capacitor c=6.20616e-18
    c7218 (\46\:S GNDA) capacitor c=7.17735e-18
    c7219 (\64\:BG_REF GNDA) capacitor c=7.92737e-18
    c7220 (\377\:VDDA GNDA) capacitor c=8.9281e-19
    c7221 (\410\:VDDA GNDA) capacitor c=7.01072e-19
    c7222 (\408\:VDDA GNDA) capacitor c=1.29335e-18
    c7223 (\406\:VDDA GNDA) capacitor c=1.29335e-18
    c7224 (\404\:VDDA GNDA) capacitor c=1.29335e-18
    c7225 (\402\:VDDA GNDA) capacitor c=6.1819e-18
    c7226 (\400\:VDDA GNDA) capacitor c=1.29335e-18
    c7227 (\398\:VDDA GNDA) capacitor c=1.29335e-18
    c7228 (\414\:VDDA GNDA) capacitor c=8.9281e-19
    c7229 (\415\:VDDA GNDA) capacitor c=1.27814e-18
    c7230 (\82\:BG_REF GNDA) capacitor c=5.78574e-18
    c7231 (\80\:BG_REF GNDA) capacitor c=6.20616e-18
    c7232 (\78\:BG_REF GNDA) capacitor c=6.20616e-18
    c7233 (\76\:BG_REF GNDA) capacitor c=6.20616e-18
    c7234 (\74\:BG_REF GNDA) capacitor c=6.20616e-18
    c7235 (\72\:BG_REF GNDA) capacitor c=6.20616e-18
    c7236 (\412\:VDDA GNDA) capacitor c=8.9281e-19
    c7237 (\23\:Vo1 GNDA) capacitor c=1.47267e-19
    c7238 (\18\:D1 GNDA) capacitor c=1.56901e-19
    c7239 (\465\:VDDA GNDA) capacitor c=7.01072e-19
    c7240 (\463\:VDDA GNDA) capacitor c=1.29335e-18
    c7241 (\461\:VDDA GNDA) capacitor c=1.29335e-18
    c7242 (\459\:VDDA GNDA) capacitor c=1.29335e-18
    c7243 (\457\:VDDA GNDA) capacitor c=1.29335e-18
    c7244 (\455\:VDDA GNDA) capacitor c=1.29335e-18
    c7245 (\453\:VDDA GNDA) capacitor c=1.29335e-18
    c7246 (\469\:VDDA GNDA) capacitor c=8.9281e-19
    c7247 (\470\:VDDA GNDA) capacitor c=1.27814e-18
    c7248 (\483\:VDDA GNDA) capacitor c=1.29335e-18
    c7249 (\481\:VDDA GNDA) capacitor c=1.29335e-18
    c7250 (\479\:VDDA GNDA) capacitor c=1.29335e-18
    c7251 (\477\:VDDA GNDA) capacitor c=1.29335e-18
    c7252 (\475\:VDDA GNDA) capacitor c=1.29335e-18
    c7253 (\473\:VDDA GNDA) capacitor c=1.29335e-18
    c7254 (\467\:VDDA GNDA) capacitor c=8.9281e-19
    c7255 (\21\:D1 GNDA) capacitor c=7.65847e-18
    c7256 (\26\:Vo1 GNDA) capacitor c=6.04496e-18
    c7257 (\29\:Vo1 GNDA) capacitor c=1.61994e-19
    c7258 (\24\:D1 GNDA) capacitor c=1.72591e-19
    c7259 (\514\:VDDA GNDA) capacitor c=7.01072e-19
    c7260 (\512\:VDDA GNDA) capacitor c=1.29335e-18
    c7261 (\510\:VDDA GNDA) capacitor c=1.29335e-18
    c7262 (\508\:VDDA GNDA) capacitor c=1.29335e-18
    c7263 (\506\:VDDA GNDA) capacitor c=1.29335e-18
    c7264 (\504\:VDDA GNDA) capacitor c=1.29335e-18
    c7265 (\502\:VDDA GNDA) capacitor c=1.29335e-18
    c7266 (\500\:VDDA GNDA) capacitor c=8.9281e-19
    c7267 (\27\:D1 GNDA) capacitor c=7.65847e-18
    c7268 (\32\:Vo1 GNDA) capacitor c=1.75903e-18
    c7269 (\35\:Vo1 GNDA) capacitor c=3.09261e-19
    c7270 (\30\:D1 GNDA) capacitor c=3.29491e-19
    c7271 (\33\:D1 GNDA) capacitor c=7.23828e-18
    c7272 (\38\:Vo1 GNDA) capacitor c=5.59621e-18
    c7273 (\41\:Vo1 GNDA) capacitor c=1.47267e-19
    c7274 (\36\:D1 GNDA) capacitor c=1.56901e-19
    c7275 (\22\:S2 GNDA) capacitor c=3.89268e-18
    c7276 (\18\:S2 GNDA) capacitor c=4.00192e-18
    c7277 (\19\:S2 GNDA) capacitor c=4.70925e-18
    c7278 (\15\:S2 GNDA) capacitor c=4.70925e-18
    c7279 (\25\:S2 GNDA) capacitor c=2.90663e-18
    c7280 (\23\:S2 GNDA) capacitor c=2.90663e-18
    c7281 (\7\:D2 GNDA) capacitor c=1.00315e-17
    c7282 (\3\:Vs GNDA) capacitor c=5.93241e-18
    c7283 (\29\:S2 GNDA) capacitor c=1.94671e-17
    c7284 (\27\:S2 GNDA) capacitor c=1.12423e-17
    c7285 (\7\:Vs GNDA) capacitor c=5.0334e-18
    c7286 (\11\:D2 GNDA) capacitor c=1.51102e-17
    c7287 (\38\:S2 GNDA) capacitor c=3.68017e-18
    c7288 (\34\:S2 GNDA) capacitor c=3.97024e-18
    c7289 (\35\:S2 GNDA) capacitor c=4.35323e-18
    c7290 (\31\:S2 GNDA) capacitor c=4.1872e-18
    c7291 (\109\:U GNDA) capacitor c=6.78e-18
    c7292 (\89\:U GNDA) capacitor c=6.78e-18
    c7293 (\12\:U GNDA) capacitor c=6.78e-18
    c7294 (\66\:U GNDA) capacitor c=6.78e-18
    c7295 (\49\:U GNDA) capacitor c=1.15993e-17
    c7296 (\107\:U GNDA) capacitor c=3.02275e-18
    c7297 (\87\:U GNDA) capacitor c=3.02275e-18
    c7298 (\10\:U GNDA) capacitor c=3.02275e-18
    c7299 (\64\:U GNDA) capacitor c=3.02275e-18
    c7300 (\47\:U GNDA) capacitor c=6.32075e-18
    c7301 (\103\:U GNDA) capacitor c=6.78e-18
    c7302 (\83\:U GNDA) capacitor c=6.78e-18
    c7303 (\6\:U GNDA) capacitor c=6.81748e-18
    c7304 (\43\:U GNDA) capacitor c=1.15971e-17
    c7305 (\81\:U GNDA) capacitor c=1.40493e-17
    c7306 (\31\:X GNDA) capacitor c=4.09609e-18
    c7307 (\60\:U GNDA) capacitor c=6.78e-18
    c7308 (\41\:U GNDA) capacitor c=1.15971e-17
    c7309 (\101\:U GNDA) capacitor c=6.78e-18
    c7310 (\79\:U GNDA) capacitor c=6.78e-18
    c7311 (\26\:U GNDA) capacitor c=6.81748e-18
    c7312 (\39\:U GNDA) capacitor c=1.15971e-17
    c7313 (\99\:U GNDA) capacitor c=3.02275e-18
    c7314 (\77\:U GNDA) capacitor c=3.02275e-18
    c7315 (\24\:U GNDA) capacitor c=3.02275e-18
    c7316 (\58\:U GNDA) capacitor c=3.02275e-18
    c7317 (\37\:U GNDA) capacitor c=6.32085e-18
    c7318 (\97\:U GNDA) capacitor c=6.78e-18
    c7319 (\75\:U GNDA) capacitor c=6.78e-18
    c7320 (\22\:U GNDA) capacitor c=6.78e-18
    c7321 (\56\:U GNDA) capacitor c=6.78e-18
    c7322 (\35\:U GNDA) capacitor c=1.15833e-17
    c7323 (\16\:Vo1 GNDA) capacitor c=2.71527e-18
    c7324 (\18\:Vo1 GNDA) capacitor c=9.73235e-18
    c7325 (\3\:Vo2 GNDA) capacitor c=1.06041e-18
    c7326 (\13\:vv GNDA) capacitor c=9.1922e-18
    c7327 (\534\:VDDA GNDA) capacitor c=3.43668e-17
    c7328 (\81\:VDDA GNDA) capacitor c=2.16954e-18
    c7329 (\79\:VDDA GNDA) capacitor c=2.20711e-18
    c7330 (\77\:VDDA GNDA) capacitor c=2.15044e-18
    c7331 (\75\:VDDA GNDA) capacitor c=2.27972e-18
    c7332 (\73\:VDDA GNDA) capacitor c=2.22558e-18
    c7333 (\71\:VDDA GNDA) capacitor c=2.26188e-18
    c7334 (\69\:VDDA GNDA) capacitor c=2.20711e-18
    c7335 (\147\:VDDA GNDA) capacitor c=1.05682e-17
    c7336 (\145\:VDDA GNDA) capacitor c=1.05682e-17
    c7337 (\143\:VDDA GNDA) capacitor c=1.05682e-17
    c7338 (\141\:VDDA GNDA) capacitor c=1.05682e-17
    c7339 (\139\:VDDA GNDA) capacitor c=1.05682e-17
    c7340 (\137\:VDDA GNDA) capacitor c=1.05682e-17
    c7341 (\182\:VDDA GNDA) capacitor c=1.05674e-17
    c7342 (\180\:VDDA GNDA) capacitor c=1.16472e-17
    c7343 (\178\:VDDA GNDA) capacitor c=1.05674e-17
    c7344 (\176\:VDDA GNDA) capacitor c=1.05674e-17
    c7345 (\174\:VDDA GNDA) capacitor c=1.16472e-17
    c7346 (\172\:VDDA GNDA) capacitor c=1.05674e-17
    c7347 (\217\:VDDA GNDA) capacitor c=9.85178e-18
    c7348 (\215\:VDDA GNDA) capacitor c=1.09639e-17
    c7349 (\213\:VDDA GNDA) capacitor c=1.09395e-17
    c7350 (\211\:VDDA GNDA) capacitor c=1.09639e-17
    c7351 (\209\:VDDA GNDA) capacitor c=1.09639e-17
    c7352 (\207\:VDDA GNDA) capacitor c=9.85178e-18
    c7353 (\252\:VDDA GNDA) capacitor c=1.12773e-17
    c7354 (\250\:VDDA GNDA) capacitor c=1.2534e-17
    c7355 (\248\:VDDA GNDA) capacitor c=1.12773e-17
    c7356 (\246\:VDDA GNDA) capacitor c=1.2534e-17
    c7357 (\244\:VDDA GNDA) capacitor c=1.2534e-17
    c7358 (\242\:VDDA GNDA) capacitor c=1.12773e-17
    c7359 (\287\:VDDA GNDA) capacitor c=1.12741e-17
    c7360 (\285\:VDDA GNDA) capacitor c=1.25588e-17
    c7361 (\283\:VDDA GNDA) capacitor c=1.25588e-17
    c7362 (\281\:VDDA GNDA) capacitor c=1.25393e-17
    c7363 (\279\:VDDA GNDA) capacitor c=4.49062e-18
    c7364 (\277\:VDDA GNDA) capacitor c=1.12741e-17
    c7365 (\322\:VDDA GNDA) capacitor c=1.12756e-17
    c7366 (\320\:VDDA GNDA) capacitor c=1.25824e-17
    c7367 (\318\:VDDA GNDA) capacitor c=1.25824e-17
    c7368 (\316\:VDDA GNDA) capacitor c=1.12756e-17
    c7369 (\314\:VDDA GNDA) capacitor c=1.25824e-17
    c7370 (\312\:VDDA GNDA) capacitor c=1.12756e-17
    c7371 (\357\:VDDA GNDA) capacitor c=1.05633e-17
    c7372 (\355\:VDDA GNDA) capacitor c=1.17934e-17
    c7373 (\353\:VDDA GNDA) capacitor c=1.17723e-17
    c7374 (\351\:VDDA GNDA) capacitor c=1.17723e-17
    c7375 (\349\:VDDA GNDA) capacitor c=1.17934e-17
    c7376 (\347\:VDDA GNDA) capacitor c=1.05633e-17
    c7377 (\149\:S GNDA) capacitor c=8.3091e-18
    c7378 (\392\:VDDA GNDA) capacitor c=1.12773e-17
    c7379 (\390\:VDDA GNDA) capacitor c=1.25138e-17
    c7380 (\388\:VDDA GNDA) capacitor c=1.12773e-17
    c7381 (\386\:VDDA GNDA) capacitor c=1.12773e-17
    c7382 (\384\:VDDA GNDA) capacitor c=1.25138e-17
    c7383 (\382\:VDDA GNDA) capacitor c=1.12773e-17
    c7384 (\447\:VDDA GNDA) capacitor c=1.1257e-17
    c7385 (\445\:VDDA GNDA) capacitor c=1.1257e-17
    c7386 (\443\:VDDA GNDA) capacitor c=1.1257e-17
    c7387 (\441\:VDDA GNDA) capacitor c=1.1257e-17
    c7388 (\439\:VDDA GNDA) capacitor c=1.1257e-17
    c7389 (\437\:VDDA GNDA) capacitor c=1.1257e-17
    c7390 (\528\:VDDA GNDA) capacitor c=2.16954e-18
    c7391 (\526\:VDDA GNDA) capacitor c=2.20711e-18
    c7392 (\524\:VDDA GNDA) capacitor c=2.15044e-18
    c7393 (\522\:VDDA GNDA) capacitor c=2.27972e-18
    c7394 (\520\:VDDA GNDA) capacitor c=2.22558e-18
    c7395 (\518\:VDDA GNDA) capacitor c=2.26188e-18
    c7396 (\516\:VDDA GNDA) capacitor c=2.20711e-18
    c7397 (\110\:S GNDA) capacitor c=1.23397e-18
    c7398 (\44\:S2 GNDA) capacitor c=1.48229e-17
    c7399 (\11\:S2 GNDA) capacitor c=3.86148e-18
    c7400 (\13\:S2 GNDA) capacitor c=4.41269e-18
    c7401 (\39\:S2 GNDA) capacitor c=7.11594e-18
    c7402 (\41\:S2 GNDA) capacitor c=7.2044e-18
    c7403 (\64\:S2 GNDA) capacitor c=3.24969e-18
    c7404 (\2\:U GNDA) capacitor c=5.54623e-18
    c7405 (\3\:U GNDA) capacitor c=8.42414e-18
    c7406 (\7\:U GNDA) capacitor c=7.39399e-18
    c7407 (\29\:X GNDA) capacitor c=5.59482e-18
    c7408 (\27\:X GNDA) capacitor c=7.442e-18
    c7409 (\20\:U GNDA) capacitor c=7.3781e-18
    c7410 (\17\:U GNDA) capacitor c=7.39399e-18
    c7411 (\19\:U GNDA) capacitor c=8.76466e-18
    c7412 (\28\:U GNDA) capacitor c=7.39399e-18
    c7413 (\30\:U GNDA) capacitor c=1.14901e-17
    c7414 (\31\:U GNDA) capacitor c=7.39399e-18
    c7415 (\32\:U GNDA) capacitor c=1.14901e-17
    c7416 (\53\:U GNDA) capacitor c=2.20599e-17
    c7417 (\71\:U GNDA) capacitor c=9.76647e-18
    c7418 (\91\:U GNDA) capacitor c=4.09609e-18
    c7419 (\93\:U GNDA) capacitor c=1.14827e-17
    c7420 (\94\:U GNDA) capacitor c=6.86151e-18
    c7421 (\104\:U GNDA) capacitor c=4.09609e-18
    c7422 (\116\:U GNDA) capacitor c=9.75289e-18
    c7423 (\117\:U GNDA) capacitor c=2.61841e-18
    c7424 (\41\:X GNDA) capacitor c=5.7382e-18
    c7425 (\37\:X GNDA) capacitor c=5.17585e-18
    R9 (\2\:net10 net7 \218\:GNDA) PRIMLIB_rpolyhc_schematic w=2e-06 \
        l=5.255e-05 mult=1 mmw=0 cap=2.08292e-14
    R28 (\2\:net28 net1 \218\:GNDA) PRIMLIB_rpolyhc_schematic w=2e-06 \
        l=5.255e-05 mult=1 mmw=0 cap=2.08292e-14
    R10 (\2\:net13 net8 \218\:GNDA) PRIMLIB_rpolyhc_schematic w=2e-06 \
        l=5.255e-05 mult=1 mmw=0 cap=2.08292e-14
    R29 (\2\:net29 net25 \218\:GNDA) PRIMLIB_rpolyhc_schematic w=2e-06 \
        l=5.255e-05 mult=1 mmw=0 cap=2.08292e-14
    R48 (\1\:GNDA \3\:GNDA \218\:GNDA) PRIMLIB_rpolyhc_schematic w=2e-06 \
        l=5.255e-05 mult=1 mmw=0 cap=2.08292e-14
    R30 (\2\:net30 net3 \218\:GNDA) PRIMLIB_rpolyhc_schematic w=2e-06 \
        l=5.255e-05 mult=1 mmw=0 cap=2.08292e-14
    R11 (\2\:net12 net9 \218\:GNDA) PRIMLIB_rpolyhc_schematic w=2e-06 \
        l=5.255e-05 mult=1 mmw=0 cap=2.08292e-14
    R31 (\2\:net31 net26 \218\:GNDA) PRIMLIB_rpolyhc_schematic w=2e-06 \
        l=5.255e-05 mult=1 mmw=0 cap=2.08292e-14
    R15 (\2\:net11 net13 \218\:GNDA) PRIMLIB_rpolyhc_schematic w=2e-06 \
        l=5.255e-05 mult=1 mmw=0 cap=2.08292e-14
    R36 (\16\:BG_REF net31 \218\:GNDA) PRIMLIB_rpolyhc_schematic w=2e-06 \
        l=5.255e-05 mult=1 mmw=0 cap=2.08292e-14
    R17 (\2\:net19 \2\:net15 \218\:GNDA) PRIMLIB_rpolyhc_schematic w=2e-06 \
        l=5.255e-05 mult=1 mmw=0 cap=2.08292e-14
    R18 (\2\:net20 \2\:net16 \218\:GNDA) PRIMLIB_rpolyhc_schematic w=2e-06 \
        l=5.255e-05 mult=1 mmw=0 cap=2.08292e-14
    R22 (\2\:net24 net20 \218\:GNDA) PRIMLIB_rpolyhc_schematic w=2e-06 \
        l=5.255e-05 mult=1 mmw=0 cap=2.08292e-14
    R50 (\2\:GNDA \4\:GNDA \218\:GNDA) PRIMLIB_rpolyhc_schematic w=2e-06 \
        l=5.255e-05 mult=1 mmw=0 cap=2.08292e-14
    R26 (net22 net24 \218\:GNDA) PRIMLIB_rpolyhc_schematic w=2e-06 \
        l=5.255e-05 mult=1 mmw=0 cap=2.08292e-14
    rb1 (\297\:Vm1 \286\:Vm1) analogLib_presistor_schematic c=0 r=0.83472
    rb2 (\286\:Vm1 \236\:Vm1) analogLib_presistor_schematic c=0 r=0.43872
    rb3 (\236\:Vm1 \248\:Vm1) analogLib_presistor_schematic c=0 r=0.43872
    rb4 (\248\:Vm1 \259\:Vm1) analogLib_presistor_schematic c=0 r=0.43872
    rb5 (\259\:Vm1 \270\:Vm1) analogLib_presistor_schematic c=0 r=0.43872
    rb6 (\270\:Vm1 \272\:Vm1) analogLib_presistor_schematic c=0 r=0.791568
    rb7 (\89\:BG_REF \100\:BG_REF) analogLib_presistor_schematic c=0 \
        r=0.651033
    rb8 (\100\:BG_REF \104\:BG_REF) analogLib_presistor_schematic c=0 \
        r=0.43872
    rb9 (\104\:BG_REF \110\:BG_REF) analogLib_presistor_schematic c=0 \
        r=0.43872
    rb10 (\110\:BG_REF \116\:BG_REF) analogLib_presistor_schematic c=0 \
        r=0.43872
    rb11 (\116\:BG_REF \120\:BG_REF) analogLib_presistor_schematic c=0 \
        r=0.43872
    rb12 (\120\:BG_REF \131\:BG_REF) analogLib_presistor_schematic c=0 \
        r=0.43872
    rb13 (\131\:BG_REF \134\:BG_REF) analogLib_presistor_schematic c=0 \
        r=0.43872
    rb14 (\134\:BG_REF \138\:BG_REF) analogLib_presistor_schematic c=0 \
        r=0.69898
    rb15 (\205\:S \207\:S) analogLib_presistor_schematic c=0 r=0.69898
    rb16 (\207\:S \216\:S) analogLib_presistor_schematic c=0 r=0.43872
    rb17 (\216\:S \221\:S) analogLib_presistor_schematic c=0 r=0.43872
    rb18 (\221\:S \226\:S) analogLib_presistor_schematic c=0 r=0.43872
    rb19 (\226\:S \235\:S) analogLib_presistor_schematic c=0 r=0.43872
    rb20 (\235\:S \237\:S) analogLib_presistor_schematic c=0 r=0.43872
    rb21 (\237\:S \239\:S) analogLib_presistor_schematic c=0 r=0.43872
    rb22 (\239\:S \242\:S) analogLib_presistor_schematic c=0 r=0.651033
    rb23 (\66\:S2 \68\:S2) analogLib_presistor_schematic c=0 r=0.83472
    rb24 (\68\:S2 \71\:S2) analogLib_presistor_schematic c=0 r=0.43872
    rb25 (\71\:S2 \73\:S2) analogLib_presistor_schematic c=0 r=0.43872
    rb26 (\73\:S2 \75\:S2) analogLib_presistor_schematic c=0 r=0.43872
    rb27 (\75\:S2 \103\:S2) analogLib_presistor_schematic c=0 r=0.43872
    rb28 (\103\:S2 \77\:S2) analogLib_presistor_schematic c=0 r=0.83472
    rb29 (\17\:vv \19\:vv) analogLib_presistor_schematic c=0 r=0.83472
    rb30 (\19\:vv \21\:vv) analogLib_presistor_schematic c=0 r=0.43872
    rb31 (\21\:vv \24\:vv) analogLib_presistor_schematic c=0 r=0.43872
    rb32 (\24\:vv \26\:vv) analogLib_presistor_schematic c=0 r=0.43872
    rb33 (\26\:vv \28\:vv) analogLib_presistor_schematic c=0 r=0.43872
    rb34 (\28\:vv \34\:vv) analogLib_presistor_schematic c=0 r=0.83472
    rb35 (\617\:VDDA \926\:VDDA) analogLib_presistor_schematic c=0 \
        r=0.284689
    rb36 (\926\:VDDA \619\:VDDA) analogLib_presistor_schematic c=0 \
        r=0.157628
    rb37 (\619\:VDDA \928\:VDDA) analogLib_presistor_schematic c=0 \
        r=0.281093
    rb38 (\928\:VDDA \621\:VDDA) analogLib_presistor_schematic c=0 \
        r=0.15523
    rb39 (\621\:VDDA \930\:VDDA) analogLib_presistor_schematic c=0 \
        r=0.28349
    rb40 (\930\:VDDA \623\:VDDA) analogLib_presistor_schematic c=0 \
        r=0.158826
    rb41 (\623\:VDDA \932\:VDDA) analogLib_presistor_schematic c=0 \
        r=0.279894
    rb42 (\932\:VDDA \625\:VDDA) analogLib_presistor_schematic c=0 \
        r=0.150436
    rb43 (\625\:VDDA \934\:VDDA) analogLib_presistor_schematic c=0 \
        r=0.288285
    rb44 (\934\:VDDA \627\:VDDA) analogLib_presistor_schematic c=0 \
        r=0.154032
    rb45 (\627\:VDDA \936\:VDDA) analogLib_presistor_schematic c=0 \
        r=0.284689
    rb46 (\936\:VDDA \629\:VDDA) analogLib_presistor_schematic c=0 \
        r=0.151634
    rb47 (\629\:VDDA \938\:VDDA) analogLib_presistor_schematic c=0 \
        r=0.330239
    rb48 (\938\:VDDA \631\:VDDA) analogLib_presistor_schematic c=0 \
        r=0.112077
    rb49 (\631\:VDDA \940\:VDDA) analogLib_presistor_schematic c=0 \
        r=0.11927
    rb50 (\940\:VDDA \941\:VDDA) analogLib_presistor_schematic c=0 \
        r=0.067127
    rb51 (\941\:VDDA \635\:VDDA) analogLib_presistor_schematic c=0 \
        r=0.658513
    rb52 (\617\:VDDA \943\:VDDA) analogLib_presistor_schematic c=0 \
        r=0.11927
    rb53 (\943\:VDDA \944\:VDDA) analogLib_presistor_schematic c=0 \
        r=0.067127
    rb54 (\944\:VDDA \633\:VDDA) analogLib_presistor_schematic c=0 \
        r=0.262513
    rb55 (\633\:VDDA \923\:VDDA) analogLib_presistor_schematic c=0 \
        r=0.210124
    rb56 (\46\:D1 \42\:D1) analogLib_presistor_schematic c=0 r=0.559932
    rb57 (\42\:D1 \61\:D1) analogLib_presistor_schematic c=0 r=0.651033
    rb58 (\51\:Vo1 \48\:Vo1) analogLib_presistor_schematic c=0 r=1.21097
    rb59 (\1505\:GNDA \1565\:GNDA) analogLib_presistor_schematic c=0 \
        r=0.65252
    rb60 (\1565\:GNDA \1566\:GNDA) analogLib_presistor_schematic c=0 \
        r=0.673664
    rb61 (\1566\:GNDA \1507\:GNDA) analogLib_presistor_schematic c=0 \
        r=0.25652
    rb62 (\1507\:GNDA \1509\:GNDA) analogLib_presistor_schematic c=0 \
        r=0.201691
    rb63 (\661\:VDDA \918\:VDDA) analogLib_presistor_schematic c=0 \
        r=0.480167
    rb64 (\1511\:GNDA \1570\:GNDA) analogLib_presistor_schematic c=0 \
        r=0.65252
    rb65 (\1570\:GNDA \1571\:GNDA) analogLib_presistor_schematic c=0 \
        r=0.673664
    rb66 (\1571\:GNDA \1513\:GNDA) analogLib_presistor_schematic c=0 \
        r=0.25652
    rb67 (\1513\:GNDA \1515\:GNDA) analogLib_presistor_schematic c=0 \
        r=0.195167
    rb68 (\44\:D1 \39\:D1) analogLib_presistor_schematic c=0 r=0.559932
    rb69 (\39\:D1 \59\:D1) analogLib_presistor_schematic c=0 r=0.651033
    rb70 (\57\:Vo1 \46\:Vo1) analogLib_presistor_schematic c=0 r=0.363946
    rb71 (\57\:Vo1 \55\:Vo1) analogLib_presistor_schematic c=0 r=0.349418
    rb72 (\55\:Vo1 \49\:Vo1) analogLib_presistor_schematic c=0 r=0.4976
    rb73 (\52\:D1 \43\:D1) analogLib_presistor_schematic c=0 r=0.986738
    rb74 (\43\:D1 \58\:D1) analogLib_presistor_schematic c=0 r=1.12579
    rb75 (\63\:Vo1 \54\:Vo1) analogLib_presistor_schematic c=0 r=1.19591
    rb76 (\54\:Vo1 \56\:Vo1) analogLib_presistor_schematic c=0 r=0.351216
    rb77 (\56\:Vo1 \69\:Vo1) analogLib_presistor_schematic c=0 r=0.565398
    rb78 (\196\:S \200\:S) analogLib_presistor_schematic c=0 r=0.391372
    rb79 (\200\:S \194\:S) analogLib_presistor_schematic c=0 r=0.419541
    rb80 (\194\:S \293\:S) analogLib_presistor_schematic c=0 r=0.33803
    rb81 (\293\:S \198\:S) analogLib_presistor_schematic c=0 r=0.194188
    rb82 (\198\:S \241\:S) analogLib_presistor_schematic c=0 r=0.409497
    rb83 (\196\:S \296\:S) analogLib_presistor_schematic c=0 r=0.3662
    rb84 (\296\:S \202\:S) analogLib_presistor_schematic c=0 r=0.590188
    rb85 (\637\:VDDA \950\:VDDA) analogLib_presistor_schematic c=0 \
        r=0.284689
    rb86 (\950\:VDDA \639\:VDDA) analogLib_presistor_schematic c=0 \
        r=0.157628
    rb87 (\639\:VDDA \952\:VDDA) analogLib_presistor_schematic c=0 \
        r=0.281093
    rb88 (\952\:VDDA \641\:VDDA) analogLib_presistor_schematic c=0 \
        r=0.15523
    rb89 (\641\:VDDA \954\:VDDA) analogLib_presistor_schematic c=0 \
        r=0.28349
    rb90 (\954\:VDDA \643\:VDDA) analogLib_presistor_schematic c=0 \
        r=0.158826
    rb91 (\643\:VDDA \956\:VDDA) analogLib_presistor_schematic c=0 \
        r=0.279894
    rb92 (\956\:VDDA \645\:VDDA) analogLib_presistor_schematic c=0 \
        r=0.150436
    rb93 (\645\:VDDA \958\:VDDA) analogLib_presistor_schematic c=0 \
        r=0.288285
    rb94 (\958\:VDDA \647\:VDDA) analogLib_presistor_schematic c=0 \
        r=0.154032
    rb95 (\647\:VDDA \960\:VDDA) analogLib_presistor_schematic c=0 \
        r=0.284689
    rb96 (\960\:VDDA \649\:VDDA) analogLib_presistor_schematic c=0 \
        r=0.151634
    rb97 (\649\:VDDA \962\:VDDA) analogLib_presistor_schematic c=0 \
        r=0.330239
    rb98 (\962\:VDDA \651\:VDDA) analogLib_presistor_schematic c=0 \
        r=0.112077
    rb99 (\651\:VDDA \964\:VDDA) analogLib_presistor_schematic c=0 \
        r=0.11927
    rb100 (\964\:VDDA \965\:VDDA) analogLib_presistor_schematic c=0 \
        r=0.067127
    rb101 (\965\:VDDA \655\:VDDA) analogLib_presistor_schematic c=0 \
        r=0.658513
    rb102 (\637\:VDDA \967\:VDDA) analogLib_presistor_schematic c=0 \
        r=0.11927
    rb103 (\967\:VDDA \968\:VDDA) analogLib_presistor_schematic c=0 \
        r=0.067127
    rb104 (\968\:VDDA \653\:VDDA) analogLib_presistor_schematic c=0 \
        r=0.262513
    rb105 (\653\:VDDA \914\:VDDA) analogLib_presistor_schematic c=0 \
        r=0.225887
    rb106 (\287\:Vm1 \306\:Vm1) analogLib_presistor_schematic c=0 \
        r=0.83472
    rb107 (\306\:Vm1 \225\:Vm1) analogLib_presistor_schematic c=0 \
        r=0.43872
    rb108 (\225\:Vm1 \237\:Vm1) analogLib_presistor_schematic c=0 \
        r=0.43872
    rb109 (\237\:Vm1 \249\:Vm1) analogLib_presistor_schematic c=0 \
        r=0.43872
    rb110 (\249\:Vm1 \260\:Vm1) analogLib_presistor_schematic c=0 \
        r=0.43872
    rb111 (\260\:Vm1 \271\:Vm1) analogLib_presistor_schematic c=0 \
        r=0.791568
    rb112 (\88\:BG_REF \90\:BG_REF) analogLib_presistor_schematic c=0 \
        r=0.651033
    rb113 (\90\:BG_REF \101\:BG_REF) analogLib_presistor_schematic c=0 \
        r=0.43872
    rb114 (\101\:BG_REF \105\:BG_REF) analogLib_presistor_schematic c=0 \
        r=0.43872
    rb115 (\105\:BG_REF \111\:BG_REF) analogLib_presistor_schematic c=0 \
        r=0.43872
    rb116 (\111\:BG_REF \117\:BG_REF) analogLib_presistor_schematic c=0 \
        r=0.43872
    rb117 (\117\:BG_REF \121\:BG_REF) analogLib_presistor_schematic c=0 \
        r=0.43872
    rb118 (\121\:BG_REF \158\:BG_REF) analogLib_presistor_schematic c=0 \
        r=0.43872
    rb119 (\158\:BG_REF \137\:BG_REF) analogLib_presistor_schematic c=0 \
        r=0.69898
    rb120 (\65\:S2 \67\:S2) analogLib_presistor_schematic c=0 r=0.83472
    rb121 (\67\:S2 \69\:S2) analogLib_presistor_schematic c=0 r=0.43872
    rb122 (\69\:S2 \72\:S2) analogLib_presistor_schematic c=0 r=0.43872
    rb123 (\72\:S2 \74\:S2) analogLib_presistor_schematic c=0 r=0.43872
    rb124 (\74\:S2 \125\:S2) analogLib_presistor_schematic c=0 r=0.43872
    rb125 (\125\:S2 \76\:S2) analogLib_presistor_schematic c=0 r=0.43872
    rb126 (\76\:S2 \112\:S2) analogLib_presistor_schematic c=0 r=0.455047
    rb127 (\16\:vv \18\:vv) analogLib_presistor_schematic c=0 r=0.83472
    rb128 (\18\:vv \20\:vv) analogLib_presistor_schematic c=0 r=0.43872
    rb129 (\20\:vv \22\:vv) analogLib_presistor_schematic c=0 r=0.43872
    rb130 (\22\:vv \25\:vv) analogLib_presistor_schematic c=0 r=0.43872
    rb131 (\25\:vv \27\:vv) analogLib_presistor_schematic c=0 r=0.43872
    rb132 (\27\:vv \33\:vv) analogLib_presistor_schematic c=0 r=0.83472
    rb133 (\18\:Vs \24\:Vs) analogLib_presistor_schematic c=0 r=1.35136
    rb134 (\31\:D2 \25\:D2) analogLib_presistor_schematic c=0 r=1.35136
    rb135 (\245\:S \249\:S) analogLib_presistor_schematic c=0 r=0.391372
    rb136 (\249\:S \243\:S) analogLib_presistor_schematic c=0 r=0.419541
    rb137 (\243\:S \301\:S) analogLib_presistor_schematic c=0 r=0.33803
    rb138 (\301\:S \247\:S) analogLib_presistor_schematic c=0 r=0.194188
    rb139 (\247\:S \240\:S) analogLib_presistor_schematic c=0 r=0.808574
    rb140 (\245\:S \304\:S) analogLib_presistor_schematic c=0 r=0.3662
    rb141 (\304\:S \251\:S) analogLib_presistor_schematic c=0 r=0.590188
    rb142 (\240\:S \238\:S) analogLib_presistor_schematic c=0 r=0.519033
    rb143 (\238\:S \236\:S) analogLib_presistor_schematic c=0 r=0.43872
    rb144 (\236\:S \227\:S) analogLib_presistor_schematic c=0 r=0.43872
    rb145 (\227\:S \222\:S) analogLib_presistor_schematic c=0 r=0.43872
    rb146 (\222\:S \217\:S) analogLib_presistor_schematic c=0 r=0.43872
    rb147 (\217\:S \208\:S) analogLib_presistor_schematic c=0 r=0.43872
    rb148 (\208\:S \206\:S) analogLib_presistor_schematic c=0 r=0.43872
    rb149 (\206\:S \204\:S) analogLib_presistor_schematic c=0 r=0.69898
    rb150 (\80\:S2 \129\:S2) analogLib_presistor_schematic c=0 r=0.181601
    rb151 (\129\:S2 \84\:S2) analogLib_presistor_schematic c=0 r=0.590188
    rb152 (\80\:S2 \78\:S2) analogLib_presistor_schematic c=0 r=0.394369
    rb153 (\78\:S2 \132\:S2) analogLib_presistor_schematic c=0 r=0.178005
    rb154 (\132\:S2 \82\:S2) analogLib_presistor_schematic c=0 r=0.590188
    rb155 (\47\:D1 \53\:D1) analogLib_presistor_schematic c=0 r=2.11252
    rb156 (\58\:Vo1 \71\:Vo1) analogLib_presistor_schematic c=0 r=0.742205
    rb157 (\71\:Vo1 \64\:Vo1) analogLib_presistor_schematic c=0 r=1.37032
    rb158 (\88\:S2 \86\:S2) analogLib_presistor_schematic c=0 r=0.379385
    rb159 (\86\:S2 \136\:S2) analogLib_presistor_schematic c=0 r=0.189992
    rb160 (\136\:S2 \92\:S2) analogLib_presistor_schematic c=0 r=0.590188
    rb161 (\88\:S2 \138\:S2) analogLib_presistor_schematic c=0 r=0.184598
    rb162 (\138\:S2 \90\:S2) analogLib_presistor_schematic c=0 r=0.590188
    rb163 (\29\:D2 \23\:D2) analogLib_presistor_schematic c=0 r=1.35136
    rb164 (\27\:Vs \31\:Vs) analogLib_presistor_schematic c=0 r=0.440812
    rb165 (\31\:Vs \19\:Vs) analogLib_presistor_schematic c=0 r=0.801018
    rb166 (\31\:Vs \15\:Vs) analogLib_presistor_schematic c=0 r=0.222021
    rb167 (\15\:Vs \22\:Vs) analogLib_presistor_schematic c=0 r=0.963663
    rb168 (\22\:Vs \13\:Vs) analogLib_presistor_schematic c=0 r=0.512335
    rb169 (\13\:Vs \36\:Vs) analogLib_presistor_schematic c=0 r=0.211755
    rb170 (\26\:D2 \19\:D2) analogLib_presistor_schematic c=0 r=0.59117
    rb171 (\19\:D2 \34\:D2) analogLib_presistor_schematic c=0 r=0.658297
    rb172 (\25\:Vs \21\:Vs) analogLib_presistor_schematic c=0 r=1.24947
    rb173 (\28\:D2 \21\:D2) analogLib_presistor_schematic c=0 r=0.59117
    rb174 (\21\:D2 \32\:D2) analogLib_presistor_schematic c=0 r=0.658297
    rb175 (\1555\:GNDA \1575\:GNDA) analogLib_presistor_schematic c=0 \
        r=0.196585
    rb176 (\1575\:GNDA \1576\:GNDA) analogLib_presistor_schematic c=0 \
        r=0.652087
    rb177 (\1576\:GNDA \1535\:GNDA) analogLib_presistor_schematic c=0 \
        r=0.592585
    rb178 (\1555\:GNDA \1559\:GNDA) analogLib_presistor_schematic c=0 \
        r=0.171194
    rb179 (\1557\:GNDA \1580\:GNDA) analogLib_presistor_schematic c=0 \
        r=0.196585
    rb180 (\1580\:GNDA \1581\:GNDA) analogLib_presistor_schematic c=0 \
        r=0.652087
    rb181 (\1581\:GNDA \1537\:GNDA) analogLib_presistor_schematic c=0 \
        r=0.592585
    rb182 (\1557\:GNDA \1561\:GNDA) analogLib_presistor_schematic c=0 \
        r=0.171194
    rb183 (\37\:X \35\:X) analogLib_presistor_schematic c=0 r=0.673464
    rb184 (\35\:X \34\:X) analogLib_presistor_schematic c=0 r=3.44206
    rb185 (\34\:X \33\:X) analogLib_presistor_schematic c=0 r=0.518107
    rb186 (\35\:X \41\:X) analogLib_presistor_schematic c=0 r=0.673514
    rb227 (\720\:VDDA \926\:VDDA) analogLib_presistor_schematic c=0 \
        r=0.396
    rb229 (\748\:VDDA \928\:VDDA) analogLib_presistor_schematic c=0 \
        r=0.396
    rb231 (\776\:VDDA \930\:VDDA) analogLib_presistor_schematic c=0 \
        r=0.396
    rb233 (\804\:VDDA \932\:VDDA) analogLib_presistor_schematic c=0 \
        r=0.396
    rb235 (\832\:VDDA \934\:VDDA) analogLib_presistor_schematic c=0 \
        r=0.396
    rb237 (\860\:VDDA \936\:VDDA) analogLib_presistor_schematic c=0 \
        r=0.396
    rb239 (\897\:VDDA \938\:VDDA) analogLib_presistor_schematic c=0 \
        r=0.396
    rb241 (\901\:VDDA \940\:VDDA) analogLib_presistor_schematic c=0 \
        r=0.396
    rb242 (\910\:VDDA \941\:VDDA) analogLib_presistor_schematic c=0 \
        r=0.132
    rb244 (\692\:VDDA \943\:VDDA) analogLib_presistor_schematic c=0 \
        r=0.396
    rb245 (\665\:VDDA \944\:VDDA) analogLib_presistor_schematic c=0 \
        r=0.132
    rb254 (\1523\:GNDA \1565\:GNDA) analogLib_presistor_schematic c=0 \
        r=0.132
    rb255 (\1532\:GNDA \1566\:GNDA) analogLib_presistor_schematic c=0 \
        r=0.132
    rb261 (\1518\:GNDA \1570\:GNDA) analogLib_presistor_schematic c=0 \
        r=0.132
    rb262 (\1527\:GNDA \1571\:GNDA) analogLib_presistor_schematic c=0 \
        r=0.132
    rb282 (\265\:S \293\:S) analogLib_presistor_schematic c=0 r=0.198
    rb285 (\279\:S \296\:S) analogLib_presistor_schematic c=0 r=0.198
    rb288 (\695\:VDDA \950\:VDDA) analogLib_presistor_schematic c=0 \
        r=0.396
    rb290 (\723\:VDDA \952\:VDDA) analogLib_presistor_schematic c=0 \
        r=0.396
    rb292 (\751\:VDDA \954\:VDDA) analogLib_presistor_schematic c=0 \
        r=0.396
    rb294 (\779\:VDDA \956\:VDDA) analogLib_presistor_schematic c=0 \
        r=0.396
    rb296 (\807\:VDDA \958\:VDDA) analogLib_presistor_schematic c=0 \
        r=0.396
    rb298 (\835\:VDDA \960\:VDDA) analogLib_presistor_schematic c=0 \
        r=0.396
    rb300 (\863\:VDDA \962\:VDDA) analogLib_presistor_schematic c=0 \
        r=0.396
    rb302 (\900\:VDDA \964\:VDDA) analogLib_presistor_schematic c=0 \
        r=0.396
    rb303 (\904\:VDDA \965\:VDDA) analogLib_presistor_schematic c=0 \
        r=0.132
    rb305 (\668\:VDDA \967\:VDDA) analogLib_presistor_schematic c=0 \
        r=0.396
    rb306 (\658\:VDDA \968\:VDDA) analogLib_presistor_schematic c=0 \
        r=0.132
    rb310 (\276\:Vm1 \306\:Vm1) analogLib_presistor_schematic c=0 r=0.396
    rb323 (\133\:BG_REF \158\:BG_REF) analogLib_presistor_schematic c=0 \
        r=0.396
    rb330 (\102\:S2 \125\:S2) analogLib_presistor_schematic c=0 r=0.396
    rb347 (\254\:S \301\:S) analogLib_presistor_schematic c=0 r=0.198
    rb350 (\268\:S \304\:S) analogLib_presistor_schematic c=0 r=0.198
    rb361 (\110\:S2 \129\:S2) analogLib_presistor_schematic c=0 r=0.198
    rb364 (\100\:S2 \132\:S2) analogLib_presistor_schematic c=0 r=0.198
    rb373 (\105\:S2 \136\:S2) analogLib_presistor_schematic c=0 r=0.198
    rb375 (\95\:S2 \138\:S2) analogLib_presistor_schematic c=0 r=0.198
    rb393 (\1553\:GNDA \1575\:GNDA) analogLib_presistor_schematic c=0 \
        r=0.198
    rb394 (\1545\:GNDA \1576\:GNDA) analogLib_presistor_schematic c=0 \
        r=0.198
    rb398 (\1551\:GNDA \1580\:GNDA) analogLib_presistor_schematic c=0 \
        r=0.198
    rb399 (\1543\:GNDA \1581\:GNDA) analogLib_presistor_schematic c=0 \
        r=0.198
    rd1 (\617\:VDDA \70\:VDDA) analogLib_presistor_schematic c=0 r=0.594
    rd2 (\619\:VDDA \72\:VDDA) analogLib_presistor_schematic c=0 r=0.594
    rd3 (\621\:VDDA \74\:VDDA) analogLib_presistor_schematic c=0 r=0.594
    rd4 (\623\:VDDA \76\:VDDA) analogLib_presistor_schematic c=0 r=0.594
    rd5 (\625\:VDDA \78\:VDDA) analogLib_presistor_schematic c=0 r=0.594
    rd6 (\627\:VDDA \80\:VDDA) analogLib_presistor_schematic c=0 r=0.594
    rd7 (\629\:VDDA \82\:VDDA) analogLib_presistor_schematic c=0 r=0.594
    rd8 (\631\:VDDA \84\:VDDA) analogLib_presistor_schematic c=0 r=0.594
    rd9 (\633\:VDDA \595\:VDDA) analogLib_presistor_schematic c=0 r=0.792
    rd10 (\635\:VDDA \569\:VDDA) analogLib_presistor_schematic c=0 r=0.396
    rd11 (\1505\:GNDA \902\:GNDA) analogLib_presistor_schematic c=0 \
        r=0.396
    rd12 (\1507\:GNDA \689\:GNDA) analogLib_presistor_schematic c=0 \
        r=0.792
    rd13 (\1509\:GNDA \243\:GNDA) analogLib_presistor_schematic c=0 \
        r=0.07425
    rd14 (\1511\:GNDA \849\:GNDA) analogLib_presistor_schematic c=0 \
        r=0.396
    rd15 (\1513\:GNDA \730\:GNDA) analogLib_presistor_schematic c=0 \
        r=0.792
    rd16 (\1515\:GNDA \240\:GNDA) analogLib_presistor_schematic c=0 \
        r=0.07425
    rd17 (\39\:D1 \11\:D1) analogLib_presistor_schematic c=0 r=1.3114
    rd18 (\11\:D1 \7\:D1) analogLib_presistor_schematic c=0 r=0.988786
    rd19 (\7\:D1 \42\:D1) analogLib_presistor_schematic c=0 r=1.60495
    rd20 (\46\:Vo1 \19\:Vo1) analogLib_presistor_schematic c=0 r=0.243334
    rd21 (\19\:Vo1 \48\:Vo1) analogLib_presistor_schematic c=0 r=0.72281
    rd22 (\49\:Vo1 \17\:Vo1) analogLib_presistor_schematic c=0 r=0.550199
    rd23 (\17\:Vo1 \51\:Vo1) analogLib_presistor_schematic c=0 r=0.415945
    rd24 (\51\:Vo1 \52\:Vo1) analogLib_presistor_schematic c=0 r=0.977212
    rd25 (\52\:Vo1 \12\:Vo1) analogLib_presistor_schematic c=0 r=1.43639
    rd26 (\812\:GNDA \1518\:GNDA) analogLib_presistor_schematic c=0 \
        r=0.653718
    rd27 (\1518\:GNDA \130\:GNDA) analogLib_presistor_schematic c=0 \
        r=0.185198
    rd28 (\130\:GNDA \126\:GNDA) analogLib_presistor_schematic c=0 \
        r=0.139647
    rd29 (\126\:GNDA \122\:GNDA) analogLib_presistor_schematic c=0 \
        r=0.178005
    rd30 (\122\:GNDA \118\:GNDA) analogLib_presistor_schematic c=0 \
        r=0.128859
    rd31 (\118\:GNDA \1523\:GNDA) analogLib_presistor_schematic c=0 \
        r=0.061133
    rd32 (\1523\:GNDA \1524\:GNDA) analogLib_presistor_schematic c=0 \
        r=0.257718
    rd33 (\1524\:GNDA \561\:GNDA) analogLib_presistor_schematic c=0 \
        r=0.356377
    rd34 (\771\:GNDA \1527\:GNDA) analogLib_presistor_schematic c=0 \
        r=0.653718
    rd35 (\1527\:GNDA \132\:GNDA) analogLib_presistor_schematic c=0 \
        r=0.185198
    rd36 (\132\:GNDA \128\:GNDA) analogLib_presistor_schematic c=0 \
        r=0.139647
    rd37 (\128\:GNDA \124\:GNDA) analogLib_presistor_schematic c=0 \
        r=0.178005
    rd38 (\124\:GNDA \120\:GNDA) analogLib_presistor_schematic c=0 \
        r=0.128859
    rd39 (\120\:GNDA \1532\:GNDA) analogLib_presistor_schematic c=0 \
        r=0.061133
    rd40 (\1532\:GNDA \1533\:GNDA) analogLib_presistor_schematic c=0 \
        r=0.257718
    rd41 (\1533\:GNDA \245\:GNDA) analogLib_presistor_schematic c=0 \
        r=0.564419
    rd42 (\43\:D1 \44\:D1) analogLib_presistor_schematic c=0 r=0.441861
    rd43 (\44\:D1 \14\:D1) analogLib_presistor_schematic c=0 r=0.152234
    rd44 (\14\:D1 \46\:D1) analogLib_presistor_schematic c=0 r=0.81391
    rd45 (\54\:Vo1 \55\:Vo1) analogLib_presistor_schematic c=0 r=0.517616
    rd46 (\56\:Vo1 \57\:Vo1) analogLib_presistor_schematic c=0 r=0.522589
    rd47 (\194\:S \50\:S) analogLib_presistor_schematic c=0 r=0.0594
    rd48 (\196\:S \52\:S) analogLib_presistor_schematic c=0 r=0.0594
    rd49 (\198\:S \186\:S) analogLib_presistor_schematic c=0 r=0.792
    rd50 (\200\:S \172\:S) analogLib_presistor_schematic c=0 r=0.792
    rd51 (\202\:S \163\:S) analogLib_presistor_schematic c=0 r=0.396
    rd52 (\637\:VDDA \517\:VDDA) analogLib_presistor_schematic c=0 r=0.594
    rd53 (\639\:VDDA \519\:VDDA) analogLib_presistor_schematic c=0 r=0.594
    rd54 (\641\:VDDA \521\:VDDA) analogLib_presistor_schematic c=0 r=0.594
    rd55 (\643\:VDDA \523\:VDDA) analogLib_presistor_schematic c=0 r=0.594
    rd56 (\645\:VDDA \525\:VDDA) analogLib_presistor_schematic c=0 r=0.594
    rd57 (\647\:VDDA \527\:VDDA) analogLib_presistor_schematic c=0 r=0.594
    rd58 (\649\:VDDA \529\:VDDA) analogLib_presistor_schematic c=0 r=0.594
    rd59 (\651\:VDDA \531\:VDDA) analogLib_presistor_schematic c=0 r=0.594
    rd60 (\653\:VDDA \612\:VDDA) analogLib_presistor_schematic c=0 r=0.792
    rd61 (\655\:VDDA \559\:VDDA) analogLib_presistor_schematic c=0 r=0.396
    rd62 (\204\:S \205\:S) analogLib_presistor_schematic c=0 r=3.92691
    rd63 (\88\:BG_REF \89\:BG_REF) analogLib_presistor_schematic c=0 \
        r=3.92691
    rd64 (\16\:vv \17\:vv) analogLib_presistor_schematic c=0 r=12.6534
    rd65 (\65\:S2 \66\:S2) analogLib_presistor_schematic c=0 r=12.6534
    rd66 (\206\:S \207\:S) analogLib_presistor_schematic c=0 r=13.4454
    rd67 (\90\:BG_REF \71\:BG_REF) analogLib_presistor_schematic c=0 \
        r=2.96453
    rd68 (\71\:BG_REF \63\:BG_REF) analogLib_presistor_schematic c=0 \
        r=0.950161
    rd69 (\63\:BG_REF \59\:BG_REF) analogLib_presistor_schematic c=0 \
        r=0.950161
    rd70 (\59\:BG_REF \55\:BG_REF) analogLib_presistor_schematic c=0 \
        r=0.950161
    rd71 (\55\:BG_REF \51\:BG_REF) analogLib_presistor_schematic c=0 \
        r=0.950161
    rd72 (\51\:BG_REF \47\:BG_REF) analogLib_presistor_schematic c=0 \
        r=0.950161
    rd73 (\47\:BG_REF \43\:BG_REF) analogLib_presistor_schematic c=0 \
        r=0.950161
    rd74 (\43\:BG_REF \35\:BG_REF) analogLib_presistor_schematic c=0 \
        r=0.950161
    rd75 (\35\:BG_REF \23\:BG_REF) analogLib_presistor_schematic c=0 \
        r=0.950161
    rd76 (\23\:BG_REF \100\:BG_REF) analogLib_presistor_schematic c=0 \
        r=2.87955
    rd77 (\18\:vv \19\:vv) analogLib_presistor_schematic c=0 r=13.4454
    rd78 (\67\:S2 \68\:S2) analogLib_presistor_schematic c=0 r=13.4454
    rd79 (\208\:S \45\:S) analogLib_presistor_schematic c=0 r=4.20823
    rd80 (\45\:S \37\:S) analogLib_presistor_schematic c=0 r=0.950161
    rd81 (\37\:S \31\:S) analogLib_presistor_schematic c=0 r=0.950161
    rd82 (\31\:S \27\:S) analogLib_presistor_schematic c=0 r=0.950161
    rd83 (\27\:S \21\:S) analogLib_presistor_schematic c=0 r=0.950161
    rd84 (\21\:S \13\:S) analogLib_presistor_schematic c=0 r=0.950161
    rd85 (\13\:S \9\:S) analogLib_presistor_schematic c=0 r=0.950161
    rd86 (\9\:S \216\:S) analogLib_presistor_schematic c=0 r=3.53617
    rd87 (\101\:BG_REF \73\:BG_REF) analogLib_presistor_schematic c=0 \
        r=2.96453
    rd88 (\73\:BG_REF \25\:BG_REF) analogLib_presistor_schematic c=0 \
        r=7.60129
    rd89 (\25\:BG_REF \104\:BG_REF) analogLib_presistor_schematic c=0 \
        r=2.87955
    rd90 (\20\:vv \21\:vv) analogLib_presistor_schematic c=0 r=13.4454
    rd91 (\69\:S2 \9\:S2) analogLib_presistor_schematic c=0 r=7.35226
    rd92 (\9\:S2 \71\:S2) analogLib_presistor_schematic c=0 r=6.09311
    rd93 (\217\:S \39\:S) analogLib_presistor_schematic c=0 r=5.15839
    rd94 (\39\:S \23\:S) analogLib_presistor_schematic c=0 r=2.85048
    rd95 (\23\:S \15\:S) analogLib_presistor_schematic c=0 r=0.950161
    rd96 (\15\:S \221\:S) analogLib_presistor_schematic c=0 r=4.48633
    rd97 (\105\:BG_REF \75\:BG_REF) analogLib_presistor_schematic c=0 \
        r=2.96453
    rd98 (\75\:BG_REF \65\:BG_REF) analogLib_presistor_schematic c=0 \
        r=0.950161
    rd99 (\65\:BG_REF \37\:BG_REF) analogLib_presistor_schematic c=0 \
        r=5.70097
    rd100 (\37\:BG_REF \27\:BG_REF) analogLib_presistor_schematic c=0 \
        r=0.950161
    rd101 (\27\:BG_REF \110\:BG_REF) analogLib_presistor_schematic c=0 \
        r=2.87955
    rd102 (\225\:Vm1 \214\:Vm1) analogLib_presistor_schematic c=0 \
        r=2.33495
    rd103 (\214\:Vm1 \202\:Vm1) analogLib_presistor_schematic c=0 \
        r=0.950161
    rd104 (\202\:Vm1 \190\:Vm1) analogLib_presistor_schematic c=0 \
        r=0.950161
    rd105 (\190\:Vm1 \178\:Vm1) analogLib_presistor_schematic c=0 \
        r=0.950161
    rd106 (\178\:Vm1 \172\:Vm1) analogLib_presistor_schematic c=0 \
        r=0.424869
    rd107 (\172\:Vm1 \164\:Vm1) analogLib_presistor_schematic c=0 \
        r=0.525292
    rd108 (\164\:Vm1 \152\:Vm1) analogLib_presistor_schematic c=0 \
        r=0.950161
    rd109 (\152\:Vm1 \138\:Vm1) analogLib_presistor_schematic c=0 \
        r=0.950161
    rd110 (\138\:Vm1 \126\:Vm1) analogLib_presistor_schematic c=0 \
        r=0.950161
    rd111 (\126\:Vm1 \114\:Vm1) analogLib_presistor_schematic c=0 \
        r=0.950161
    rd112 (\114\:Vm1 \236\:Vm1) analogLib_presistor_schematic c=0 \
        r=3.50913
    rd113 (\22\:vv \7\:vv) analogLib_presistor_schematic c=0 r=7.64581
    rd114 (\7\:vv \24\:vv) analogLib_presistor_schematic c=0 r=5.79956
    rd115 (\72\:S2 \73\:S2) analogLib_presistor_schematic c=0 r=13.4454
    rd116 (\222\:S \41\:S) analogLib_presistor_schematic c=0 r=5.15839
    rd117 (\41\:S \33\:S) analogLib_presistor_schematic c=0 r=0.950161
    rd118 (\33\:S \17\:S) analogLib_presistor_schematic c=0 r=2.85048
    rd119 (\17\:S \226\:S) analogLib_presistor_schematic c=0 r=4.48633
    rd120 (\111\:BG_REF \77\:BG_REF) analogLib_presistor_schematic c=0 \
        r=2.96453
    rd121 (\77\:BG_REF \67\:BG_REF) analogLib_presistor_schematic c=0 \
        r=0.950161
    rd122 (\67\:BG_REF \39\:BG_REF) analogLib_presistor_schematic c=0 \
        r=5.70097
    rd123 (\39\:BG_REF \29\:BG_REF) analogLib_presistor_schematic c=0 \
        r=0.950161
    rd124 (\29\:BG_REF \116\:BG_REF) analogLib_presistor_schematic c=0 \
        r=2.87955
    rd125 (\237\:Vm1 \216\:Vm1) analogLib_presistor_schematic c=0 \
        r=2.33495
    rd126 (\216\:Vm1 \204\:Vm1) analogLib_presistor_schematic c=0 \
        r=0.950161
    rd127 (\204\:Vm1 \192\:Vm1) analogLib_presistor_schematic c=0 \
        r=0.950161
    rd128 (\192\:Vm1 \180\:Vm1) analogLib_presistor_schematic c=0 \
        r=0.950161
    rd129 (\180\:Vm1 \166\:Vm1) analogLib_presistor_schematic c=0 \
        r=0.950161
    rd130 (\166\:Vm1 \154\:Vm1) analogLib_presistor_schematic c=0 \
        r=0.950161
    rd131 (\154\:Vm1 \146\:Vm1) analogLib_presistor_schematic c=0 \
        r=0.424869
    rd132 (\146\:Vm1 \140\:Vm1) analogLib_presistor_schematic c=0 \
        r=0.525292
    rd133 (\140\:Vm1 \128\:Vm1) analogLib_presistor_schematic c=0 \
        r=0.950161
    rd134 (\128\:Vm1 \116\:Vm1) analogLib_presistor_schematic c=0 \
        r=0.950161
    rd135 (\116\:Vm1 \248\:Vm1) analogLib_presistor_schematic c=0 \
        r=3.50913
    rd136 (\25\:vv \26\:vv) analogLib_presistor_schematic c=0 r=13.4454
    rd137 (\74\:S2 \75\:S2) analogLib_presistor_schematic c=0 r=13.4454
    rd138 (\227\:S \47\:S) analogLib_presistor_schematic c=0 r=4.20823
    rd139 (\47\:S \43\:S) analogLib_presistor_schematic c=0 r=0.950161
    rd140 (\43\:S \35\:S) analogLib_presistor_schematic c=0 r=0.950161
    rd141 (\35\:S \29\:S) analogLib_presistor_schematic c=0 r=0.950161
    rd142 (\29\:S \25\:S) analogLib_presistor_schematic c=0 r=0.950161
    rd143 (\25\:S \19\:S) analogLib_presistor_schematic c=0 r=0.950161
    rd144 (\19\:S \11\:S) analogLib_presistor_schematic c=0 r=0.950161
    rd145 (\11\:S \235\:S) analogLib_presistor_schematic c=0 r=3.53617
    rd146 (\117\:BG_REF \79\:BG_REF) analogLib_presistor_schematic c=0 \
        r=2.96453
    rd147 (\79\:BG_REF \31\:BG_REF) analogLib_presistor_schematic c=0 \
        r=7.60129
    rd148 (\31\:BG_REF \120\:BG_REF) analogLib_presistor_schematic c=0 \
        r=2.87955
    rd149 (\249\:Vm1 \218\:Vm1) analogLib_presistor_schematic c=0 \
        r=2.33495
    rd150 (\218\:Vm1 \206\:Vm1) analogLib_presistor_schematic c=0 \
        r=0.950161
    rd151 (\206\:Vm1 \194\:Vm1) analogLib_presistor_schematic c=0 \
        r=0.950161
    rd152 (\194\:Vm1 \182\:Vm1) analogLib_presistor_schematic c=0 \
        r=0.950161
    rd153 (\182\:Vm1 \168\:Vm1) analogLib_presistor_schematic c=0 \
        r=0.950161
    rd154 (\168\:Vm1 \156\:Vm1) analogLib_presistor_schematic c=0 \
        r=0.950161
    rd155 (\156\:Vm1 \142\:Vm1) analogLib_presistor_schematic c=0 \
        r=0.950161
    rd156 (\142\:Vm1 \130\:Vm1) analogLib_presistor_schematic c=0 \
        r=0.950161
    rd157 (\130\:Vm1 \118\:Vm1) analogLib_presistor_schematic c=0 \
        r=0.950161
    rd158 (\118\:Vm1 \259\:Vm1) analogLib_presistor_schematic c=0 \
        r=3.50913
    rd159 (\27\:vv \28\:vv) analogLib_presistor_schematic c=0 r=13.4454
    rd160 (\236\:S \237\:S) analogLib_presistor_schematic c=0 r=13.4454
    rd161 (\121\:BG_REF \81\:BG_REF) analogLib_presistor_schematic c=0 \
        r=2.96453
    rd162 (\81\:BG_REF \69\:BG_REF) analogLib_presistor_schematic c=0 \
        r=0.950161
    rd163 (\69\:BG_REF \61\:BG_REF) analogLib_presistor_schematic c=0 \
        r=0.950161
    rd164 (\61\:BG_REF \57\:BG_REF) analogLib_presistor_schematic c=0 \
        r=0.950161
    rd165 (\57\:BG_REF \53\:BG_REF) analogLib_presistor_schematic c=0 \
        r=0.950161
    rd166 (\53\:BG_REF \49\:BG_REF) analogLib_presistor_schematic c=0 \
        r=0.950161
    rd167 (\49\:BG_REF \45\:BG_REF) analogLib_presistor_schematic c=0 \
        r=0.950161
    rd168 (\45\:BG_REF \41\:BG_REF) analogLib_presistor_schematic c=0 \
        r=0.950161
    rd169 (\41\:BG_REF \33\:BG_REF) analogLib_presistor_schematic c=0 \
        r=0.950161
    rd170 (\33\:BG_REF \131\:BG_REF) analogLib_presistor_schematic c=0 \
        r=2.87955
    rd171 (\260\:Vm1 \220\:Vm1) analogLib_presistor_schematic c=0 \
        r=2.33495
    rd172 (\220\:Vm1 \208\:Vm1) analogLib_presistor_schematic c=0 \
        r=0.950161
    rd173 (\208\:Vm1 \196\:Vm1) analogLib_presistor_schematic c=0 \
        r=0.950161
    rd174 (\196\:Vm1 \184\:Vm1) analogLib_presistor_schematic c=0 \
        r=0.950161
    rd175 (\184\:Vm1 \170\:Vm1) analogLib_presistor_schematic c=0 \
        r=0.950161
    rd176 (\170\:Vm1 \158\:Vm1) analogLib_presistor_schematic c=0 \
        r=0.950161
    rd177 (\158\:Vm1 \144\:Vm1) analogLib_presistor_schematic c=0 \
        r=0.950161
    rd178 (\144\:Vm1 \132\:Vm1) analogLib_presistor_schematic c=0 \
        r=0.950161
    rd179 (\132\:Vm1 \120\:Vm1) analogLib_presistor_schematic c=0 \
        r=0.950161
    rd180 (\120\:Vm1 \270\:Vm1) analogLib_presistor_schematic c=0 \
        r=3.50913
    rd181 (\76\:S2 \77\:S2) analogLib_presistor_schematic c=0 r=13.0494
    rd182 (\238\:S \239\:S) analogLib_presistor_schematic c=0 r=13.4454
    rd183 (\271\:Vm1 \272\:Vm1) analogLib_presistor_schematic c=0 \
        r=12.6534
    rd184 (\240\:S \241\:S) analogLib_presistor_schematic c=0 r=1.18085
    rd185 (\241\:S \242\:S) analogLib_presistor_schematic c=0 r=2.87805
    rd186 (\536\:VDDA \658\:VDDA) analogLib_presistor_schematic c=0 \
        r=0.913834
    rd187 (\658\:VDDA \659\:VDDA) analogLib_presistor_schematic c=0 \
        r=0.730601
    rd188 (\659\:VDDA \660\:VDDA) analogLib_presistor_schematic c=0 \
        r=0.421339
    rd189 (\660\:VDDA \661\:VDDA) analogLib_presistor_schematic c=0 \
        r=0.369796
    rd190 (\661\:VDDA \662\:VDDA) analogLib_presistor_schematic c=0 \
        r=0.108481
    rd191 (\662\:VDDA \663\:VDDA) analogLib_presistor_schematic c=0 \
        r=0.478277
    rd192 (\663\:VDDA \664\:VDDA) analogLib_presistor_schematic c=0 \
        r=0.478277
    rd193 (\664\:VDDA \665\:VDDA) analogLib_presistor_schematic c=0 \
        r=0.793533
    rd194 (\665\:VDDA \591\:VDDA) analogLib_presistor_schematic c=0 \
        r=0.913834
    rd195 (\537\:VDDA \668\:VDDA) analogLib_presistor_schematic c=0 \
        r=2.85658
    rd196 (\668\:VDDA \501\:VDDA) analogLib_presistor_schematic c=0 \
        r=0.270371
    rd197 (\501\:VDDA \485\:VDDA) analogLib_presistor_schematic c=0 \
        r=0.424869
    rd198 (\485\:VDDA \671\:VDDA) analogLib_presistor_schematic c=0 \
        r=0.513705
    rd199 (\671\:VDDA \450\:VDDA) analogLib_presistor_schematic c=0 \
        r=0.436456
    rd200 (\450\:VDDA \673\:VDDA) analogLib_presistor_schematic c=0 \
        r=0.513705
    rd201 (\673\:VDDA \395\:VDDA) analogLib_presistor_schematic c=0 \
        r=0.436456
    rd202 (\395\:VDDA \675\:VDDA) analogLib_presistor_schematic c=0 \
        r=0.513705
    rd203 (\675\:VDDA \360\:VDDA) analogLib_presistor_schematic c=0 \
        r=0.436456
    rd204 (\360\:VDDA \677\:VDDA) analogLib_presistor_schematic c=0 \
        r=0.513705
    rd205 (\677\:VDDA \325\:VDDA) analogLib_presistor_schematic c=0 \
        r=0.436456
    rd206 (\325\:VDDA \679\:VDDA) analogLib_presistor_schematic c=0 \
        r=0.513705
    rd207 (\679\:VDDA \290\:VDDA) analogLib_presistor_schematic c=0 \
        r=0.436456
    rd208 (\290\:VDDA \681\:VDDA) analogLib_presistor_schematic c=0 \
        r=0.513705
    rd209 (\681\:VDDA \255\:VDDA) analogLib_presistor_schematic c=0 \
        r=0.436456
    rd210 (\255\:VDDA \683\:VDDA) analogLib_presistor_schematic c=0 \
        r=0.513705
    rd211 (\683\:VDDA \220\:VDDA) analogLib_presistor_schematic c=0 \
        r=0.436456
    rd212 (\220\:VDDA \685\:VDDA) analogLib_presistor_schematic c=0 \
        r=0.513705
    rd213 (\685\:VDDA \185\:VDDA) analogLib_presistor_schematic c=0 \
        r=0.436456
    rd214 (\185\:VDDA \687\:VDDA) analogLib_presistor_schematic c=0 \
        r=0.513705
    rd215 (\687\:VDDA \150\:VDDA) analogLib_presistor_schematic c=0 \
        r=0.436456
    rd216 (\150\:VDDA \133\:VDDA) analogLib_presistor_schematic c=0 \
        r=0.525292
    rd217 (\133\:VDDA \102\:VDDA) analogLib_presistor_schematic c=0 \
        r=0.424869
    rd218 (\102\:VDDA \86\:VDDA) analogLib_presistor_schematic c=0 \
        r=0.424869
    rd219 (\86\:VDDA \692\:VDDA) analogLib_presistor_schematic c=0 \
        r=0.270371
    rd220 (\692\:VDDA \590\:VDDA) analogLib_presistor_schematic c=0 \
        r=2.85658
    rd221 (\540\:VDDA \695\:VDDA) analogLib_presistor_schematic c=0 \
        r=2.85658
    rd222 (\695\:VDDA \503\:VDDA) analogLib_presistor_schematic c=0 \
        r=0.270371
    rd223 (\503\:VDDA \487\:VDDA) analogLib_presistor_schematic c=0 \
        r=0.424869
    rd224 (\487\:VDDA \472\:VDDA) analogLib_presistor_schematic c=0 \
        r=0.372726
    rd225 (\472\:VDDA \454\:VDDA) analogLib_presistor_schematic c=0 \
        r=0.243334
    rd226 (\454\:VDDA \438\:VDDA) analogLib_presistor_schematic c=0 \
        r=0.355345
    rd227 (\438\:VDDA \399\:VDDA) analogLib_presistor_schematic c=0 \
        r=0.592885
    rd228 (\399\:VDDA \383\:VDDA) analogLib_presistor_schematic c=0 \
        r=0.353414
    rd229 (\383\:VDDA \364\:VDDA) analogLib_presistor_schematic c=0 \
        r=0.598679
    rd230 (\364\:VDDA \348\:VDDA) analogLib_presistor_schematic c=0 \
        r=0.34762
    rd231 (\348\:VDDA \329\:VDDA) analogLib_presistor_schematic c=0 \
        r=0.602541
    rd232 (\329\:VDDA \313\:VDDA) analogLib_presistor_schematic c=0 \
        r=0.359207
    rd233 (\313\:VDDA \294\:VDDA) analogLib_presistor_schematic c=0 \
        r=0.592885
    rd234 (\294\:VDDA \278\:VDDA) analogLib_presistor_schematic c=0 \
        r=0.353414
    rd235 (\278\:VDDA \259\:VDDA) analogLib_presistor_schematic c=0 \
        r=0.594816
    rd236 (\259\:VDDA \243\:VDDA) analogLib_presistor_schematic c=0 \
        r=0.351482
    rd237 (\243\:VDDA \224\:VDDA) analogLib_presistor_schematic c=0 \
        r=0.596748
    rd238 (\224\:VDDA \208\:VDDA) analogLib_presistor_schematic c=0 \
        r=0.334101
    rd239 (\208\:VDDA \189\:VDDA) analogLib_presistor_schematic c=0 \
        r=0.617991
    rd240 (\189\:VDDA \173\:VDDA) analogLib_presistor_schematic c=0 \
        r=0.328308
    rd241 (\173\:VDDA \154\:VDDA) analogLib_presistor_schematic c=0 \
        r=0.621854
    rd242 (\154\:VDDA \138\:VDDA) analogLib_presistor_schematic c=0 \
        r=0.324445
    rd243 (\138\:VDDA \118\:VDDA) analogLib_presistor_schematic c=0 \
        r=0.580332
    rd244 (\118\:VDDA \104\:VDDA) analogLib_presistor_schematic c=0 \
        r=0.379485
    rd245 (\104\:VDDA \88\:VDDA) analogLib_presistor_schematic c=0 \
        r=0.424869
    rd246 (\88\:VDDA \720\:VDDA) analogLib_presistor_schematic c=0 \
        r=0.270371
    rd247 (\720\:VDDA \587\:VDDA) analogLib_presistor_schematic c=0 \
        r=2.85658
    rd248 (\542\:VDDA \723\:VDDA) analogLib_presistor_schematic c=0 \
        r=2.85658
    rd249 (\723\:VDDA \505\:VDDA) analogLib_presistor_schematic c=0 \
        r=0.270371
    rd250 (\505\:VDDA \489\:VDDA) analogLib_presistor_schematic c=0 \
        r=0.424869
    rd251 (\489\:VDDA \474\:VDDA) analogLib_presistor_schematic c=0 \
        r=0.372726
    rd252 (\474\:VDDA \456\:VDDA) analogLib_presistor_schematic c=0 \
        r=0.243334
    rd253 (\456\:VDDA \440\:VDDA) analogLib_presistor_schematic c=0 \
        r=0.355345
    rd254 (\440\:VDDA \401\:VDDA) analogLib_presistor_schematic c=0 \
        r=0.592885
    rd255 (\401\:VDDA \385\:VDDA) analogLib_presistor_schematic c=0 \
        r=0.353414
    rd256 (\385\:VDDA \366\:VDDA) analogLib_presistor_schematic c=0 \
        r=0.598679
    rd257 (\366\:VDDA \350\:VDDA) analogLib_presistor_schematic c=0 \
        r=0.34762
    rd258 (\350\:VDDA \331\:VDDA) analogLib_presistor_schematic c=0 \
        r=0.602541
    rd259 (\331\:VDDA \315\:VDDA) analogLib_presistor_schematic c=0 \
        r=0.359207
    rd260 (\315\:VDDA \296\:VDDA) analogLib_presistor_schematic c=0 \
        r=0.592885
    rd261 (\296\:VDDA \280\:VDDA) analogLib_presistor_schematic c=0 \
        r=0.353414
    rd262 (\280\:VDDA \261\:VDDA) analogLib_presistor_schematic c=0 \
        r=0.594816
    rd263 (\261\:VDDA \245\:VDDA) analogLib_presistor_schematic c=0 \
        r=0.351482
    rd264 (\245\:VDDA \226\:VDDA) analogLib_presistor_schematic c=0 \
        r=0.596748
    rd265 (\226\:VDDA \210\:VDDA) analogLib_presistor_schematic c=0 \
        r=0.334101
    rd266 (\210\:VDDA \191\:VDDA) analogLib_presistor_schematic c=0 \
        r=0.617991
    rd267 (\191\:VDDA \175\:VDDA) analogLib_presistor_schematic c=0 \
        r=0.328308
    rd268 (\175\:VDDA \156\:VDDA) analogLib_presistor_schematic c=0 \
        r=0.621854
    rd269 (\156\:VDDA \140\:VDDA) analogLib_presistor_schematic c=0 \
        r=0.324445
    rd270 (\140\:VDDA \120\:VDDA) analogLib_presistor_schematic c=0 \
        r=0.580332
    rd271 (\120\:VDDA \106\:VDDA) analogLib_presistor_schematic c=0 \
        r=0.379485
    rd272 (\106\:VDDA \90\:VDDA) analogLib_presistor_schematic c=0 \
        r=0.424869
    rd273 (\90\:VDDA \748\:VDDA) analogLib_presistor_schematic c=0 \
        r=0.270371
    rd274 (\748\:VDDA \585\:VDDA) analogLib_presistor_schematic c=0 \
        r=2.85658
    rd275 (\544\:VDDA \751\:VDDA) analogLib_presistor_schematic c=0 \
        r=2.85658
    rd276 (\751\:VDDA \507\:VDDA) analogLib_presistor_schematic c=0 \
        r=0.270371
    rd277 (\507\:VDDA \491\:VDDA) analogLib_presistor_schematic c=0 \
        r=0.424869
    rd278 (\491\:VDDA \476\:VDDA) analogLib_presistor_schematic c=0 \
        r=0.372726
    rd279 (\476\:VDDA \458\:VDDA) analogLib_presistor_schematic c=0 \
        r=0.243334
    rd280 (\458\:VDDA \442\:VDDA) analogLib_presistor_schematic c=0 \
        r=0.355345
    rd281 (\442\:VDDA \403\:VDDA) analogLib_presistor_schematic c=0 \
        r=0.592885
    rd282 (\403\:VDDA \387\:VDDA) analogLib_presistor_schematic c=0 \
        r=0.353414
    rd283 (\387\:VDDA \368\:VDDA) analogLib_presistor_schematic c=0 \
        r=0.598679
    rd284 (\368\:VDDA \352\:VDDA) analogLib_presistor_schematic c=0 \
        r=0.34762
    rd285 (\352\:VDDA \333\:VDDA) analogLib_presistor_schematic c=0 \
        r=0.602541
    rd286 (\333\:VDDA \317\:VDDA) analogLib_presistor_schematic c=0 \
        r=0.359207
    rd287 (\317\:VDDA \298\:VDDA) analogLib_presistor_schematic c=0 \
        r=0.592885
    rd288 (\298\:VDDA \282\:VDDA) analogLib_presistor_schematic c=0 \
        r=0.353414
    rd289 (\282\:VDDA \263\:VDDA) analogLib_presistor_schematic c=0 \
        r=0.594816
    rd290 (\263\:VDDA \247\:VDDA) analogLib_presistor_schematic c=0 \
        r=0.351482
    rd291 (\247\:VDDA \228\:VDDA) analogLib_presistor_schematic c=0 \
        r=0.596748
    rd292 (\228\:VDDA \212\:VDDA) analogLib_presistor_schematic c=0 \
        r=0.334101
    rd293 (\212\:VDDA \193\:VDDA) analogLib_presistor_schematic c=0 \
        r=0.617991
    rd294 (\193\:VDDA \177\:VDDA) analogLib_presistor_schematic c=0 \
        r=0.328308
    rd295 (\177\:VDDA \158\:VDDA) analogLib_presistor_schematic c=0 \
        r=0.621854
    rd296 (\158\:VDDA \142\:VDDA) analogLib_presistor_schematic c=0 \
        r=0.324445
    rd297 (\142\:VDDA \122\:VDDA) analogLib_presistor_schematic c=0 \
        r=0.580332
    rd298 (\122\:VDDA \108\:VDDA) analogLib_presistor_schematic c=0 \
        r=0.379485
    rd299 (\108\:VDDA \92\:VDDA) analogLib_presistor_schematic c=0 \
        r=0.424869
    rd300 (\92\:VDDA \776\:VDDA) analogLib_presistor_schematic c=0 \
        r=0.270371
    rd301 (\776\:VDDA \583\:VDDA) analogLib_presistor_schematic c=0 \
        r=2.85658
    rd302 (\546\:VDDA \779\:VDDA) analogLib_presistor_schematic c=0 \
        r=2.85658
    rd303 (\779\:VDDA \509\:VDDA) analogLib_presistor_schematic c=0 \
        r=0.270371
    rd304 (\509\:VDDA \493\:VDDA) analogLib_presistor_schematic c=0 \
        r=0.424869
    rd305 (\493\:VDDA \478\:VDDA) analogLib_presistor_schematic c=0 \
        r=0.372726
    rd306 (\478\:VDDA \460\:VDDA) analogLib_presistor_schematic c=0 \
        r=0.243334
    rd307 (\460\:VDDA \444\:VDDA) analogLib_presistor_schematic c=0 \
        r=0.355345
    rd308 (\444\:VDDA \405\:VDDA) analogLib_presistor_schematic c=0 \
        r=0.592885
    rd309 (\405\:VDDA \389\:VDDA) analogLib_presistor_schematic c=0 \
        r=0.353414
    rd310 (\389\:VDDA \370\:VDDA) analogLib_presistor_schematic c=0 \
        r=0.598679
    rd311 (\370\:VDDA \354\:VDDA) analogLib_presistor_schematic c=0 \
        r=0.34762
    rd312 (\354\:VDDA \335\:VDDA) analogLib_presistor_schematic c=0 \
        r=0.602541
    rd313 (\335\:VDDA \319\:VDDA) analogLib_presistor_schematic c=0 \
        r=0.359207
    rd314 (\319\:VDDA \300\:VDDA) analogLib_presistor_schematic c=0 \
        r=0.592885
    rd315 (\300\:VDDA \284\:VDDA) analogLib_presistor_schematic c=0 \
        r=0.353414
    rd316 (\284\:VDDA \265\:VDDA) analogLib_presistor_schematic c=0 \
        r=0.594816
    rd317 (\265\:VDDA \249\:VDDA) analogLib_presistor_schematic c=0 \
        r=0.351482
    rd318 (\249\:VDDA \230\:VDDA) analogLib_presistor_schematic c=0 \
        r=0.596748
    rd319 (\230\:VDDA \214\:VDDA) analogLib_presistor_schematic c=0 \
        r=0.334101
    rd320 (\214\:VDDA \195\:VDDA) analogLib_presistor_schematic c=0 \
        r=0.617991
    rd321 (\195\:VDDA \179\:VDDA) analogLib_presistor_schematic c=0 \
        r=0.328308
    rd322 (\179\:VDDA \160\:VDDA) analogLib_presistor_schematic c=0 \
        r=0.621854
    rd323 (\160\:VDDA \144\:VDDA) analogLib_presistor_schematic c=0 \
        r=0.324445
    rd324 (\144\:VDDA \124\:VDDA) analogLib_presistor_schematic c=0 \
        r=0.580332
    rd325 (\124\:VDDA \110\:VDDA) analogLib_presistor_schematic c=0 \
        r=0.379485
    rd326 (\110\:VDDA \94\:VDDA) analogLib_presistor_schematic c=0 \
        r=0.424869
    rd327 (\94\:VDDA \804\:VDDA) analogLib_presistor_schematic c=0 \
        r=0.270371
    rd328 (\804\:VDDA \581\:VDDA) analogLib_presistor_schematic c=0 \
        r=2.85658
    rd329 (\548\:VDDA \807\:VDDA) analogLib_presistor_schematic c=0 \
        r=2.85658
    rd330 (\807\:VDDA \511\:VDDA) analogLib_presistor_schematic c=0 \
        r=0.270371
    rd331 (\511\:VDDA \495\:VDDA) analogLib_presistor_schematic c=0 \
        r=0.424869
    rd332 (\495\:VDDA \480\:VDDA) analogLib_presistor_schematic c=0 \
        r=0.372726
    rd333 (\480\:VDDA \462\:VDDA) analogLib_presistor_schematic c=0 \
        r=0.243334
    rd334 (\462\:VDDA \446\:VDDA) analogLib_presistor_schematic c=0 \
        r=0.355345
    rd335 (\446\:VDDA \407\:VDDA) analogLib_presistor_schematic c=0 \
        r=0.592885
    rd336 (\407\:VDDA \391\:VDDA) analogLib_presistor_schematic c=0 \
        r=0.353414
    rd337 (\391\:VDDA \372\:VDDA) analogLib_presistor_schematic c=0 \
        r=0.598679
    rd338 (\372\:VDDA \356\:VDDA) analogLib_presistor_schematic c=0 \
        r=0.34762
    rd339 (\356\:VDDA \337\:VDDA) analogLib_presistor_schematic c=0 \
        r=0.602541
    rd340 (\337\:VDDA \321\:VDDA) analogLib_presistor_schematic c=0 \
        r=0.359207
    rd341 (\321\:VDDA \302\:VDDA) analogLib_presistor_schematic c=0 \
        r=0.592885
    rd342 (\302\:VDDA \286\:VDDA) analogLib_presistor_schematic c=0 \
        r=0.353414
    rd343 (\286\:VDDA \267\:VDDA) analogLib_presistor_schematic c=0 \
        r=0.594816
    rd344 (\267\:VDDA \251\:VDDA) analogLib_presistor_schematic c=0 \
        r=0.351482
    rd345 (\251\:VDDA \232\:VDDA) analogLib_presistor_schematic c=0 \
        r=0.596748
    rd346 (\232\:VDDA \216\:VDDA) analogLib_presistor_schematic c=0 \
        r=0.334101
    rd347 (\216\:VDDA \197\:VDDA) analogLib_presistor_schematic c=0 \
        r=0.617991
    rd348 (\197\:VDDA \181\:VDDA) analogLib_presistor_schematic c=0 \
        r=0.328308
    rd349 (\181\:VDDA \162\:VDDA) analogLib_presistor_schematic c=0 \
        r=0.621854
    rd350 (\162\:VDDA \146\:VDDA) analogLib_presistor_schematic c=0 \
        r=0.324445
    rd351 (\146\:VDDA \126\:VDDA) analogLib_presistor_schematic c=0 \
        r=0.580332
    rd352 (\126\:VDDA \112\:VDDA) analogLib_presistor_schematic c=0 \
        r=0.379485
    rd353 (\112\:VDDA \96\:VDDA) analogLib_presistor_schematic c=0 \
        r=0.424869
    rd354 (\96\:VDDA \832\:VDDA) analogLib_presistor_schematic c=0 \
        r=0.270371
    rd355 (\832\:VDDA \579\:VDDA) analogLib_presistor_schematic c=0 \
        r=2.85658
    rd356 (\550\:VDDA \835\:VDDA) analogLib_presistor_schematic c=0 \
        r=2.85658
    rd357 (\835\:VDDA \513\:VDDA) analogLib_presistor_schematic c=0 \
        r=0.270371
    rd358 (\513\:VDDA \497\:VDDA) analogLib_presistor_schematic c=0 \
        r=0.424869
    rd359 (\497\:VDDA \482\:VDDA) analogLib_presistor_schematic c=0 \
        r=0.372726
    rd360 (\482\:VDDA \464\:VDDA) analogLib_presistor_schematic c=0 \
        r=0.243334
    rd361 (\464\:VDDA \448\:VDDA) analogLib_presistor_schematic c=0 \
        r=0.355345
    rd362 (\448\:VDDA \409\:VDDA) analogLib_presistor_schematic c=0 \
        r=0.592885
    rd363 (\409\:VDDA \393\:VDDA) analogLib_presistor_schematic c=0 \
        r=0.353414
    rd364 (\393\:VDDA \374\:VDDA) analogLib_presistor_schematic c=0 \
        r=0.598679
    rd365 (\374\:VDDA \358\:VDDA) analogLib_presistor_schematic c=0 \
        r=0.34762
    rd366 (\358\:VDDA \339\:VDDA) analogLib_presistor_schematic c=0 \
        r=0.602541
    rd367 (\339\:VDDA \323\:VDDA) analogLib_presistor_schematic c=0 \
        r=0.359207
    rd368 (\323\:VDDA \304\:VDDA) analogLib_presistor_schematic c=0 \
        r=0.592885
    rd369 (\304\:VDDA \288\:VDDA) analogLib_presistor_schematic c=0 \
        r=0.353414
    rd370 (\288\:VDDA \269\:VDDA) analogLib_presistor_schematic c=0 \
        r=0.594816
    rd371 (\269\:VDDA \253\:VDDA) analogLib_presistor_schematic c=0 \
        r=0.351482
    rd372 (\253\:VDDA \234\:VDDA) analogLib_presistor_schematic c=0 \
        r=0.596748
    rd373 (\234\:VDDA \218\:VDDA) analogLib_presistor_schematic c=0 \
        r=0.334101
    rd374 (\218\:VDDA \199\:VDDA) analogLib_presistor_schematic c=0 \
        r=0.617991
    rd375 (\199\:VDDA \183\:VDDA) analogLib_presistor_schematic c=0 \
        r=0.328308
    rd376 (\183\:VDDA \164\:VDDA) analogLib_presistor_schematic c=0 \
        r=0.621854
    rd377 (\164\:VDDA \148\:VDDA) analogLib_presistor_schematic c=0 \
        r=0.324445
    rd378 (\148\:VDDA \128\:VDDA) analogLib_presistor_schematic c=0 \
        r=0.580332
    rd379 (\128\:VDDA \114\:VDDA) analogLib_presistor_schematic c=0 \
        r=0.379485
    rd380 (\114\:VDDA \98\:VDDA) analogLib_presistor_schematic c=0 \
        r=0.424869
    rd381 (\98\:VDDA \860\:VDDA) analogLib_presistor_schematic c=0 \
        r=0.270371
    rd382 (\860\:VDDA \577\:VDDA) analogLib_presistor_schematic c=0 \
        r=2.85658
    rd383 (\553\:VDDA \863\:VDDA) analogLib_presistor_schematic c=0 \
        r=2.85658
    rd384 (\863\:VDDA \515\:VDDA) analogLib_presistor_schematic c=0 \
        r=0.270371
    rd385 (\515\:VDDA \499\:VDDA) analogLib_presistor_schematic c=0 \
        r=0.424869
    rd386 (\499\:VDDA \471\:VDDA) analogLib_presistor_schematic c=0 \
        r=0.336033
    rd387 (\471\:VDDA \466\:VDDA) analogLib_presistor_schematic c=0 \
        r=0.18926
    rd388 (\466\:VDDA \452\:VDDA) analogLib_presistor_schematic c=0 \
        r=0.424869
    rd389 (\452\:VDDA \416\:VDDA) analogLib_presistor_schematic c=0 \
        r=0.336033
    rd390 (\416\:VDDA \411\:VDDA) analogLib_presistor_schematic c=0 \
        r=0.18926
    rd391 (\411\:VDDA \397\:VDDA) analogLib_presistor_schematic c=0 \
        r=0.424869
    rd392 (\397\:VDDA \381\:VDDA) analogLib_presistor_schematic c=0 \
        r=0.336033
    rd393 (\381\:VDDA \376\:VDDA) analogLib_presistor_schematic c=0 \
        r=0.18926
    rd394 (\376\:VDDA \362\:VDDA) analogLib_presistor_schematic c=0 \
        r=0.424869
    rd395 (\362\:VDDA \346\:VDDA) analogLib_presistor_schematic c=0 \
        r=0.336033
    rd396 (\346\:VDDA \341\:VDDA) analogLib_presistor_schematic c=0 \
        r=0.18926
    rd397 (\341\:VDDA \327\:VDDA) analogLib_presistor_schematic c=0 \
        r=0.424869
    rd398 (\327\:VDDA \311\:VDDA) analogLib_presistor_schematic c=0 \
        r=0.336033
    rd399 (\311\:VDDA \306\:VDDA) analogLib_presistor_schematic c=0 \
        r=0.18926
    rd400 (\306\:VDDA \292\:VDDA) analogLib_presistor_schematic c=0 \
        r=0.424869
    rd401 (\292\:VDDA \276\:VDDA) analogLib_presistor_schematic c=0 \
        r=0.336033
    rd402 (\276\:VDDA \271\:VDDA) analogLib_presistor_schematic c=0 \
        r=0.18926
    rd403 (\271\:VDDA \257\:VDDA) analogLib_presistor_schematic c=0 \
        r=0.424869
    rd404 (\257\:VDDA \241\:VDDA) analogLib_presistor_schematic c=0 \
        r=0.336033
    rd405 (\241\:VDDA \236\:VDDA) analogLib_presistor_schematic c=0 \
        r=0.18926
    rd406 (\236\:VDDA \222\:VDDA) analogLib_presistor_schematic c=0 \
        r=0.424869
    rd407 (\222\:VDDA \206\:VDDA) analogLib_presistor_schematic c=0 \
        r=0.336033
    rd408 (\206\:VDDA \201\:VDDA) analogLib_presistor_schematic c=0 \
        r=0.18926
    rd409 (\201\:VDDA \187\:VDDA) analogLib_presistor_schematic c=0 \
        r=0.424869
    rd410 (\187\:VDDA \171\:VDDA) analogLib_presistor_schematic c=0 \
        r=0.336033
    rd411 (\171\:VDDA \166\:VDDA) analogLib_presistor_schematic c=0 \
        r=0.18926
    rd412 (\166\:VDDA \152\:VDDA) analogLib_presistor_schematic c=0 \
        r=0.424869
    rd413 (\152\:VDDA \136\:VDDA) analogLib_presistor_schematic c=0 \
        r=0.336033
    rd414 (\136\:VDDA \130\:VDDA) analogLib_presistor_schematic c=0 \
        r=0.18926
    rd415 (\130\:VDDA \116\:VDDA) analogLib_presistor_schematic c=0 \
        r=0.424869
    rd416 (\116\:VDDA \100\:VDDA) analogLib_presistor_schematic c=0 \
        r=0.424869
    rd417 (\100\:VDDA \897\:VDDA) analogLib_presistor_schematic c=0 \
        r=0.270371
    rd418 (\897\:VDDA \574\:VDDA) analogLib_presistor_schematic c=0 \
        r=2.85658
    rd419 (\554\:VDDA \900\:VDDA) analogLib_presistor_schematic c=0 \
        r=2.85658
    rd420 (\900\:VDDA \901\:VDDA) analogLib_presistor_schematic c=0 \
        r=10.8921
    rd421 (\901\:VDDA \573\:VDDA) analogLib_presistor_schematic c=0 \
        r=2.85658
    rd422 (\555\:VDDA \904\:VDDA) analogLib_presistor_schematic c=0 \
        r=0.913834
    rd423 (\904\:VDDA \905\:VDDA) analogLib_presistor_schematic c=0 \
        r=0.730601
    rd424 (\905\:VDDA \906\:VDDA) analogLib_presistor_schematic c=0 \
        r=0.421339
    rd425 (\906\:VDDA \907\:VDDA) analogLib_presistor_schematic c=0 \
        r=0.478277
    rd426 (\907\:VDDA \908\:VDDA) analogLib_presistor_schematic c=0 \
        r=0.478277
    rd427 (\908\:VDDA \909\:VDDA) analogLib_presistor_schematic c=0 \
        r=0.478277
    rd428 (\909\:VDDA \910\:VDDA) analogLib_presistor_schematic c=0 \
        r=0.793533
    rd429 (\910\:VDDA \572\:VDDA) analogLib_presistor_schematic c=0 \
        r=0.913834
    rd430 (\1535\:GNDA \758\:GNDA) analogLib_presistor_schematic c=0 \
        r=0.396
    rd431 (\1537\:GNDA \715\:GNDA) analogLib_presistor_schematic c=0 \
        r=0.396
    rd432 (\222\:Vm1 \224\:Vm1) analogLib_presistor_schematic c=0 \
        r=0.576195
    rd433 (\224\:Vm1 \275\:Vm1) analogLib_presistor_schematic c=0 \
        r=0.07593
    rd434 (\275\:Vm1 \276\:Vm1) analogLib_presistor_schematic c=0 \
        r=2.91186
    rd435 (\276\:Vm1 \212\:Vm1) analogLib_presistor_schematic c=0 \
        r=1.93895
    rd436 (\212\:Vm1 \200\:Vm1) analogLib_presistor_schematic c=0 \
        r=0.950161
    rd437 (\200\:Vm1 \188\:Vm1) analogLib_presistor_schematic c=0 \
        r=0.950161
    rd438 (\188\:Vm1 \176\:Vm1) analogLib_presistor_schematic c=0 \
        r=0.950161
    rd439 (\176\:Vm1 \162\:Vm1) analogLib_presistor_schematic c=0 \
        r=0.950161
    rd440 (\162\:Vm1 \150\:Vm1) analogLib_presistor_schematic c=0 \
        r=0.950161
    rd441 (\150\:Vm1 \136\:Vm1) analogLib_presistor_schematic c=0 \
        r=0.950161
    rd442 (\136\:Vm1 \124\:Vm1) analogLib_presistor_schematic c=0 \
        r=0.950161
    rd443 (\124\:Vm1 \112\:Vm1) analogLib_presistor_schematic c=0 \
        r=0.950161
    rd444 (\112\:Vm1 \286\:Vm1) analogLib_presistor_schematic c=0 \
        r=3.50913
    rd445 (\275\:Vm1 \287\:Vm1) analogLib_presistor_schematic c=0 \
        r=2.00813
    rd446 (\287\:Vm1 \210\:Vm1) analogLib_presistor_schematic c=0 \
        r=1.93895
    rd447 (\210\:Vm1 \198\:Vm1) analogLib_presistor_schematic c=0 \
        r=0.950161
    rd448 (\198\:Vm1 \186\:Vm1) analogLib_presistor_schematic c=0 \
        r=0.950161
    rd449 (\186\:Vm1 \174\:Vm1) analogLib_presistor_schematic c=0 \
        r=0.950161
    rd450 (\174\:Vm1 \160\:Vm1) analogLib_presistor_schematic c=0 \
        r=0.950161
    rd451 (\160\:Vm1 \148\:Vm1) analogLib_presistor_schematic c=0 \
        r=0.950161
    rd452 (\148\:Vm1 \134\:Vm1) analogLib_presistor_schematic c=0 \
        r=0.950161
    rd453 (\134\:Vm1 \122\:Vm1) analogLib_presistor_schematic c=0 \
        r=0.950161
    rd454 (\122\:Vm1 \110\:Vm1) analogLib_presistor_schematic c=0 \
        r=0.950161
    rd455 (\110\:Vm1 \297\:Vm1) analogLib_presistor_schematic c=0 \
        r=3.11313
    rd456 (\87\:BG_REF \133\:BG_REF) analogLib_presistor_schematic c=0 \
        r=2.23423
    rd457 (\133\:BG_REF \134\:BG_REF) analogLib_presistor_schematic c=0 \
        r=13.0494
    rd458 (\134\:GNDA \138\:GNDA) analogLib_presistor_schematic c=0 \
        r=0.180214
    rd459 (\138\:GNDA \136\:GNDA) analogLib_presistor_schematic c=0 \
        r=0.272607
    rd460 (\136\:GNDA \140\:GNDA) analogLib_presistor_schematic c=0 \
        r=0.198509
    rd461 (\140\:GNDA \1543\:GNDA) analogLib_presistor_schematic c=0 \
        r=0.093309
    rd462 (\1543\:GNDA \675\:GNDA) analogLib_presistor_schematic c=0 \
        r=0.98736
    rd463 (\134\:GNDA \1545\:GNDA) analogLib_presistor_schematic c=0 \
        r=0.294562
    rd464 (\1545\:GNDA \809\:GNDA) analogLib_presistor_schematic c=0 \
        r=0.98736
    rd465 (\78\:S2 \12\:S2) analogLib_presistor_schematic c=0 r=0.2376
    rd466 (\80\:S2 \14\:S2) analogLib_presistor_schematic c=0 r=0.2376
    rd467 (\243\:S \146\:S) analogLib_presistor_schematic c=0 r=0.0594
    rd468 (\245\:S \148\:S) analogLib_presistor_schematic c=0 r=0.0594
    rd469 (\247\:S \191\:S) analogLib_presistor_schematic c=0 r=0.792
    rd470 (\249\:S \183\:S) analogLib_presistor_schematic c=0 r=0.792
    rd471 (\251\:S \158\:S) analogLib_presistor_schematic c=0 r=0.396
    rd472 (\82\:S2 \60\:S2) analogLib_presistor_schematic c=0 r=0.396
    rd473 (\84\:S2 \52\:S2) analogLib_presistor_schematic c=0 r=0.396
    rd474 (\47\:D1 \38\:D1) analogLib_presistor_schematic c=0 r=0.680603
    rd475 (\38\:D1 \32\:D1) analogLib_presistor_schematic c=0 r=0.461054
    rd476 (\32\:D1 \26\:D1) analogLib_presistor_schematic c=0 r=0.461054
    rd477 (\26\:D1 \20\:D1) analogLib_presistor_schematic c=0 r=0.461054
    rd478 (\20\:D1 \52\:D1) analogLib_presistor_schematic c=0 r=0.86722
    rd479 (\58\:Vo1 \40\:Vo1) analogLib_presistor_schematic c=0 r=1.05018
    rd480 (\40\:Vo1 \34\:Vo1) analogLib_presistor_schematic c=0 r=0.461054
    rd481 (\34\:Vo1 \28\:Vo1) analogLib_presistor_schematic c=0 r=0.461054
    rd482 (\28\:Vo1 \22\:Vo1) analogLib_presistor_schematic c=0 r=0.461054
    rd483 (\22\:Vo1 \63\:Vo1) analogLib_presistor_schematic c=0 r=0.497645
    rd484 (\64\:Vo1 \43\:Vo1) analogLib_presistor_schematic c=0 r=0.819651
    rd485 (\43\:Vo1 \37\:Vo1) analogLib_presistor_schematic c=0 r=0.461054
    rd486 (\37\:Vo1 \31\:Vo1) analogLib_presistor_schematic c=0 r=0.461054
    rd487 (\31\:Vo1 \25\:Vo1) analogLib_presistor_schematic c=0 r=0.461054
    rd488 (\25\:Vo1 \69\:Vo1) analogLib_presistor_schematic c=0 r=0.728172
    rd489 (\53\:D1 \35\:D1) analogLib_presistor_schematic c=0 r=0.91113
    rd490 (\35\:D1 \29\:D1) analogLib_presistor_schematic c=0 r=0.461054
    rd491 (\29\:D1 \23\:D1) analogLib_presistor_schematic c=0 r=0.461054
    rd492 (\23\:D1 \17\:D1) analogLib_presistor_schematic c=0 r=0.461054
    rd493 (\17\:D1 \58\:D1) analogLib_presistor_schematic c=0 r=0.636693
    rd494 (\58\:D1 \59\:D1) analogLib_presistor_schematic c=0 r=0.391307
    rd495 (\59\:D1 \10\:D1) analogLib_presistor_schematic c=0 r=0.459098
    rd496 (\10\:D1 \61\:D1) analogLib_presistor_schematic c=0 r=0.507046
    rd497 (\16\:BIAS \32\:BIAS) analogLib_presistor_schematic c=0 \
        r=0.397656
    rd498 (\32\:BIAS \22\:BIAS) analogLib_presistor_schematic c=0 \
        r=0.162916
    rd499 (\22\:BIAS \10\:BIAS) analogLib_presistor_schematic c=0 \
        r=0.457395
    rd500 (\10\:BIAS \12\:BIAS) analogLib_presistor_schematic c=0 \
        r=0.457395
    rd501 (\12\:BIAS \29\:BIAS) analogLib_presistor_schematic c=0 \
        r=0.228697
    rd502 (\32\:BIAS BIAS) analogLib_presistor_schematic c=0 r=0.16566
    rd503 (\29\:BIAS \14\:BIAS) analogLib_presistor_schematic c=0 \
        r=0.544146
    rd504 (\151\:S \254\:S) analogLib_presistor_schematic c=0 r=0.981871
    rd505 (\254\:S \255\:S) analogLib_presistor_schematic c=0 r=0.219549
    rd506 (\255\:S \256\:S) analogLib_presistor_schematic c=0 r=0.160088
    rd507 (\256\:S \257\:S) analogLib_presistor_schematic c=0 r=0.230527
    rd508 (\257\:S \258\:S) analogLib_presistor_schematic c=0 r=0.230527
    rd509 (\258\:S \259\:S) analogLib_presistor_schematic c=0 r=0.230527
    rd510 (\259\:S \260\:S) analogLib_presistor_schematic c=0 r=0.230527
    rd511 (\260\:S \261\:S) analogLib_presistor_schematic c=0 r=0.230527
    rd512 (\261\:S \262\:S) analogLib_presistor_schematic c=0 r=0.230527
    rd513 (\262\:S \263\:S) analogLib_presistor_schematic c=0 r=0.230527
    rd514 (\263\:S \264\:S) analogLib_presistor_schematic c=0 r=0.300966
    rd515 (\264\:S \265\:S) analogLib_presistor_schematic c=0 r=0.219549
    rd516 (\265\:S \170\:S) analogLib_presistor_schematic c=0 r=0.981871
    rd517 (\155\:S \268\:S) analogLib_presistor_schematic c=0 r=0.981871
    rd518 (\268\:S \269\:S) analogLib_presistor_schematic c=0 r=0.219549
    rd519 (\269\:S \270\:S) analogLib_presistor_schematic c=0 r=0.160088
    rd520 (\270\:S \271\:S) analogLib_presistor_schematic c=0 r=0.230527
    rd521 (\271\:S \272\:S) analogLib_presistor_schematic c=0 r=0.230527
    rd522 (\272\:S \273\:S) analogLib_presistor_schematic c=0 r=0.230527
    rd523 (\273\:S \274\:S) analogLib_presistor_schematic c=0 r=0.230527
    rd524 (\274\:S \275\:S) analogLib_presistor_schematic c=0 r=0.230527
    rd525 (\275\:S \276\:S) analogLib_presistor_schematic c=0 r=0.230527
    rd526 (\276\:S \277\:S) analogLib_presistor_schematic c=0 r=0.230527
    rd527 (\277\:S \278\:S) analogLib_presistor_schematic c=0 r=0.300966
    rd528 (\278\:S \279\:S) analogLib_presistor_schematic c=0 r=0.219549
    rd529 (\279\:S \166\:S) analogLib_presistor_schematic c=0 r=0.981871
    rd530 (\19\:D2 \16\:D2) analogLib_presistor_schematic c=0 r=0.792
    rd531 (\21\:D2 \15\:D2) analogLib_presistor_schematic c=0 r=0.792
    rd532 (\86\:S2 \40\:S2) analogLib_presistor_schematic c=0 r=0.2376
    rd533 (\88\:S2 \42\:S2) analogLib_presistor_schematic c=0 r=0.2376
    rd534 (\90\:S2 \62\:S2) analogLib_presistor_schematic c=0 r=0.396
    rd535 (\92\:S2 \50\:S2) analogLib_presistor_schematic c=0 r=0.396
    rd536 (\44\:Vo1 \71\:Vo1) analogLib_presistor_schematic c=0 r=0.781917
    rd537 (\4\:Vo2 \2\:Vo2) analogLib_presistor_schematic c=0 r=0.578073
    rd538 (\18\:X \33\:X) analogLib_presistor_schematic c=0 r=2.70179
    rd539 (\13\:Vs \10\:Vs) analogLib_presistor_schematic c=0 r=0.4752
    rd540 (\15\:Vs \4\:Vs) analogLib_presistor_schematic c=0 r=0.659054
    rd541 (\4\:Vs \17\:Vs) analogLib_presistor_schematic c=0 r=0.460222
    rd542 (\17\:Vs \18\:Vs) analogLib_presistor_schematic c=0 r=0.083329
    rd543 (\17\:Vs \19\:Vs) analogLib_presistor_schematic c=0 r=0.350697
    rd544 (\19\:Vs \6\:Vs) analogLib_presistor_schematic c=0 r=0.773912
    rd545 (\6\:Vs \21\:Vs) analogLib_presistor_schematic c=0 r=0.682433
    rd546 (\22\:Vs \8\:Vs) analogLib_presistor_schematic c=0 r=0.562086
    rd547 (\8\:Vs \24\:Vs) analogLib_presistor_schematic c=0 r=0.6495
    rd548 (\23\:D2 \8\:D2) analogLib_presistor_schematic c=0 r=0.600102
    rd549 (\8\:D2 \25\:D2) analogLib_presistor_schematic c=0 r=0.413485
    rd550 (\144\:GNDA \145\:GNDA) analogLib_presistor_schematic c=0 \
        r=0.180214
    rd551 (\145\:GNDA \142\:GNDA) analogLib_presistor_schematic c=0 \
        r=0.270778
    rd552 (\142\:GNDA \148\:GNDA) analogLib_presistor_schematic c=0 \
        r=0.200339
    rd553 (\148\:GNDA \1551\:GNDA) analogLib_presistor_schematic c=0 \
        r=0.093309
    rd554 (\1551\:GNDA \537\:GNDA) analogLib_presistor_schematic c=0 \
        r=0.98736
    rd555 (\144\:GNDA \1553\:GNDA) analogLib_presistor_schematic c=0 \
        r=0.294562
    rd556 (\1553\:GNDA \845\:GNDA) analogLib_presistor_schematic c=0 \
        r=0.98736
    rd557 (\43\:S2 \95\:S2) analogLib_presistor_schematic c=0 r=0.981871
    rd558 (\95\:S2 \96\:S2) analogLib_presistor_schematic c=0 r=0.15277
    rd559 (\96\:S2 \28\:S2) analogLib_presistor_schematic c=0 r=0.121667
    rd560 (\28\:S2 \24\:S2) analogLib_presistor_schematic c=0 r=0.096968
    rd561 (\24\:S2 \99\:S2) analogLib_presistor_schematic c=0 r=0.072268
    rd562 (\99\:S2 \100\:S2) analogLib_presistor_schematic c=0 r=0.15277
    rd563 (\100\:S2 \101\:S2) analogLib_presistor_schematic c=0 r=0.387871
    rd564 (\101\:S2 \102\:S2) analogLib_presistor_schematic c=0 r=0.809766
    rd565 (\102\:S2 \103\:S2) analogLib_presistor_schematic c=0 r=13.0494
    rd566 (\47\:S2 \105\:S2) analogLib_presistor_schematic c=0 r=0.981871
    rd567 (\105\:S2 \106\:S2) analogLib_presistor_schematic c=0 r=0.15277
    rd568 (\106\:S2 \30\:S2) analogLib_presistor_schematic c=0 r=0.121667
    rd569 (\30\:S2 \26\:S2) analogLib_presistor_schematic c=0 r=0.096968
    rd570 (\26\:S2 \109\:S2) analogLib_presistor_schematic c=0 r=0.072268
    rd571 (\109\:S2 \110\:S2) analogLib_presistor_schematic c=0 r=0.15277
    rd572 (\110\:S2 \111\:S2) analogLib_presistor_schematic c=0 r=0.387871
    rd573 (\111\:S2 \112\:S2) analogLib_presistor_schematic c=0 r=0.385168
    rd574 (\26\:D2 \18\:D2) analogLib_presistor_schematic c=0 r=0.821481
    rd575 (\18\:D2 \28\:D2) analogLib_presistor_schematic c=0 r=0.634864
    rd576 (\28\:D2 \29\:D2) analogLib_presistor_schematic c=0 r=0.794508
    rd577 (\29\:D2 \12\:D2) analogLib_presistor_schematic c=0 r=0.503134
    rd578 (\12\:D2 \31\:D2) analogLib_presistor_schematic c=0 r=0.510453
    rd579 (\31\:D2 \32\:D2) analogLib_presistor_schematic c=0 r=1.02091
    rd580 (\32\:D2 \10\:D2) analogLib_presistor_schematic c=0 r=1.08494
    rd581 (\10\:D2 \34\:D2) analogLib_presistor_schematic c=0 r=0.371405
    rd582 (\29\:vv \15\:vv) analogLib_presistor_schematic c=0 r=0.319326
    rd583 (\15\:vv \9\:vv) analogLib_presistor_schematic c=0 r=0.886431
    rd584 (\9\:vv \12\:vv) analogLib_presistor_schematic c=0 r=2.61212
    rd585 (\12\:vv \33\:vv) analogLib_presistor_schematic c=0 r=1.24333
    rd586 (\33\:vv \34\:vv) analogLib_presistor_schematic c=0 r=12.6418
    rd587 (\15\:vv \35\:vv) analogLib_presistor_schematic c=0 r=0.316272
    rd588 (\25\:Vs \12\:Vs) analogLib_presistor_schematic c=0 r=0.232357
    rd589 (\12\:Vs \27\:Vs) analogLib_presistor_schematic c=0 r=1.22399
    rd590 (\1555\:GNDA \895\:GNDA) analogLib_presistor_schematic c=0 \
        r=0.792
    rd591 (\1557\:GNDA \898\:GNDA) analogLib_presistor_schematic c=0 \
        r=0.792
    rd592 (\1559\:GNDA \207\:GNDA) analogLib_presistor_schematic c=0 \
        r=0.07425
    rd593 (\1561\:GNDA \212\:GNDA) analogLib_presistor_schematic c=0 \
        r=0.07425
    rd594 (\15\:BG_REF \135\:BG_REF) analogLib_presistor_schematic c=0 \
        r=0.492363
    rd595 (\135\:BG_REF \136\:BG_REF) analogLib_presistor_schematic c=0 \
        r=0.247261
    rd596 (\136\:BG_REF \137\:BG_REF) analogLib_presistor_schematic c=0 \
        r=0.794336
    rd597 (\137\:BG_REF \138\:BG_REF) analogLib_presistor_schematic c=0 \
        r=3.92691
    rd598 (\135\:BG_REF \16\:BG_REF) analogLib_presistor_schematic c=0 \
        r=0.922093
    rd599 (\136\:BG_REF \83\:BG_REF) analogLib_presistor_schematic c=0 \
        r=0.198801
    rd600 (\138\:BG_REF BG_REF) analogLib_presistor_schematic c=0 \
        r=0.13319
    rd601 (BG_REF \140\:BG_REF) analogLib_presistor_schematic c=0 \
        r=0.340721
    rd602 (\140\:BG_REF \20\:BG_REF) analogLib_presistor_schematic c=0 \
        r=0.205328
    rd603 (\17\:X \34\:X) analogLib_presistor_schematic c=0 r=0.432862
    rd604 (\19\:Y \17\:Y) analogLib_presistor_schematic c=0 r=6.72334
    rd605 (\2\:net31 net31) analogLib_presistor_schematic c=0 r=1.20394
    rd606 (\2\:net24 net24) analogLib_presistor_schematic c=0 r=1.21011
    rd607 (\2\:net12 net12) analogLib_presistor_schematic c=0 r=1.68627
    rd608 (\4\:net30 \5\:net30) analogLib_presistor_schematic c=0 \
        r=0.037356
    rd609 (\5\:net30 \3\:net30) analogLib_presistor_schematic c=0 \
        r=0.010377
    rd610 (\3\:net30 net30) analogLib_presistor_schematic c=0 r=1.34751
    rd611 (\2\:net30 \4\:net30) analogLib_presistor_schematic c=0 r=0.594
    rd612 (\2\:net30 \5\:net30) analogLib_presistor_schematic c=0 r=0.594
    rd613 (\2\:net18 net18) analogLib_presistor_schematic c=0 r=1.21445
    rd614 (\2\:net2 net2) analogLib_presistor_schematic c=0 r=2.79142
    rd615 (\317\:GNDA \2\:GNDA) analogLib_presistor_schematic c=0 \
        r=0.893131
    rd616 (\35\:X \28\:X) analogLib_presistor_schematic c=0 r=0.1584
    rd617 (\2\:net32 net32) analogLib_presistor_schematic c=0 r=1.7155
    rd618 (\2\:net37 net37) analogLib_presistor_schematic c=0 r=1.23223
    rd619 (\2\:net13 net13) analogLib_presistor_schematic c=0 r=1.21011
    rd620 (\2\:net28 net28) analogLib_presistor_schematic c=0 r=1.66993
    rd621 (\2\:net34 net34) analogLib_presistor_schematic c=0 r=1.20394
    rd622 (\2\:net10 net10) analogLib_presistor_schematic c=0 r=1.68044
    rd626 (\13\:U \15\:U) analogLib_presistor_schematic c=0 r=0.594
    rd627 (\13\:U \115\:U) analogLib_presistor_schematic c=0 r=0.025403
    rd628 (\115\:U \116\:U) analogLib_presistor_schematic c=0 r=1.24225
    rd629 (\116\:U \117\:U) analogLib_presistor_schematic c=0 r=0.773097
    rd630 (\117\:U \118\:U) analogLib_presistor_schematic c=0 r=1.19889
    rd631 (\118\:U \105\:U) analogLib_presistor_schematic c=0 r=1.16196
    rd632 (\105\:U \85\:U) analogLib_presistor_schematic c=0 r=0.333359
    rd633 (\85\:U \8\:U) analogLib_presistor_schematic c=0 r=0.333359
    rd634 (\8\:U \62\:U) analogLib_presistor_schematic c=0 r=0.333359
    rd635 (\62\:U \45\:U) analogLib_presistor_schematic c=0 r=0.333359
    rd636 (\45\:U \124\:U) analogLib_presistor_schematic c=0 r=1.49364
    rd637 (\124\:U \125\:U) analogLib_presistor_schematic c=0 r=0.711756
    rd638 (\125\:U \126\:U) analogLib_presistor_schematic c=0 r=0.339854
    rd639 (\126\:U \127\:U) analogLib_presistor_schematic c=0 r=0.339397
    rd640 (\127\:U \128\:U) analogLib_presistor_schematic c=0 r=0.340312
    rd641 (\128\:U \129\:U) analogLib_presistor_schematic c=0 r=0.340312
    rd642 (\129\:U \130\:U) analogLib_presistor_schematic c=0 r=0.179544
    rd643 (\124\:U \131\:U) analogLib_presistor_schematic c=0 r=1.19375
    rd644 (\131\:U \132\:U) analogLib_presistor_schematic c=0 r=0.711756
    rd645 (\132\:U \133\:U) analogLib_presistor_schematic c=0 r=0.339854
    rd646 (\133\:U \134\:U) analogLib_presistor_schematic c=0 r=0.339397
    rd647 (\134\:U \135\:U) analogLib_presistor_schematic c=0 r=0.340312
    rd648 (\135\:U \136\:U) analogLib_presistor_schematic c=0 r=0.340312
    rd649 (\136\:U \137\:U) analogLib_presistor_schematic c=0 r=0.179544
    rd650 (\130\:U \118\:U) analogLib_presistor_schematic c=0 r=0.179215
    rd651 (\131\:U \27\:U) analogLib_presistor_schematic c=0 r=1.49097
    rd652 (\27\:U \50\:U) analogLib_presistor_schematic c=0 r=0.333359
    rd653 (\50\:U \16\:U) analogLib_presistor_schematic c=0 r=0.333359
    rd654 (\16\:U \67\:U) analogLib_presistor_schematic c=0 r=0.333359
    rd655 (\67\:U \90\:U) analogLib_presistor_schematic c=0 r=0.333359
    rd656 (\90\:U \143\:U) analogLib_presistor_schematic c=0 r=0.17776
    rd657 (\137\:U \117\:U) analogLib_presistor_schematic c=0 r=0.179215
    rd658 (\143\:U \116\:U) analogLib_presistor_schematic c=0 r=0.19961
    rd659 (U \13\:U) analogLib_presistor_schematic c=0 r=0.594
    rd660 (U \13\:U) analogLib_presistor_schematic c=0 r=0.594
    rd661 (U \13\:U) analogLib_presistor_schematic c=0 r=0.594
    rd662 (\532\:VDDA \913\:VDDA) analogLib_presistor_schematic c=0 \
        r=0.160744
    rd663 (\913\:VDDA \914\:VDDA) analogLib_presistor_schematic c=0 \
        r=0.059868
    rd664 (\914\:VDDA \915\:VDDA) analogLib_presistor_schematic c=0 \
        r=0.080234
    rd665 (\915\:VDDA \916\:VDDA) analogLib_presistor_schematic c=0 \
        r=0.140101
    rd666 (\916\:VDDA \917\:VDDA) analogLib_presistor_schematic c=0 \
        r=0.140101
    rd667 (\917\:VDDA \918\:VDDA) analogLib_presistor_schematic c=0 \
        r=0.08831
    rd668 (\918\:VDDA \919\:VDDA) analogLib_presistor_schematic c=0 \
        r=0.051792
    rd669 (\919\:VDDA \920\:VDDA) analogLib_presistor_schematic c=0 \
        r=0.140101
    rd670 (\920\:VDDA \921\:VDDA) analogLib_presistor_schematic c=0 \
        r=0.140101
    rd671 (\921\:VDDA \922\:VDDA) analogLib_presistor_schematic c=0 \
        r=0.140101
    rd672 (\922\:VDDA \923\:VDDA) analogLib_presistor_schematic c=0 \
        r=0.070402
    rd673 (\923\:VDDA \924\:VDDA) analogLib_presistor_schematic c=0 \
        r=0.0697
    rd674 (\924\:VDDA VDDA) analogLib_presistor_schematic c=0 r=0.079531
    rd1131 (\73\:S \277\:S) analogLib_presistor_schematic c=0 r=0.297
    rd1132 (\65\:S \278\:S) analogLib_presistor_schematic c=0 r=0.297
    rd827 (\468\:VDDA \671\:VDDA) analogLib_presistor_schematic c=0 \
        r=0.396
    rd829 (\413\:VDDA \673\:VDDA) analogLib_presistor_schematic c=0 \
        r=0.396
    rd831 (\378\:VDDA \675\:VDDA) analogLib_presistor_schematic c=0 \
        r=0.396
    rd833 (\343\:VDDA \677\:VDDA) analogLib_presistor_schematic c=0 \
        r=0.396
    rd835 (\308\:VDDA \679\:VDDA) analogLib_presistor_schematic c=0 \
        r=0.396
    rd837 (\273\:VDDA \681\:VDDA) analogLib_presistor_schematic c=0 \
        r=0.396
    rd839 (\238\:VDDA \683\:VDDA) analogLib_presistor_schematic c=0 \
        r=0.396
    rd841 (\203\:VDDA \685\:VDDA) analogLib_presistor_schematic c=0 \
        r=0.396
    rd843 (\168\:VDDA \687\:VDDA) analogLib_presistor_schematic c=0 \
        r=0.396
    rd1156 (\33\:S2 \96\:S2) analogLib_presistor_schematic c=0 r=0.594
    rd1159 (\17\:S2 \99\:S2) analogLib_presistor_schematic c=0 r=0.594
    rd1160 (\57\:S2 \101\:S2) analogLib_presistor_schematic c=0 r=0.594
    rd1162 (\37\:S2 \106\:S2) analogLib_presistor_schematic c=0 r=0.594
    rd1165 (\21\:S2 \109\:S2) analogLib_presistor_schematic c=0 r=0.594
    rd1166 (\55\:S2 \111\:S2) analogLib_presistor_schematic c=0 r=0.594
    rd1179 (\18\:BG_REF \140\:BG_REF) analogLib_presistor_schematic c=0 \
        r=0.297
    rd1187 (\14\:U \115\:U) analogLib_presistor_schematic c=0 r=0.396
    rd1193 (\33\:U \125\:U) analogLib_presistor_schematic c=0 r=0.2376
    rd1194 (\54\:U \126\:U) analogLib_presistor_schematic c=0 r=0.2376
    rd1195 (\4\:U \127\:U) analogLib_presistor_schematic c=0 r=0.2376
    rd1196 (\73\:U \128\:U) analogLib_presistor_schematic c=0 r=0.2376
    rd1197 (\95\:U \129\:U) analogLib_presistor_schematic c=0 r=0.2376
    rd1198 (\29\:U \132\:U) analogLib_presistor_schematic c=0 r=0.2376
    rd1199 (\52\:U \133\:U) analogLib_presistor_schematic c=0 r=0.2376
    rd1200 (\18\:U \134\:U) analogLib_presistor_schematic c=0 r=0.2376
    rd1201 (\69\:U \135\:U) analogLib_presistor_schematic c=0 r=0.2376
    rd1202 (\92\:U \136\:U) analogLib_presistor_schematic c=0 r=0.2376
    rd1209 (\614\:VDDA \913\:VDDA) analogLib_presistor_schematic c=0 \
        r=0.028286
    rd1210 (\610\:VDDA \915\:VDDA) analogLib_presistor_schematic c=0 \
        r=0.028286
    rd1211 (\608\:VDDA \916\:VDDA) analogLib_presistor_schematic c=0 \
        r=0.028286
    rd1212 (\606\:VDDA \917\:VDDA) analogLib_presistor_schematic c=0 \
        r=0.028286
    rd1213 (\604\:VDDA \919\:VDDA) analogLib_presistor_schematic c=0 \
        r=0.028286
    rd1214 (\601\:VDDA \920\:VDDA) analogLib_presistor_schematic c=0 \
        r=0.028286
    rd1215 (\599\:VDDA \921\:VDDA) analogLib_presistor_schematic c=0 \
        r=0.028286
    rd1216 (\597\:VDDA \922\:VDDA) analogLib_presistor_schematic c=0 \
        r=0.028286
    rd1217 (\594\:VDDA \924\:VDDA) analogLib_presistor_schematic c=0 \
        r=0.028286
    rd695 (\13\:Vo1 \52\:Vo1) analogLib_presistor_schematic c=0 r=0.056571
    rd702 (\944\:GNDA \1524\:GNDA) analogLib_presistor_schematic c=0 \
        r=0.396
    rd709 (\686\:GNDA \1533\:GNDA) analogLib_presistor_schematic c=0 \
        r=0.396
    rd1043 (\428\:VDDA \905\:VDDA) analogLib_presistor_schematic c=0 \
        r=0.02475
    rd1044 (\430\:VDDA \906\:VDDA) analogLib_presistor_schematic c=0 \
        r=0.018857
    rd1045 (\432\:VDDA \907\:VDDA) analogLib_presistor_schematic c=0 \
        r=0.018857
    rd1046 (\434\:VDDA \908\:VDDA) analogLib_presistor_schematic c=0 \
        r=0.018857
    rd1047 (\436\:VDDA \909\:VDDA) analogLib_presistor_schematic c=0 \
        r=0.018857
    rd1111 (\136\:S \255\:S) analogLib_presistor_schematic c=0 r=0.297
    rd1112 (\125\:S \256\:S) analogLib_presistor_schematic c=0 r=0.297
    rd1113 (\117\:S \257\:S) analogLib_presistor_schematic c=0 r=0.297
    rd1114 (\109\:S \258\:S) analogLib_presistor_schematic c=0 r=0.297
    rd1115 (\101\:S \259\:S) analogLib_presistor_schematic c=0 r=0.297
    rd1116 (\93\:S \260\:S) analogLib_presistor_schematic c=0 r=0.297
    rd1117 (\85\:S \261\:S) analogLib_presistor_schematic c=0 r=0.297
    rd1118 (\77\:S \262\:S) analogLib_presistor_schematic c=0 r=0.297
    rd1119 (\69\:S \263\:S) analogLib_presistor_schematic c=0 r=0.297
    rd1120 (\58\:S \264\:S) analogLib_presistor_schematic c=0 r=0.297
    rd1123 (\143\:S \269\:S) analogLib_presistor_schematic c=0 r=0.297
    rd818 (\418\:VDDA \659\:VDDA) analogLib_presistor_schematic c=0 \
        r=0.02475
    rd1124 (\129\:S \270\:S) analogLib_presistor_schematic c=0 r=0.297
    rd819 (\420\:VDDA \660\:VDDA) analogLib_presistor_schematic c=0 \
        r=0.018857
    rd1125 (\121\:S \271\:S) analogLib_presistor_schematic c=0 r=0.297
    rd820 (\422\:VDDA \662\:VDDA) analogLib_presistor_schematic c=0 \
        r=0.018857
    rd1126 (\113\:S \272\:S) analogLib_presistor_schematic c=0 r=0.297
    rd821 (\424\:VDDA \663\:VDDA) analogLib_presistor_schematic c=0 \
        r=0.018857
    rd1127 (\105\:S \273\:S) analogLib_presistor_schematic c=0 r=0.297
    rd822 (\426\:VDDA \664\:VDDA) analogLib_presistor_schematic c=0 \
        r=0.018857
    rd1128 (\97\:S \274\:S) analogLib_presistor_schematic c=0 r=0.297
    rd1129 (\89\:S \275\:S) analogLib_presistor_schematic c=0 r=0.297
    rd1130 (\81\:S \276\:S) analogLib_presistor_schematic c=0 r=0.297
    re1 (\9\:BG_REF \18\:BG_REF) analogLib_presistor_schematic c=0 \
        r=0.594528
    re2 (\18\:BG_REF \7\:BG_REF) analogLib_presistor_schematic c=0 \
        r=0.567624
    re3 (\7\:BG_REF \20\:BG_REF) analogLib_presistor_schematic c=0 \
        r=0.200528
    re4 (\20\:BG_REF \3\:BG_REF) analogLib_presistor_schematic c=0 \
        r=0.945136
    re5 (\3\:BG_REF \1\:BG_REF) analogLib_presistor_schematic c=0 \
        r=1.68844
    re6 (\69\:VDDA \70\:VDDA) analogLib_presistor_schematic c=0 r=7.425
    re7 (\71\:VDDA \72\:VDDA) analogLib_presistor_schematic c=0 r=7.425
    re8 (\73\:VDDA \74\:VDDA) analogLib_presistor_schematic c=0 r=7.425
    re9 (\75\:VDDA \76\:VDDA) analogLib_presistor_schematic c=0 r=7.425
    re10 (\77\:VDDA \78\:VDDA) analogLib_presistor_schematic c=0 r=7.425
    re11 (\79\:VDDA \80\:VDDA) analogLib_presistor_schematic c=0 r=7.425
    re12 (\81\:VDDA \82\:VDDA) analogLib_presistor_schematic c=0 r=7.425
    re13 (\83\:VDDA \84\:VDDA) analogLib_presistor_schematic c=0 r=7.425
    re14 (\85\:VDDA \86\:VDDA) analogLib_presistor_schematic c=0 r=10.8562
    re15 (\87\:VDDA \88\:VDDA) analogLib_presistor_schematic c=0 r=11.0578
    re16 (\89\:VDDA \90\:VDDA) analogLib_presistor_schematic c=0 r=11.0578
    re17 (\91\:VDDA \92\:VDDA) analogLib_presistor_schematic c=0 r=11.0578
    re18 (\93\:VDDA \94\:VDDA) analogLib_presistor_schematic c=0 r=11.0578
    re19 (\95\:VDDA \96\:VDDA) analogLib_presistor_schematic c=0 r=11.0578
    re20 (\97\:VDDA \98\:VDDA) analogLib_presistor_schematic c=0 r=11.0578
    re21 (\99\:VDDA \100\:VDDA) analogLib_presistor_schematic c=0 \
        r=10.8075
    re22 (\5\:Vo1 \11\:Vo1) analogLib_presistor_schematic c=0 r=2.8908
    re23 (\11\:Vo1 \12\:Vo1) analogLib_presistor_schematic c=0 r=0.030906
    re24 (\12\:Vo1 \13\:Vo1) analogLib_presistor_schematic c=0 r=0.917515
    re25 (\13\:Vo1 \14\:Vo1) analogLib_presistor_schematic c=0 r=0.28781
    re26 (\14\:Vo1 \9\:Vo1) analogLib_presistor_schematic c=0 r=2.44383
    re27 (\1\:VDDA \102\:VDDA) analogLib_presistor_schematic c=0 r=0.44926
    re28 (\3\:VDDA \104\:VDDA) analogLib_presistor_schematic c=0 r=0.44926
    re29 (\5\:VDDA \106\:VDDA) analogLib_presistor_schematic c=0 r=0.44926
    re30 (\7\:VDDA \108\:VDDA) analogLib_presistor_schematic c=0 r=0.44926
    re31 (\9\:VDDA \110\:VDDA) analogLib_presistor_schematic c=0 r=0.44926
    re32 (\11\:VDDA \112\:VDDA) analogLib_presistor_schematic c=0 \
        r=0.44926
    re33 (\13\:VDDA \114\:VDDA) analogLib_presistor_schematic c=0 \
        r=0.44926
    re34 (\15\:VDDA \116\:VDDA) analogLib_presistor_schematic c=0 \
        r=0.44926
    re35 (\117\:VDDA \118\:VDDA) analogLib_presistor_schematic c=0 \
        r=11.3043
    re36 (\119\:VDDA \120\:VDDA) analogLib_presistor_schematic c=0 \
        r=11.3043
    re37 (\121\:VDDA \122\:VDDA) analogLib_presistor_schematic c=0 \
        r=11.3043
    re38 (\123\:VDDA \124\:VDDA) analogLib_presistor_schematic c=0 \
        r=11.3043
    re39 (\125\:VDDA \126\:VDDA) analogLib_presistor_schematic c=0 \
        r=11.3043
    re40 (\127\:VDDA \128\:VDDA) analogLib_presistor_schematic c=0 \
        r=11.3043
    re41 (\129\:VDDA \130\:VDDA) analogLib_presistor_schematic c=0 \
        r=10.8075
    re42 (\131\:VDDA \132\:VDDA) analogLib_presistor_schematic c=0 \
        r=10.4498
    re43 (\132\:VDDA \133\:VDDA) analogLib_presistor_schematic c=0 \
        r=0.525359
    re44 (\132\:VDDA \134\:VDDA) analogLib_presistor_schematic c=0 \
        r=10.3255
    re45 (\135\:VDDA \136\:VDDA) analogLib_presistor_schematic c=0 \
        r=11.7121
    re46 (\23\:BG_REF \24\:BG_REF) analogLib_presistor_schematic c=0 \
        r=11.4001
    re47 (\25\:BG_REF \26\:BG_REF) analogLib_presistor_schematic c=0 \
        r=11.4001
    re48 (\27\:BG_REF \28\:BG_REF) analogLib_presistor_schematic c=0 \
        r=11.4001
    re49 (\29\:BG_REF \30\:BG_REF) analogLib_presistor_schematic c=0 \
        r=11.4001
    re50 (\31\:BG_REF \32\:BG_REF) analogLib_presistor_schematic c=0 \
        r=11.4001
    re51 (\33\:BG_REF \34\:BG_REF) analogLib_presistor_schematic c=0 \
        r=11.4001
    re52 (\137\:VDDA \138\:VDDA) analogLib_presistor_schematic c=0 r=7.722
    re53 (\139\:VDDA \140\:VDDA) analogLib_presistor_schematic c=0 r=7.722
    re54 (\141\:VDDA \142\:VDDA) analogLib_presistor_schematic c=0 r=7.722
    re55 (\143\:VDDA \144\:VDDA) analogLib_presistor_schematic c=0 r=7.722
    re56 (\145\:VDDA \146\:VDDA) analogLib_presistor_schematic c=0 r=7.722
    re57 (\147\:VDDA \148\:VDDA) analogLib_presistor_schematic c=0 r=7.722
    re58 (\17\:VDDA \150\:VDDA) analogLib_presistor_schematic c=0 \
        r=0.44926
    re59 (Vm1 \110\:Vm1) analogLib_presistor_schematic c=0 r=0.44926
    re60 (\3\:Vm1 \112\:Vm1) analogLib_presistor_schematic c=0 r=0.44926
    re61 (\5\:Vm1 \114\:Vm1) analogLib_presistor_schematic c=0 r=0.44926
    re62 (\7\:Vm1 \116\:Vm1) analogLib_presistor_schematic c=0 r=0.44926
    re63 (\9\:Vm1 \118\:Vm1) analogLib_presistor_schematic c=0 r=0.44926
    re64 (\11\:Vm1 \120\:Vm1) analogLib_presistor_schematic c=0 r=0.44926
    re65 (\19\:VDDA \152\:VDDA) analogLib_presistor_schematic c=0 \
        r=0.44926
    re66 (\153\:VDDA \154\:VDDA) analogLib_presistor_schematic c=0 \
        r=11.1517
    re67 (\155\:VDDA \156\:VDDA) analogLib_presistor_schematic c=0 \
        r=11.1517
    re68 (\157\:VDDA \158\:VDDA) analogLib_presistor_schematic c=0 \
        r=11.1517
    re69 (\159\:VDDA \160\:VDDA) analogLib_presistor_schematic c=0 \
        r=11.1517
    re70 (\161\:VDDA \162\:VDDA) analogLib_presistor_schematic c=0 \
        r=11.1517
    re71 (\163\:VDDA \164\:VDDA) analogLib_presistor_schematic c=0 \
        r=11.1517
    re72 (\165\:VDDA \166\:VDDA) analogLib_presistor_schematic c=0 \
        r=10.8075
    re73 (\167\:VDDA \168\:VDDA) analogLib_presistor_schematic c=0 \
        r=10.5521
    re74 (\168\:VDDA \169\:VDDA) analogLib_presistor_schematic c=0 \
        r=10.4935
    re75 (\170\:VDDA \171\:VDDA) analogLib_presistor_schematic c=0 \
        r=11.7121
    re76 (\35\:BG_REF \36\:BG_REF) analogLib_presistor_schematic c=0 \
        r=11.4001
    re77 (\9\:S \10\:S) analogLib_presistor_schematic c=0 r=11.6504
    re78 (\37\:BG_REF \38\:BG_REF) analogLib_presistor_schematic c=0 \
        r=11.4001
    re79 (\39\:BG_REF \40\:BG_REF) analogLib_presistor_schematic c=0 \
        r=11.4001
    re80 (\11\:S \12\:S) analogLib_presistor_schematic c=0 r=11.6504
    re81 (\41\:BG_REF \42\:BG_REF) analogLib_presistor_schematic c=0 \
        r=11.4001
    re82 (\172\:VDDA \173\:VDDA) analogLib_presistor_schematic c=0 r=7.722
    re83 (\174\:VDDA \175\:VDDA) analogLib_presistor_schematic c=0 r=7.722
    re84 (\176\:VDDA \177\:VDDA) analogLib_presistor_schematic c=0 r=7.722
    re85 (\178\:VDDA \179\:VDDA) analogLib_presistor_schematic c=0 r=7.722
    re86 (\180\:VDDA \181\:VDDA) analogLib_presistor_schematic c=0 r=7.722
    re87 (\182\:VDDA \183\:VDDA) analogLib_presistor_schematic c=0 r=7.722
    re88 (\21\:VDDA \185\:VDDA) analogLib_presistor_schematic c=0 \
        r=0.44926
    re89 (\13\:Vm1 \122\:Vm1) analogLib_presistor_schematic c=0 r=0.44926
    re90 (\15\:Vm1 \124\:Vm1) analogLib_presistor_schematic c=0 r=0.44926
    re91 (\17\:Vm1 \126\:Vm1) analogLib_presistor_schematic c=0 r=0.44926
    re92 (\19\:Vm1 \128\:Vm1) analogLib_presistor_schematic c=0 r=0.44926
    re93 (\21\:Vm1 \130\:Vm1) analogLib_presistor_schematic c=0 r=0.44926
    re94 (\23\:Vm1 \132\:Vm1) analogLib_presistor_schematic c=0 r=0.44926
    re95 (\23\:VDDA \187\:VDDA) analogLib_presistor_schematic c=0 \
        r=0.44926
    re96 (\188\:VDDA \189\:VDDA) analogLib_presistor_schematic c=0 \
        r=11.1517
    re97 (\190\:VDDA \191\:VDDA) analogLib_presistor_schematic c=0 \
        r=11.1517
    re98 (\192\:VDDA \193\:VDDA) analogLib_presistor_schematic c=0 \
        r=11.1517
    re99 (\194\:VDDA \195\:VDDA) analogLib_presistor_schematic c=0 \
        r=11.1517
    re100 (\196\:VDDA \197\:VDDA) analogLib_presistor_schematic c=0 \
        r=11.1517
    re101 (\198\:VDDA \199\:VDDA) analogLib_presistor_schematic c=0 \
        r=11.1517
    re102 (\200\:VDDA \201\:VDDA) analogLib_presistor_schematic c=0 \
        r=10.8075
    re103 (\202\:VDDA \203\:VDDA) analogLib_presistor_schematic c=0 \
        r=10.5521
    re104 (\203\:VDDA \204\:VDDA) analogLib_presistor_schematic c=0 \
        r=10.4935
    re105 (\205\:VDDA \206\:VDDA) analogLib_presistor_schematic c=0 \
        r=11.7121
    re106 (\43\:BG_REF \44\:BG_REF) analogLib_presistor_schematic c=0 \
        r=11.4001
    re107 (\13\:S \14\:S) analogLib_presistor_schematic c=0 r=11.6504
    re108 (\15\:S \16\:S) analogLib_presistor_schematic c=0 r=11.6504
    re109 (\17\:S \18\:S) analogLib_presistor_schematic c=0 r=11.6504
    re110 (\19\:S \20\:S) analogLib_presistor_schematic c=0 r=11.6504
    re111 (\45\:BG_REF \46\:BG_REF) analogLib_presistor_schematic c=0 \
        r=11.4001
    re112 (\207\:VDDA \208\:VDDA) analogLib_presistor_schematic c=0 \
        r=7.722
    re113 (\209\:VDDA \210\:VDDA) analogLib_presistor_schematic c=0 \
        r=7.722
    re114 (\211\:VDDA \212\:VDDA) analogLib_presistor_schematic c=0 \
        r=7.722
    re115 (\213\:VDDA \214\:VDDA) analogLib_presistor_schematic c=0 \
        r=7.722
    re116 (\215\:VDDA \216\:VDDA) analogLib_presistor_schematic c=0 \
        r=7.722
    re117 (\217\:VDDA \218\:VDDA) analogLib_presistor_schematic c=0 \
        r=7.722
    re118 (\25\:VDDA \220\:VDDA) analogLib_presistor_schematic c=0 \
        r=0.44926
    re119 (\25\:Vm1 \134\:Vm1) analogLib_presistor_schematic c=0 r=0.44926
    re120 (\27\:Vm1 \136\:Vm1) analogLib_presistor_schematic c=0 r=0.44926
    re121 (\29\:Vm1 \138\:Vm1) analogLib_presistor_schematic c=0 r=0.44926
    re122 (\31\:Vm1 \140\:Vm1) analogLib_presistor_schematic c=0 r=0.44926
    re123 (\33\:Vm1 \142\:Vm1) analogLib_presistor_schematic c=0 r=0.44926
    re124 (\35\:Vm1 \144\:Vm1) analogLib_presistor_schematic c=0 r=0.44926
    re125 (\27\:VDDA \222\:VDDA) analogLib_presistor_schematic c=0 \
        r=0.44926
    re126 (\223\:VDDA \224\:VDDA) analogLib_presistor_schematic c=0 \
        r=11.1497
    re127 (\225\:VDDA \226\:VDDA) analogLib_presistor_schematic c=0 \
        r=11.1497
    re128 (\227\:VDDA \228\:VDDA) analogLib_presistor_schematic c=0 \
        r=11.1497
    re129 (\229\:VDDA \230\:VDDA) analogLib_presistor_schematic c=0 \
        r=11.1497
    re130 (\231\:VDDA \232\:VDDA) analogLib_presistor_schematic c=0 \
        r=11.1497
    re131 (\233\:VDDA \234\:VDDA) analogLib_presistor_schematic c=0 \
        r=11.1497
    re132 (\235\:VDDA \236\:VDDA) analogLib_presistor_schematic c=0 \
        r=10.8075
    re133 (\237\:VDDA \238\:VDDA) analogLib_presistor_schematic c=0 \
        r=10.5521
    re134 (\238\:VDDA \239\:VDDA) analogLib_presistor_schematic c=0 \
        r=10.4935
    re135 (\145\:Vm1 \146\:Vm1) analogLib_presistor_schematic c=0 \
        r=11.6135
    re136 (\240\:VDDA \241\:VDDA) analogLib_presistor_schematic c=0 \
        r=11.7121
    re137 (\47\:BG_REF \48\:BG_REF) analogLib_presistor_schematic c=0 \
        r=11.4001
    re138 (\21\:S \22\:S) analogLib_presistor_schematic c=0 r=11.6504
    re139 (\23\:S \24\:S) analogLib_presistor_schematic c=0 r=11.6504
    re140 (\25\:S \26\:S) analogLib_presistor_schematic c=0 r=11.6504
    re141 (\49\:BG_REF \50\:BG_REF) analogLib_presistor_schematic c=0 \
        r=11.4001
    re142 (\117\:GNDA \118\:GNDA) analogLib_presistor_schematic c=0 \
        r=3.57024
    re143 (\119\:GNDA \120\:GNDA) analogLib_presistor_schematic c=0 \
        r=3.57024
    re144 (\242\:VDDA \243\:VDDA) analogLib_presistor_schematic c=0 \
        r=7.722
    re145 (\244\:VDDA \245\:VDDA) analogLib_presistor_schematic c=0 \
        r=7.722
    re146 (\246\:VDDA \247\:VDDA) analogLib_presistor_schematic c=0 \
        r=7.722
    re147 (\248\:VDDA \249\:VDDA) analogLib_presistor_schematic c=0 \
        r=7.722
    re148 (\250\:VDDA \251\:VDDA) analogLib_presistor_schematic c=0 \
        r=7.722
    re149 (\252\:VDDA \253\:VDDA) analogLib_presistor_schematic c=0 \
        r=7.722
    re150 (\29\:VDDA \255\:VDDA) analogLib_presistor_schematic c=0 \
        r=0.44926
    re151 (\37\:Vm1 \148\:Vm1) analogLib_presistor_schematic c=0 r=0.44926
    re152 (\39\:Vm1 \150\:Vm1) analogLib_presistor_schematic c=0 r=0.44926
    re153 (\41\:Vm1 \152\:Vm1) analogLib_presistor_schematic c=0 r=0.44926
    re154 (\43\:Vm1 \154\:Vm1) analogLib_presistor_schematic c=0 r=0.44926
    re155 (\45\:Vm1 \156\:Vm1) analogLib_presistor_schematic c=0 r=0.44926
    re156 (\47\:Vm1 \158\:Vm1) analogLib_presistor_schematic c=0 r=0.44926
    re157 (\31\:VDDA \257\:VDDA) analogLib_presistor_schematic c=0 \
        r=0.44926
    re158 (\258\:VDDA \259\:VDDA) analogLib_presistor_schematic c=0 \
        r=11.1517
    re159 (\260\:VDDA \261\:VDDA) analogLib_presistor_schematic c=0 \
        r=11.1517
    re160 (\262\:VDDA \263\:VDDA) analogLib_presistor_schematic c=0 \
        r=11.1517
    re161 (\264\:VDDA \265\:VDDA) analogLib_presistor_schematic c=0 \
        r=11.1517
    re162 (\266\:VDDA \267\:VDDA) analogLib_presistor_schematic c=0 \
        r=11.1517
    re163 (\268\:VDDA \269\:VDDA) analogLib_presistor_schematic c=0 \
        r=11.1517
    re164 (\270\:VDDA \271\:VDDA) analogLib_presistor_schematic c=0 \
        r=10.8075
    re165 (\272\:VDDA \273\:VDDA) analogLib_presistor_schematic c=0 \
        r=10.5521
    re166 (\273\:VDDA \274\:VDDA) analogLib_presistor_schematic c=0 \
        r=10.4935
    re167 (\121\:GNDA \122\:GNDA) analogLib_presistor_schematic c=0 \
        r=6.0588
    re168 (\123\:GNDA \124\:GNDA) analogLib_presistor_schematic c=0 \
        r=6.0588
    re169 (\7\:D1 \2\:D1) analogLib_presistor_schematic c=0 r=0.569217
    re170 (\275\:VDDA \276\:VDDA) analogLib_presistor_schematic c=0 \
        r=11.7121
    re171 (\51\:BG_REF \52\:BG_REF) analogLib_presistor_schematic c=0 \
        r=11.4001
    re172 (\27\:S \28\:S) analogLib_presistor_schematic c=0 r=11.6504
    re173 (\9\:S2 \10\:S2) analogLib_presistor_schematic c=0 r=11.9008
    re174 (\7\:vv \8\:vv) analogLib_presistor_schematic c=0 r=12.1511
    re175 (\29\:S \30\:S) analogLib_presistor_schematic c=0 r=11.6504
    re176 (\53\:BG_REF \54\:BG_REF) analogLib_presistor_schematic c=0 \
        r=11.4001
    re177 (\16\:Vo1 \17\:Vo1) analogLib_presistor_schematic c=0 r=4.32523
    re178 (\9\:D1 \10\:D1) analogLib_presistor_schematic c=0 r=4.32523
    re179 (\125\:GNDA \126\:GNDA) analogLib_presistor_schematic c=0 \
        r=3.57024
    re180 (\127\:GNDA \128\:GNDA) analogLib_presistor_schematic c=0 \
        r=3.57024
    re181 (\277\:VDDA \278\:VDDA) analogLib_presistor_schematic c=0 \
        r=7.722
    re182 (\279\:VDDA \280\:VDDA) analogLib_presistor_schematic c=0 \
        r=7.722
    re183 (\281\:VDDA \282\:VDDA) analogLib_presistor_schematic c=0 \
        r=7.722
    re184 (\283\:VDDA \284\:VDDA) analogLib_presistor_schematic c=0 \
        r=7.722
    re185 (\285\:VDDA \286\:VDDA) analogLib_presistor_schematic c=0 \
        r=7.722
    re186 (\287\:VDDA \288\:VDDA) analogLib_presistor_schematic c=0 \
        r=7.722
    re187 (\33\:VDDA \290\:VDDA) analogLib_presistor_schematic c=0 \
        r=0.44926
    re188 (\49\:Vm1 \160\:Vm1) analogLib_presistor_schematic c=0 r=0.44926
    re189 (\51\:Vm1 \162\:Vm1) analogLib_presistor_schematic c=0 r=0.44926
    re190 (\53\:Vm1 \164\:Vm1) analogLib_presistor_schematic c=0 r=0.44926
    re191 (\55\:Vm1 \166\:Vm1) analogLib_presistor_schematic c=0 r=0.44926
    re192 (\57\:Vm1 \168\:Vm1) analogLib_presistor_schematic c=0 r=0.44926
    re193 (\59\:Vm1 \170\:Vm1) analogLib_presistor_schematic c=0 r=0.44926
    re194 (\35\:VDDA \292\:VDDA) analogLib_presistor_schematic c=0 \
        r=0.44926
    re195 (\293\:VDDA \294\:VDDA) analogLib_presistor_schematic c=0 \
        r=11.1536
    re196 (\295\:VDDA \296\:VDDA) analogLib_presistor_schematic c=0 \
        r=11.1536
    re197 (\297\:VDDA \298\:VDDA) analogLib_presistor_schematic c=0 \
        r=11.1536
    re198 (\299\:VDDA \300\:VDDA) analogLib_presistor_schematic c=0 \
        r=11.1536
    re199 (\301\:VDDA \302\:VDDA) analogLib_presistor_schematic c=0 \
        r=11.1536
    re200 (\303\:VDDA \304\:VDDA) analogLib_presistor_schematic c=0 \
        r=11.1536
    re201 (\305\:VDDA \306\:VDDA) analogLib_presistor_schematic c=0 \
        r=10.8075
    re202 (\307\:VDDA \308\:VDDA) analogLib_presistor_schematic c=0 \
        r=10.5521
    re203 (\308\:VDDA \309\:VDDA) analogLib_presistor_schematic c=0 \
        r=10.4935
    re204 (\171\:Vm1 \172\:Vm1) analogLib_presistor_schematic c=0 \
        r=11.6135
    re205 (\11\:D1 \5\:D1) analogLib_presistor_schematic c=0 r=0.569217
    re206 (\129\:GNDA \130\:GNDA) analogLib_presistor_schematic c=0 \
        r=6.0588
    re207 (\131\:GNDA \132\:GNDA) analogLib_presistor_schematic c=0 \
        r=6.0588
    re208 (\310\:VDDA \311\:VDDA) analogLib_presistor_schematic c=0 \
        r=11.7121
    re209 (\55\:BG_REF \56\:BG_REF) analogLib_presistor_schematic c=0 \
        r=11.4001
    re210 (\31\:S \32\:S) analogLib_presistor_schematic c=0 r=11.6504
    re211 (\33\:S \34\:S) analogLib_presistor_schematic c=0 r=11.6504
    re212 (\35\:S \36\:S) analogLib_presistor_schematic c=0 r=11.6504
    re213 (\57\:BG_REF \58\:BG_REF) analogLib_presistor_schematic c=0 \
        r=11.4001
    re214 (\13\:D1 \14\:D1) analogLib_presistor_schematic c=0 r=3.94774
    re215 (\18\:Vo1 \19\:Vo1) analogLib_presistor_schematic c=0 r=3.94774
    re216 (\312\:VDDA \313\:VDDA) analogLib_presistor_schematic c=0 \
        r=7.722
    re217 (\314\:VDDA \315\:VDDA) analogLib_presistor_schematic c=0 \
        r=7.722
    re218 (\316\:VDDA \317\:VDDA) analogLib_presistor_schematic c=0 \
        r=7.722
    re219 (\318\:VDDA \319\:VDDA) analogLib_presistor_schematic c=0 \
        r=7.722
    re220 (\320\:VDDA \321\:VDDA) analogLib_presistor_schematic c=0 \
        r=7.722
    re221 (\322\:VDDA \323\:VDDA) analogLib_presistor_schematic c=0 \
        r=7.722
    re222 (\37\:VDDA \325\:VDDA) analogLib_presistor_schematic c=0 \
        r=0.44926
    re223 (\61\:Vm1 \174\:Vm1) analogLib_presistor_schematic c=0 r=0.44926
    re224 (\63\:Vm1 \176\:Vm1) analogLib_presistor_schematic c=0 r=0.44926
    re225 (\65\:Vm1 \178\:Vm1) analogLib_presistor_schematic c=0 r=0.44926
    re226 (\67\:Vm1 \180\:Vm1) analogLib_presistor_schematic c=0 r=0.44926
    re227 (\69\:Vm1 \182\:Vm1) analogLib_presistor_schematic c=0 r=0.44926
    re228 (\71\:Vm1 \184\:Vm1) analogLib_presistor_schematic c=0 r=0.44926
    re229 (\39\:VDDA \327\:VDDA) analogLib_presistor_schematic c=0 \
        r=0.44926
    re230 (\328\:VDDA \329\:VDDA) analogLib_presistor_schematic c=0 \
        r=11.1517
    re231 (\330\:VDDA \331\:VDDA) analogLib_presistor_schematic c=0 \
        r=11.1517
    re232 (\332\:VDDA \333\:VDDA) analogLib_presistor_schematic c=0 \
        r=11.1517
    re233 (\334\:VDDA \335\:VDDA) analogLib_presistor_schematic c=0 \
        r=11.1517
    re234 (\336\:VDDA \337\:VDDA) analogLib_presistor_schematic c=0 \
        r=11.1517
    re235 (\338\:VDDA \339\:VDDA) analogLib_presistor_schematic c=0 \
        r=11.1517
    re236 (\340\:VDDA \341\:VDDA) analogLib_presistor_schematic c=0 \
        r=10.8075
    re237 (\342\:VDDA \343\:VDDA) analogLib_presistor_schematic c=0 \
        r=10.5521
    re238 (\343\:VDDA \344\:VDDA) analogLib_presistor_schematic c=0 \
        r=10.4935
    re239 (\345\:VDDA \346\:VDDA) analogLib_presistor_schematic c=0 \
        r=11.7121
    re240 (\59\:BG_REF \60\:BG_REF) analogLib_presistor_schematic c=0 \
        r=11.4001
    re241 (\37\:S \38\:S) analogLib_presistor_schematic c=0 r=11.6504
    re242 (\39\:S \40\:S) analogLib_presistor_schematic c=0 r=11.6504
    re243 (\41\:S \42\:S) analogLib_presistor_schematic c=0 r=11.6504
    re244 (\43\:S \44\:S) analogLib_presistor_schematic c=0 r=11.6504
    re245 (\61\:BG_REF \62\:BG_REF) analogLib_presistor_schematic c=0 \
        r=11.4001
    re246 (\347\:VDDA \348\:VDDA) analogLib_presistor_schematic c=0 \
        r=7.722
    re247 (\349\:VDDA \350\:VDDA) analogLib_presistor_schematic c=0 \
        r=7.722
    re248 (\351\:VDDA \352\:VDDA) analogLib_presistor_schematic c=0 \
        r=7.722
    re249 (\353\:VDDA \354\:VDDA) analogLib_presistor_schematic c=0 \
        r=7.722
    re250 (\355\:VDDA \356\:VDDA) analogLib_presistor_schematic c=0 \
        r=7.722
    re251 (\357\:VDDA \358\:VDDA) analogLib_presistor_schematic c=0 \
        r=7.722
    re252 (\41\:VDDA \360\:VDDA) analogLib_presistor_schematic c=0 \
        r=0.44926
    re253 (\73\:Vm1 \186\:Vm1) analogLib_presistor_schematic c=0 r=0.44926
    re254 (\75\:Vm1 \188\:Vm1) analogLib_presistor_schematic c=0 r=0.44926
    re255 (\77\:Vm1 \190\:Vm1) analogLib_presistor_schematic c=0 r=0.44926
    re256 (\79\:Vm1 \192\:Vm1) analogLib_presistor_schematic c=0 r=0.44926
    re257 (\81\:Vm1 \194\:Vm1) analogLib_presistor_schematic c=0 r=0.44926
    re258 (\83\:Vm1 \196\:Vm1) analogLib_presistor_schematic c=0 r=0.44926
    re259 (\43\:VDDA \362\:VDDA) analogLib_presistor_schematic c=0 \
        r=0.44926
    re260 (\363\:VDDA \364\:VDDA) analogLib_presistor_schematic c=0 \
        r=11.1517
    re261 (\365\:VDDA \366\:VDDA) analogLib_presistor_schematic c=0 \
        r=11.1517
    re262 (\367\:VDDA \368\:VDDA) analogLib_presistor_schematic c=0 \
        r=11.1517
    re263 (\369\:VDDA \370\:VDDA) analogLib_presistor_schematic c=0 \
        r=11.1517
    re264 (\371\:VDDA \372\:VDDA) analogLib_presistor_schematic c=0 \
        r=11.1517
    re265 (\373\:VDDA \374\:VDDA) analogLib_presistor_schematic c=0 \
        r=11.1517
    re266 (\375\:VDDA \376\:VDDA) analogLib_presistor_schematic c=0 \
        r=10.8075
    re267 (\377\:VDDA \378\:VDDA) analogLib_presistor_schematic c=0 \
        r=10.5521
    re268 (\378\:VDDA \379\:VDDA) analogLib_presistor_schematic c=0 \
        r=10.4935
    re269 (\380\:VDDA \381\:VDDA) analogLib_presistor_schematic c=0 \
        r=11.7121
    re270 (\63\:BG_REF \64\:BG_REF) analogLib_presistor_schematic c=0 \
        r=11.4001
    re271 (\45\:S \46\:S) analogLib_presistor_schematic c=0 r=11.6504
    re272 (\65\:BG_REF \66\:BG_REF) analogLib_presistor_schematic c=0 \
        r=11.4001
    re273 (\67\:BG_REF \68\:BG_REF) analogLib_presistor_schematic c=0 \
        r=11.4001
    re274 (\47\:S \48\:S) analogLib_presistor_schematic c=0 r=11.6504
    re275 (\69\:BG_REF \70\:BG_REF) analogLib_presistor_schematic c=0 \
        r=11.4001
    re276 (\382\:VDDA \383\:VDDA) analogLib_presistor_schematic c=0 \
        r=7.722
    re277 (\384\:VDDA \385\:VDDA) analogLib_presistor_schematic c=0 \
        r=7.722
    re278 (\386\:VDDA \387\:VDDA) analogLib_presistor_schematic c=0 \
        r=7.722
    re279 (\388\:VDDA \389\:VDDA) analogLib_presistor_schematic c=0 \
        r=7.722
    re280 (\390\:VDDA \391\:VDDA) analogLib_presistor_schematic c=0 \
        r=7.722
    re281 (\392\:VDDA \393\:VDDA) analogLib_presistor_schematic c=0 \
        r=7.722
    re282 (\49\:S \50\:S) analogLib_presistor_schematic c=0 r=5.22815
    re283 (\50\:S \49\:S) analogLib_presistor_schematic c=0 r=0.747849
    re284 (\51\:S \52\:S) analogLib_presistor_schematic c=0 r=5.22815
    re285 (\52\:S \51\:S) analogLib_presistor_schematic c=0 r=0.747849
    re286 (\45\:VDDA \395\:VDDA) analogLib_presistor_schematic c=0 \
        r=0.44926
    re287 (\85\:Vm1 \198\:Vm1) analogLib_presistor_schematic c=0 r=0.44926
    re288 (\87\:Vm1 \200\:Vm1) analogLib_presistor_schematic c=0 r=0.44926
    re289 (\89\:Vm1 \202\:Vm1) analogLib_presistor_schematic c=0 r=0.44926
    re290 (\91\:Vm1 \204\:Vm1) analogLib_presistor_schematic c=0 r=0.44926
    re291 (\93\:Vm1 \206\:Vm1) analogLib_presistor_schematic c=0 r=0.44926
    re292 (\95\:Vm1 \208\:Vm1) analogLib_presistor_schematic c=0 r=0.44926
    re293 (\47\:VDDA \397\:VDDA) analogLib_presistor_schematic c=0 \
        r=0.44926
    re294 (\398\:VDDA \399\:VDDA) analogLib_presistor_schematic c=0 \
        r=11.1497
    re295 (\400\:VDDA \401\:VDDA) analogLib_presistor_schematic c=0 \
        r=11.1497
    re296 (\402\:VDDA \403\:VDDA) analogLib_presistor_schematic c=0 \
        r=11.1497
    re297 (\404\:VDDA \405\:VDDA) analogLib_presistor_schematic c=0 \
        r=11.1497
    re298 (\406\:VDDA \407\:VDDA) analogLib_presistor_schematic c=0 \
        r=11.1497
    re299 (\408\:VDDA \409\:VDDA) analogLib_presistor_schematic c=0 \
        r=11.1497
    re300 (\410\:VDDA \411\:VDDA) analogLib_presistor_schematic c=0 \
        r=10.8075
    re301 (\412\:VDDA \413\:VDDA) analogLib_presistor_schematic c=0 \
        r=10.5521
    re302 (\413\:VDDA \414\:VDDA) analogLib_presistor_schematic c=0 \
        r=10.4935
    re303 (\415\:VDDA \416\:VDDA) analogLib_presistor_schematic c=0 \
        r=11.7121
    re304 (\71\:BG_REF \72\:BG_REF) analogLib_presistor_schematic c=0 \
        r=11.4001
    re305 (\73\:BG_REF \74\:BG_REF) analogLib_presistor_schematic c=0 \
        r=11.4001
    re306 (\75\:BG_REF \76\:BG_REF) analogLib_presistor_schematic c=0 \
        r=11.4001
    re307 (\77\:BG_REF \78\:BG_REF) analogLib_presistor_schematic c=0 \
        r=11.4001
    re308 (\79\:BG_REF \80\:BG_REF) analogLib_presistor_schematic c=0 \
        r=11.4001
    re309 (\81\:BG_REF \82\:BG_REF) analogLib_presistor_schematic c=0 \
        r=11.4001
    re310 (\54\:S \55\:S) analogLib_presistor_schematic c=0 r=0.736538
    re311 (\55\:S \57\:S) analogLib_presistor_schematic c=0 r=0.736538
    re312 (\57\:S \56\:S) analogLib_presistor_schematic c=0 r=4.20182
    re313 (\54\:S \53\:S) analogLib_presistor_schematic c=0 r=4.20182
    re314 (\55\:S \58\:S) analogLib_presistor_schematic c=0 r=0.099166
    re315 (\58\:S S) analogLib_presistor_schematic c=0 r=0.198
    re316 (\53\:S \54\:S) analogLib_presistor_schematic c=0 r=5.4
    re317 (\56\:S \57\:S) analogLib_presistor_schematic c=0 r=5.4
    re318 (\60\:S \61\:S) analogLib_presistor_schematic c=0 r=6.63182
    re319 (\61\:S \62\:S) analogLib_presistor_schematic c=0 r=1.09416
    re320 (\62\:S \64\:S) analogLib_presistor_schematic c=0 r=1.09416
    re321 (\62\:S \65\:S) analogLib_presistor_schematic c=0 r=0.099166
    re322 (\65\:S \3\:S) analogLib_presistor_schematic c=0 r=0.198
    re323 (\64\:S \63\:S) analogLib_presistor_schematic c=0 r=6.63182
    re324 (\60\:S \61\:S) analogLib_presistor_schematic c=0 r=2.97
    re325 (\63\:S \64\:S) analogLib_presistor_schematic c=0 r=2.97
    re326 (\417\:VDDA \418\:VDDA) analogLib_presistor_schematic c=0 \
        r=0.550497
    re327 (\418\:VDDA \419\:VDDA) analogLib_presistor_schematic c=0 \
        r=0.375008
    re328 (\419\:VDDA \420\:VDDA) analogLib_presistor_schematic c=0 \
        r=0.011417
    re329 (\420\:VDDA \421\:VDDA) analogLib_presistor_schematic c=0 \
        r=0.233665
    re330 (\421\:VDDA \422\:VDDA) analogLib_presistor_schematic c=0 \
        r=0.04016
    re331 (\422\:VDDA \423\:VDDA) analogLib_presistor_schematic c=0 \
        r=0.083489
    re332 (\423\:VDDA \424\:VDDA) analogLib_presistor_schematic c=0 \
        r=0.100551
    re333 (\424\:VDDA \425\:VDDA) analogLib_presistor_schematic c=0 \
        r=0.032801
    re334 (\425\:VDDA \426\:VDDA) analogLib_presistor_schematic c=0 \
        r=0.308878
    re335 (\426\:VDDA \417\:VDDA) analogLib_presistor_schematic c=0 \
        r=0.502466
    re336 (\417\:VDDA \419\:VDDA) analogLib_presistor_schematic c=0 \
        r=0.495
    re337 (\417\:VDDA \421\:VDDA) analogLib_presistor_schematic c=0 \
        r=0.495
    re338 (\417\:VDDA \423\:VDDA) analogLib_presistor_schematic c=0 \
        r=0.495
    re339 (\417\:VDDA \425\:VDDA) analogLib_presistor_schematic c=0 \
        r=0.495
    re340 (\427\:VDDA \428\:VDDA) analogLib_presistor_schematic c=0 \
        r=0.550497
    re341 (\428\:VDDA \429\:VDDA) analogLib_presistor_schematic c=0 \
        r=0.375008
    re342 (\429\:VDDA \430\:VDDA) analogLib_presistor_schematic c=0 \
        r=0.011417
    re343 (\430\:VDDA \431\:VDDA) analogLib_presistor_schematic c=0 \
        r=0.233665
    re344 (\431\:VDDA \432\:VDDA) analogLib_presistor_schematic c=0 \
        r=0.04016
    re345 (\432\:VDDA \433\:VDDA) analogLib_presistor_schematic c=0 \
        r=0.083489
    re346 (\433\:VDDA \434\:VDDA) analogLib_presistor_schematic c=0 \
        r=0.100551
    re347 (\434\:VDDA \435\:VDDA) analogLib_presistor_schematic c=0 \
        r=0.032801
    re348 (\435\:VDDA \436\:VDDA) analogLib_presistor_schematic c=0 \
        r=0.308878
    re349 (\436\:VDDA \427\:VDDA) analogLib_presistor_schematic c=0 \
        r=0.502466
    re350 (\427\:VDDA \429\:VDDA) analogLib_presistor_schematic c=0 \
        r=0.495
    re351 (\427\:VDDA \431\:VDDA) analogLib_presistor_schematic c=0 \
        r=0.495
    re352 (\427\:VDDA \433\:VDDA) analogLib_presistor_schematic c=0 \
        r=0.495
    re353 (\427\:VDDA \435\:VDDA) analogLib_presistor_schematic c=0 \
        r=0.495
    re354 (\21\:Vo1 \20\:Vo1) analogLib_presistor_schematic c=0 r=4.20182
    re355 (\21\:Vo1 \22\:Vo1) analogLib_presistor_schematic c=0 r=1.24235
    re356 (\20\:Vo1 \21\:Vo1) analogLib_presistor_schematic c=0 r=5.4
    re357 (\15\:D1 \16\:D1) analogLib_presistor_schematic c=0 r=6.63182
    re358 (\16\:D1 \17\:D1) analogLib_presistor_schematic c=0 r=1.59997
    re359 (\15\:D1 \16\:D1) analogLib_presistor_schematic c=0 r=2.97
    re360 (\437\:VDDA \438\:VDDA) analogLib_presistor_schematic c=0 \
        r=7.722
    re361 (\439\:VDDA \440\:VDDA) analogLib_presistor_schematic c=0 \
        r=7.722
    re362 (\441\:VDDA \442\:VDDA) analogLib_presistor_schematic c=0 \
        r=7.722
    re363 (\443\:VDDA \444\:VDDA) analogLib_presistor_schematic c=0 \
        r=7.722
    re364 (\445\:VDDA \446\:VDDA) analogLib_presistor_schematic c=0 \
        r=7.722
    re365 (\447\:VDDA \448\:VDDA) analogLib_presistor_schematic c=0 \
        r=7.722
    re366 (\49\:VDDA \450\:VDDA) analogLib_presistor_schematic c=0 \
        r=0.44926
    re367 (\97\:Vm1 \210\:Vm1) analogLib_presistor_schematic c=0 r=0.44926
    re368 (\99\:Vm1 \212\:Vm1) analogLib_presistor_schematic c=0 r=0.44926
    re369 (\101\:Vm1 \214\:Vm1) analogLib_presistor_schematic c=0 \
        r=0.44926
    re370 (\103\:Vm1 \216\:Vm1) analogLib_presistor_schematic c=0 \
        r=0.44926
    re371 (\105\:Vm1 \218\:Vm1) analogLib_presistor_schematic c=0 \
        r=0.44926
    re372 (\107\:Vm1 \220\:Vm1) analogLib_presistor_schematic c=0 \
        r=0.44926
    re373 (\51\:VDDA \452\:VDDA) analogLib_presistor_schematic c=0 \
        r=0.44926
    re374 (\68\:S \69\:S) analogLib_presistor_schematic c=0 r=0.653161
    re375 (\69\:S \70\:S) analogLib_presistor_schematic c=0 r=7.51266
    re376 (\68\:S \67\:S) analogLib_presistor_schematic c=0 r=4.20182
    re377 (\67\:S \68\:S) analogLib_presistor_schematic c=0 r=5.4
    re378 (\71\:S \72\:S) analogLib_presistor_schematic c=0 r=6.63182
    re379 (\72\:S \73\:S) analogLib_presistor_schematic c=0 r=1.01154
    re380 (\73\:S \74\:S) analogLib_presistor_schematic c=0 r=7.51362
    re381 (\71\:S \72\:S) analogLib_presistor_schematic c=0 r=2.97
    re382 (\19\:D1 \18\:D1) analogLib_presistor_schematic c=0 r=4.20182
    re383 (\19\:D1 \20\:D1) analogLib_presistor_schematic c=0 r=1.5205
    re384 (\18\:D1 \19\:D1) analogLib_presistor_schematic c=0 r=5.4
    re385 (\23\:Vo1 \24\:Vo1) analogLib_presistor_schematic c=0 r=6.63182
    re386 (\24\:Vo1 \25\:Vo1) analogLib_presistor_schematic c=0 r=1.87812
    re387 (\23\:Vo1 \24\:Vo1) analogLib_presistor_schematic c=0 r=2.97
    re388 (\453\:VDDA \454\:VDDA) analogLib_presistor_schematic c=0 \
        r=11.1517
    re389 (\455\:VDDA \456\:VDDA) analogLib_presistor_schematic c=0 \
        r=11.1517
    re390 (\457\:VDDA \458\:VDDA) analogLib_presistor_schematic c=0 \
        r=11.1517
    re391 (\459\:VDDA \460\:VDDA) analogLib_presistor_schematic c=0 \
        r=11.1517
    re392 (\461\:VDDA \462\:VDDA) analogLib_presistor_schematic c=0 \
        r=11.1517
    re393 (\463\:VDDA \464\:VDDA) analogLib_presistor_schematic c=0 \
        r=11.1517
    re394 (\465\:VDDA \466\:VDDA) analogLib_presistor_schematic c=0 \
        r=10.8075
    re395 (\467\:VDDA \468\:VDDA) analogLib_presistor_schematic c=0 \
        r=10.5521
    re396 (\468\:VDDA \469\:VDDA) analogLib_presistor_schematic c=0 \
        r=10.4935
    re397 (\470\:VDDA \471\:VDDA) analogLib_presistor_schematic c=0 \
        r=11.7121
    re398 (\472\:VDDA \473\:VDDA) analogLib_presistor_schematic c=0 \
        r=11.311
    re399 (\474\:VDDA \475\:VDDA) analogLib_presistor_schematic c=0 \
        r=11.311
    re400 (\476\:VDDA \477\:VDDA) analogLib_presistor_schematic c=0 \
        r=11.311
    re401 (\478\:VDDA \479\:VDDA) analogLib_presistor_schematic c=0 \
        r=11.311
    re402 (\480\:VDDA \481\:VDDA) analogLib_presistor_schematic c=0 \
        r=11.311
    re403 (\482\:VDDA \483\:VDDA) analogLib_presistor_schematic c=0 \
        r=11.311
    re404 (\76\:S \77\:S) analogLib_presistor_schematic c=0 r=0.653161
    re405 (\77\:S \78\:S) analogLib_presistor_schematic c=0 r=7.51853
    re406 (\76\:S \75\:S) analogLib_presistor_schematic c=0 r=4.20182
    re407 (\75\:S \76\:S) analogLib_presistor_schematic c=0 r=5.4
    re408 (\79\:S \80\:S) analogLib_presistor_schematic c=0 r=6.63182
    re409 (\80\:S \81\:S) analogLib_presistor_schematic c=0 r=1.01154
    re410 (\81\:S \82\:S) analogLib_presistor_schematic c=0 r=7.5195
    re411 (\79\:S \80\:S) analogLib_presistor_schematic c=0 r=2.97
    re412 (\27\:Vo1 \26\:Vo1) analogLib_presistor_schematic c=0 r=4.20182
    re413 (\27\:Vo1 \28\:Vo1) analogLib_presistor_schematic c=0 r=1.24235
    re414 (\26\:Vo1 \27\:Vo1) analogLib_presistor_schematic c=0 r=5.4
    re415 (\21\:D1 \22\:D1) analogLib_presistor_schematic c=0 r=6.63182
    re416 (\22\:D1 \23\:D1) analogLib_presistor_schematic c=0 r=1.59997
    re417 (\21\:D1 \22\:D1) analogLib_presistor_schematic c=0 r=2.97
    re418 (\53\:VDDA \485\:VDDA) analogLib_presistor_schematic c=0 \
        r=0.44926
    re419 (\55\:VDDA \487\:VDDA) analogLib_presistor_schematic c=0 \
        r=0.44926
    re420 (\57\:VDDA \489\:VDDA) analogLib_presistor_schematic c=0 \
        r=0.44926
    re421 (\59\:VDDA \491\:VDDA) analogLib_presistor_schematic c=0 \
        r=0.44926
    re422 (\61\:VDDA \493\:VDDA) analogLib_presistor_schematic c=0 \
        r=0.44926
    re423 (\63\:VDDA \495\:VDDA) analogLib_presistor_schematic c=0 \
        r=0.44926
    re424 (\65\:VDDA \497\:VDDA) analogLib_presistor_schematic c=0 \
        r=0.44926
    re425 (\67\:VDDA \499\:VDDA) analogLib_presistor_schematic c=0 \
        r=0.44926
    re426 (\84\:S \85\:S) analogLib_presistor_schematic c=0 r=0.653161
    re427 (\85\:S \86\:S) analogLib_presistor_schematic c=0 r=7.50972
    re428 (\84\:S \83\:S) analogLib_presistor_schematic c=0 r=4.20182
    re429 (\83\:S \84\:S) analogLib_presistor_schematic c=0 r=5.4
    re430 (\87\:S \88\:S) analogLib_presistor_schematic c=0 r=6.63182
    re431 (\88\:S \89\:S) analogLib_presistor_schematic c=0 r=1.01154
    re432 (\89\:S \90\:S) analogLib_presistor_schematic c=0 r=7.51068
    re433 (\87\:S \88\:S) analogLib_presistor_schematic c=0 r=2.97
    re434 (\25\:D1 \24\:D1) analogLib_presistor_schematic c=0 r=4.20182
    re435 (\25\:D1 \26\:D1) analogLib_presistor_schematic c=0 r=1.5205
    re436 (\24\:D1 \25\:D1) analogLib_presistor_schematic c=0 r=5.4
    re437 (\29\:Vo1 \30\:Vo1) analogLib_presistor_schematic c=0 r=6.63182
    re438 (\30\:Vo1 \31\:Vo1) analogLib_presistor_schematic c=0 r=1.87812
    re439 (\29\:Vo1 \30\:Vo1) analogLib_presistor_schematic c=0 r=2.97
    re440 (\500\:VDDA \501\:VDDA) analogLib_presistor_schematic c=0 \
        r=10.8562
    re441 (\502\:VDDA \503\:VDDA) analogLib_presistor_schematic c=0 \
        r=11.0578
    re442 (\504\:VDDA \505\:VDDA) analogLib_presistor_schematic c=0 \
        r=11.0578
    re443 (\506\:VDDA \507\:VDDA) analogLib_presistor_schematic c=0 \
        r=11.0578
    re444 (\508\:VDDA \509\:VDDA) analogLib_presistor_schematic c=0 \
        r=11.0578
    re445 (\510\:VDDA \511\:VDDA) analogLib_presistor_schematic c=0 \
        r=11.0578
    re446 (\512\:VDDA \513\:VDDA) analogLib_presistor_schematic c=0 \
        r=11.0578
    re447 (\514\:VDDA \515\:VDDA) analogLib_presistor_schematic c=0 \
        r=10.8075
    re448 (\516\:VDDA \517\:VDDA) analogLib_presistor_schematic c=0 \
        r=7.425
    re449 (\518\:VDDA \519\:VDDA) analogLib_presistor_schematic c=0 \
        r=7.425
    re450 (\520\:VDDA \521\:VDDA) analogLib_presistor_schematic c=0 \
        r=7.425
    re451 (\522\:VDDA \523\:VDDA) analogLib_presistor_schematic c=0 \
        r=7.425
    re452 (\524\:VDDA \525\:VDDA) analogLib_presistor_schematic c=0 \
        r=7.425
    re453 (\526\:VDDA \527\:VDDA) analogLib_presistor_schematic c=0 \
        r=7.425
    re454 (\528\:VDDA \529\:VDDA) analogLib_presistor_schematic c=0 \
        r=7.425
    re455 (\530\:VDDA \531\:VDDA) analogLib_presistor_schematic c=0 \
        r=7.425
    re456 (\92\:S \93\:S) analogLib_presistor_schematic c=0 r=0.653161
    re457 (\93\:S \94\:S) analogLib_presistor_schematic c=0 r=7.5156
    re458 (\92\:S \91\:S) analogLib_presistor_schematic c=0 r=4.20182
    re459 (\91\:S \92\:S) analogLib_presistor_schematic c=0 r=5.4
    re460 (\95\:S \96\:S) analogLib_presistor_schematic c=0 r=6.63182
    re461 (\96\:S \97\:S) analogLib_presistor_schematic c=0 r=1.01154
    re462 (\97\:S \98\:S) analogLib_presistor_schematic c=0 r=7.51656
    re463 (\95\:S \96\:S) analogLib_presistor_schematic c=0 r=2.97
    re464 (\33\:Vo1 \32\:Vo1) analogLib_presistor_schematic c=0 r=4.20182
    re465 (\33\:Vo1 \34\:Vo1) analogLib_presistor_schematic c=0 r=1.24235
    re466 (\32\:Vo1 \33\:Vo1) analogLib_presistor_schematic c=0 r=5.4
    re467 (\27\:D1 \28\:D1) analogLib_presistor_schematic c=0 r=6.63182
    re468 (\28\:D1 \29\:D1) analogLib_presistor_schematic c=0 r=1.59997
    re469 (\27\:D1 \28\:D1) analogLib_presistor_schematic c=0 r=2.97
    re470 (\100\:S \101\:S) analogLib_presistor_schematic c=0 r=0.653161
    re471 (\101\:S \102\:S) analogLib_presistor_schematic c=0 r=7.51364
    re472 (\100\:S \99\:S) analogLib_presistor_schematic c=0 r=4.20182
    re473 (\99\:S \100\:S) analogLib_presistor_schematic c=0 r=5.4
    re474 (\103\:S \104\:S) analogLib_presistor_schematic c=0 r=6.63182
    re475 (\104\:S \105\:S) analogLib_presistor_schematic c=0 r=1.01154
    re476 (\105\:S \106\:S) analogLib_presistor_schematic c=0 r=7.5146
    re477 (\103\:S \104\:S) analogLib_presistor_schematic c=0 r=2.97
    re478 (\31\:D1 \30\:D1) analogLib_presistor_schematic c=0 r=4.20182
    re479 (\31\:D1 \32\:D1) analogLib_presistor_schematic c=0 r=1.5205
    re480 (\30\:D1 \31\:D1) analogLib_presistor_schematic c=0 r=5.4
    re481 (\35\:Vo1 \36\:Vo1) analogLib_presistor_schematic c=0 r=6.63182
    re482 (\36\:Vo1 \37\:Vo1) analogLib_presistor_schematic c=0 r=1.87812
    re483 (\35\:Vo1 \36\:Vo1) analogLib_presistor_schematic c=0 r=2.97
    re484 (\108\:S \109\:S) analogLib_presistor_schematic c=0 r=0.653161
    re485 (\109\:S \110\:S) analogLib_presistor_schematic c=0 r=7.51951
    re486 (\108\:S \107\:S) analogLib_presistor_schematic c=0 r=4.20182
    re487 (\107\:S \108\:S) analogLib_presistor_schematic c=0 r=5.4
    re488 (\111\:S \112\:S) analogLib_presistor_schematic c=0 r=6.63182
    re489 (\112\:S \113\:S) analogLib_presistor_schematic c=0 r=1.01154
    re490 (\113\:S \114\:S) analogLib_presistor_schematic c=0 r=7.52048
    re491 (\111\:S \112\:S) analogLib_presistor_schematic c=0 r=2.97
    re492 (\39\:Vo1 \38\:Vo1) analogLib_presistor_schematic c=0 r=4.20182
    re493 (\39\:Vo1 \40\:Vo1) analogLib_presistor_schematic c=0 r=1.24235
    re494 (\38\:Vo1 \39\:Vo1) analogLib_presistor_schematic c=0 r=5.4
    re495 (\33\:D1 \34\:D1) analogLib_presistor_schematic c=0 r=6.63182
    re496 (\34\:D1 \35\:D1) analogLib_presistor_schematic c=0 r=1.59997
    re497 (\33\:D1 \34\:D1) analogLib_presistor_schematic c=0 r=2.97
    re498 (\116\:S \117\:S) analogLib_presistor_schematic c=0 r=0.653161
    re499 (\117\:S \118\:S) analogLib_presistor_schematic c=0 r=7.5107
    re500 (\116\:S \115\:S) analogLib_presistor_schematic c=0 r=4.20182
    re501 (\115\:S \116\:S) analogLib_presistor_schematic c=0 r=5.4
    re502 (\119\:S \120\:S) analogLib_presistor_schematic c=0 r=6.63182
    re503 (\120\:S \121\:S) analogLib_presistor_schematic c=0 r=1.01154
    re504 (\121\:S \122\:S) analogLib_presistor_schematic c=0 r=7.51166
    re505 (\119\:S \120\:S) analogLib_presistor_schematic c=0 r=2.97
    re506 (\37\:D1 \36\:D1) analogLib_presistor_schematic c=0 r=4.20182
    re507 (\37\:D1 \38\:D1) analogLib_presistor_schematic c=0 r=1.5205
    re508 (\36\:D1 \37\:D1) analogLib_presistor_schematic c=0 r=5.4
    re509 (\41\:Vo1 \42\:Vo1) analogLib_presistor_schematic c=0 r=6.63182
    re510 (\42\:Vo1 \43\:Vo1) analogLib_presistor_schematic c=0 r=1.87812
    re511 (\41\:Vo1 \42\:Vo1) analogLib_presistor_schematic c=0 r=2.97
    re512 (\124\:S \125\:S) analogLib_presistor_schematic c=0 r=0.653161
    re513 (\125\:S \126\:S) analogLib_presistor_schematic c=0 r=7.51657
    re514 (\124\:S \123\:S) analogLib_presistor_schematic c=0 r=4.20182
    re515 (\123\:S \124\:S) analogLib_presistor_schematic c=0 r=5.4
    re516 (\127\:S \128\:S) analogLib_presistor_schematic c=0 r=6.63182
    re517 (\128\:S \129\:S) analogLib_presistor_schematic c=0 r=1.01154
    re518 (\129\:S \130\:S) analogLib_presistor_schematic c=0 r=7.51754
    re519 (\127\:S \128\:S) analogLib_presistor_schematic c=0 r=2.97
    re520 (\532\:VDDA \533\:VDDA) analogLib_presistor_schematic c=0 \
        r=0.389901
    re521 (\533\:VDDA \535\:VDDA) analogLib_presistor_schematic c=0 \
        r=0.273071
    re522 (\535\:VDDA \536\:VDDA) analogLib_presistor_schematic c=0 \
        r=0.778317
    re523 (\536\:VDDA \537\:VDDA) analogLib_presistor_schematic c=0 \
        r=0.23762
    re524 (\537\:VDDA \538\:VDDA) analogLib_presistor_schematic c=0 \
        r=0.019316
    re525 (\538\:VDDA \539\:VDDA) analogLib_presistor_schematic c=0 \
        r=1.58392
    re526 (\539\:VDDA \540\:VDDA) analogLib_presistor_schematic c=0 \
        r=0.046359
    re527 (\540\:VDDA \541\:VDDA) analogLib_presistor_schematic c=0 \
        r=1.52061
    re528 (\541\:VDDA \542\:VDDA) analogLib_presistor_schematic c=0 \
        r=0.278858
    re529 (\542\:VDDA \543\:VDDA) analogLib_presistor_schematic c=0 \
        r=1.29213
    re530 (\543\:VDDA \544\:VDDA) analogLib_presistor_schematic c=0 \
        r=0.50734
    re531 (\544\:VDDA \545\:VDDA) analogLib_presistor_schematic c=0 \
        r=1.06364
    re532 (\545\:VDDA \546\:VDDA) analogLib_presistor_schematic c=0 \
        r=0.735822
    re533 (\546\:VDDA \547\:VDDA) analogLib_presistor_schematic c=0 \
        r=0.835162
    re534 (\547\:VDDA \548\:VDDA) analogLib_presistor_schematic c=0 \
        r=0.964304
    re535 (\548\:VDDA \549\:VDDA) analogLib_presistor_schematic c=0 \
        r=0.60668
    re536 (\549\:VDDA \550\:VDDA) analogLib_presistor_schematic c=0 \
        r=1.19279
    re537 (\550\:VDDA \551\:VDDA) analogLib_presistor_schematic c=0 \
        r=0.378198
    re538 (\551\:VDDA \552\:VDDA) analogLib_presistor_schematic c=0 \
        r=1.58463
    re539 (\552\:VDDA \553\:VDDA) analogLib_presistor_schematic c=0 \
        r=0.015453
    re540 (\553\:VDDA \554\:VDDA) analogLib_presistor_schematic c=0 \
        r=0.940175
    re541 (\554\:VDDA \555\:VDDA) analogLib_presistor_schematic c=0 \
        r=0.23762
    re542 (\555\:VDDA \556\:VDDA) analogLib_presistor_schematic c=0 \
        r=0.301485
    re543 (\556\:VDDA \557\:VDDA) analogLib_presistor_schematic c=0 \
        r=1.13284
    re544 (\557\:VDDA \558\:VDDA) analogLib_presistor_schematic c=0 \
        r=1.16104
    re545 (\558\:VDDA \559\:VDDA) analogLib_presistor_schematic c=0 \
        r=0.544868
    re546 (\559\:VDDA \560\:VDDA) analogLib_presistor_schematic c=0 \
        r=0.981964
    re547 (\560\:VDDA \561\:VDDA) analogLib_presistor_schematic c=0 \
        r=1.58944
    re548 (\561\:VDDA \562\:VDDA) analogLib_presistor_schematic c=0 \
        r=1.58944
    re549 (\562\:VDDA \563\:VDDA) analogLib_presistor_schematic c=0 \
        r=1.58944
    re550 (\563\:VDDA \564\:VDDA) analogLib_presistor_schematic c=0 \
        r=1.58944
    re551 (\564\:VDDA \565\:VDDA) analogLib_presistor_schematic c=0 \
        r=1.58944
    re552 (\565\:VDDA \566\:VDDA) analogLib_presistor_schematic c=0 \
        r=1.58944
    re553 (\566\:VDDA \567\:VDDA) analogLib_presistor_schematic c=0 \
        r=1.58944
    re554 (\567\:VDDA \568\:VDDA) analogLib_presistor_schematic c=0 \
        r=1.58944
    re555 (\568\:VDDA \569\:VDDA) analogLib_presistor_schematic c=0 \
        r=0.246848
    re556 (\569\:VDDA \570\:VDDA) analogLib_presistor_schematic c=0 \
        r=1.27998
    re557 (\570\:VDDA \571\:VDDA) analogLib_presistor_schematic c=0 \
        r=1.55875
    re558 (\571\:VDDA \572\:VDDA) analogLib_presistor_schematic c=0 \
        r=0.301485
    re559 (\572\:VDDA \573\:VDDA) analogLib_presistor_schematic c=0 \
        r=0.23762
    re560 (\573\:VDDA \574\:VDDA) analogLib_presistor_schematic c=0 \
        r=0.940175
    re561 (\574\:VDDA \575\:VDDA) analogLib_presistor_schematic c=0 \
        r=0.015453
    re562 (\575\:VDDA \576\:VDDA) analogLib_presistor_schematic c=0 \
        r=1.58282
    re563 (\576\:VDDA \577\:VDDA) analogLib_presistor_schematic c=0 \
        r=0.378198
    re564 (\577\:VDDA \578\:VDDA) analogLib_presistor_schematic c=0 \
        r=1.19279
    re565 (\578\:VDDA \579\:VDDA) analogLib_presistor_schematic c=0 \
        r=0.60668
    re566 (\579\:VDDA \580\:VDDA) analogLib_presistor_schematic c=0 \
        r=0.964304
    re567 (\580\:VDDA \581\:VDDA) analogLib_presistor_schematic c=0 \
        r=0.835162
    re568 (\581\:VDDA \582\:VDDA) analogLib_presistor_schematic c=0 \
        r=0.735822
    re569 (\582\:VDDA \583\:VDDA) analogLib_presistor_schematic c=0 \
        r=1.06364
    re570 (\583\:VDDA \584\:VDDA) analogLib_presistor_schematic c=0 \
        r=0.50734
    re571 (\584\:VDDA \585\:VDDA) analogLib_presistor_schematic c=0 \
        r=1.29213
    re572 (\585\:VDDA \586\:VDDA) analogLib_presistor_schematic c=0 \
        r=0.278858
    re573 (\586\:VDDA \587\:VDDA) analogLib_presistor_schematic c=0 \
        r=1.52061
    re574 (\587\:VDDA \588\:VDDA) analogLib_presistor_schematic c=0 \
        r=0.046359
    re575 (\588\:VDDA \589\:VDDA) analogLib_presistor_schematic c=0 \
        r=1.58573
    re576 (\589\:VDDA \590\:VDDA) analogLib_presistor_schematic c=0 \
        r=0.019316
    re577 (\590\:VDDA \591\:VDDA) analogLib_presistor_schematic c=0 \
        r=0.23762
    re578 (\591\:VDDA \592\:VDDA) analogLib_presistor_schematic c=0 \
        r=0.778317
    re579 (\592\:VDDA \593\:VDDA) analogLib_presistor_schematic c=0 \
        r=0.495462
    re580 (\593\:VDDA \594\:VDDA) analogLib_presistor_schematic c=0 \
        r=0.038548
    re581 (\594\:VDDA \595\:VDDA) analogLib_presistor_schematic c=0 \
        r=0.119726
    re582 (\595\:VDDA \596\:VDDA) analogLib_presistor_schematic c=0 \
        r=0.036281
    re583 (\596\:VDDA \597\:VDDA) analogLib_presistor_schematic c=0 \
        r=0.08526
    re584 (\597\:VDDA \598\:VDDA) analogLib_presistor_schematic c=0 \
        r=0.108237
    re585 (\598\:VDDA \599\:VDDA) analogLib_presistor_schematic c=0 \
        r=0.133029
    re586 (\599\:VDDA \600\:VDDA) analogLib_presistor_schematic c=0 \
        r=0.060468
    re587 (\600\:VDDA \601\:VDDA) analogLib_presistor_schematic c=0 \
        r=0.180799
    re588 (\601\:VDDA \602\:VDDA) analogLib_presistor_schematic c=0 \
        r=0.012698
    re589 (\602\:VDDA \603\:VDDA) analogLib_presistor_schematic c=0 \
        r=0.193497
    re590 (\603\:VDDA \604\:VDDA) analogLib_presistor_schematic c=0 \
        r=0.035071
    re591 (\604\:VDDA \605\:VDDA) analogLib_presistor_schematic c=0 \
        r=0.158426
    re592 (\605\:VDDA \606\:VDDA) analogLib_presistor_schematic c=0 \
        r=0.082841
    re593 (\606\:VDDA \607\:VDDA) analogLib_presistor_schematic c=0 \
        r=0.110656
    re594 (\607\:VDDA \608\:VDDA) analogLib_presistor_schematic c=0 \
        r=0.13061
    re595 (\608\:VDDA \609\:VDDA) analogLib_presistor_schematic c=0 \
        r=0.062887
    re596 (\609\:VDDA \610\:VDDA) analogLib_presistor_schematic c=0 \
        r=0.17838
    re597 (\610\:VDDA \611\:VDDA) analogLib_presistor_schematic c=0 \
        r=0.015117
    re598 (\611\:VDDA \612\:VDDA) analogLib_presistor_schematic c=0 \
        r=0.120936
    re599 (\612\:VDDA \613\:VDDA) analogLib_presistor_schematic c=0 \
        r=0.072561
    re600 (\613\:VDDA \614\:VDDA) analogLib_presistor_schematic c=0 \
        r=0.032653
    re601 (\614\:VDDA \615\:VDDA) analogLib_presistor_schematic c=0 \
        r=0.107633
    re602 (\615\:VDDA \616\:VDDA) analogLib_presistor_schematic c=0 \
        r=0.043355
    re603 (\616\:VDDA \533\:VDDA) analogLib_presistor_schematic c=0 \
        r=0.014391
    re604 (\534\:VDDA \535\:VDDA) analogLib_presistor_schematic c=0 \
        r=3.7125
    re605 (\534\:VDDA \538\:VDDA) analogLib_presistor_schematic c=0 \
        r=1.485
    re606 (\534\:VDDA \539\:VDDA) analogLib_presistor_schematic c=0 \
        r=1.485
    re607 (\534\:VDDA \541\:VDDA) analogLib_presistor_schematic c=0 \
        r=1.485
    re608 (\534\:VDDA \543\:VDDA) analogLib_presistor_schematic c=0 \
        r=1.485
    re609 (\534\:VDDA \545\:VDDA) analogLib_presistor_schematic c=0 \
        r=1.485
    re610 (\534\:VDDA \547\:VDDA) analogLib_presistor_schematic c=0 \
        r=1.485
    re611 (\534\:VDDA \549\:VDDA) analogLib_presistor_schematic c=0 \
        r=1.485
    re612 (\534\:VDDA \551\:VDDA) analogLib_presistor_schematic c=0 \
        r=1.485
    re613 (\534\:VDDA \552\:VDDA) analogLib_presistor_schematic c=0 \
        r=1.485
    re614 (\534\:VDDA \556\:VDDA) analogLib_presistor_schematic c=0 \
        r=1.485
    re615 (\534\:VDDA \557\:VDDA) analogLib_presistor_schematic c=0 r=3.3
    re616 (\534\:VDDA \558\:VDDA) analogLib_presistor_schematic c=0 \
        r=1.485
    re617 (\534\:VDDA \560\:VDDA) analogLib_presistor_schematic c=0 \
        r=1.485
    re618 (\534\:VDDA \561\:VDDA) analogLib_presistor_schematic c=0 \
        r=1.485
    re619 (\534\:VDDA \562\:VDDA) analogLib_presistor_schematic c=0 \
        r=1.485
    re620 (\534\:VDDA \563\:VDDA) analogLib_presistor_schematic c=0 \
        r=1.485
    re621 (\534\:VDDA \564\:VDDA) analogLib_presistor_schematic c=0 \
        r=1.485
    re622 (\534\:VDDA \565\:VDDA) analogLib_presistor_schematic c=0 \
        r=1.485
    re623 (\534\:VDDA \566\:VDDA) analogLib_presistor_schematic c=0 \
        r=1.485
    re624 (\534\:VDDA \567\:VDDA) analogLib_presistor_schematic c=0 \
        r=1.485
    re625 (\534\:VDDA \568\:VDDA) analogLib_presistor_schematic c=0 \
        r=1.485
    re626 (\534\:VDDA \570\:VDDA) analogLib_presistor_schematic c=0 \
        r=1.485
    re627 (\534\:VDDA \571\:VDDA) analogLib_presistor_schematic c=0 \
        r=1.485
    re628 (\534\:VDDA \575\:VDDA) analogLib_presistor_schematic c=0 \
        r=1.485
    re629 (\534\:VDDA \576\:VDDA) analogLib_presistor_schematic c=0 \
        r=1.485
    re630 (\534\:VDDA \578\:VDDA) analogLib_presistor_schematic c=0 \
        r=1.485
    re631 (\534\:VDDA \580\:VDDA) analogLib_presistor_schematic c=0 \
        r=1.485
    re632 (\534\:VDDA \582\:VDDA) analogLib_presistor_schematic c=0 \
        r=1.485
    re633 (\534\:VDDA \584\:VDDA) analogLib_presistor_schematic c=0 \
        r=1.485
    re634 (\534\:VDDA \586\:VDDA) analogLib_presistor_schematic c=0 \
        r=1.485
    re635 (\534\:VDDA \588\:VDDA) analogLib_presistor_schematic c=0 \
        r=1.485
    re636 (\534\:VDDA \589\:VDDA) analogLib_presistor_schematic c=0 \
        r=1.485
    re637 (\534\:VDDA \592\:VDDA) analogLib_presistor_schematic c=0 \
        r=3.7125
    re638 (\534\:VDDA \593\:VDDA) analogLib_presistor_schematic c=0 \
        r=1.485
    re639 (\534\:VDDA \596\:VDDA) analogLib_presistor_schematic c=0 \
        r=1.485
    re640 (\534\:VDDA \598\:VDDA) analogLib_presistor_schematic c=0 \
        r=1.485
    re641 (\534\:VDDA \600\:VDDA) analogLib_presistor_schematic c=0 \
        r=1.485
    re642 (\534\:VDDA \602\:VDDA) analogLib_presistor_schematic c=0 \
        r=1.485
    re643 (\534\:VDDA \603\:VDDA) analogLib_presistor_schematic c=0 \
        r=1.485
    re644 (\534\:VDDA \605\:VDDA) analogLib_presistor_schematic c=0 \
        r=1.485
    re645 (\534\:VDDA \607\:VDDA) analogLib_presistor_schematic c=0 \
        r=1.485
    re646 (\534\:VDDA \609\:VDDA) analogLib_presistor_schematic c=0 \
        r=1.485
    re647 (\534\:VDDA \611\:VDDA) analogLib_presistor_schematic c=0 \
        r=1.485
    re648 (\534\:VDDA \613\:VDDA) analogLib_presistor_schematic c=0 \
        r=1.485
    re649 (\534\:VDDA \615\:VDDA) analogLib_presistor_schematic c=0 r=3.3
    re650 (\132\:S \133\:S) analogLib_presistor_schematic c=0 r=0.736538
    re651 (\133\:S \135\:S) analogLib_presistor_schematic c=0 r=0.736538
    re652 (\135\:S \134\:S) analogLib_presistor_schematic c=0 r=4.20182
    re653 (\132\:S \131\:S) analogLib_presistor_schematic c=0 r=4.20182
    re654 (\133\:S \136\:S) analogLib_presistor_schematic c=0 r=0.099166
    re655 (\136\:S \5\:S) analogLib_presistor_schematic c=0 r=0.198
    re656 (\131\:S \132\:S) analogLib_presistor_schematic c=0 r=5.4
    re657 (\134\:S \135\:S) analogLib_presistor_schematic c=0 r=5.4
    re658 (\138\:S \139\:S) analogLib_presistor_schematic c=0 r=6.63182
    re659 (\139\:S \140\:S) analogLib_presistor_schematic c=0 r=1.09416
    re660 (\140\:S \142\:S) analogLib_presistor_schematic c=0 r=1.09416
    re661 (\140\:S \143\:S) analogLib_presistor_schematic c=0 r=0.099166
    re662 (\143\:S \7\:S) analogLib_presistor_schematic c=0 r=0.198
    re663 (\142\:S \141\:S) analogLib_presistor_schematic c=0 r=6.63182
    re664 (\138\:S \139\:S) analogLib_presistor_schematic c=0 r=2.97
    re665 (\141\:S \142\:S) analogLib_presistor_schematic c=0 r=2.97
    re666 (\133\:GNDA \134\:GNDA) analogLib_presistor_schematic c=0 \
        r=15.147
    re667 (\135\:GNDA \136\:GNDA) analogLib_presistor_schematic c=0 \
        r=15.147
    re668 (\9\:BIAS \10\:BIAS) analogLib_presistor_schematic c=0 r=5.09913
    re669 (\11\:BIAS \12\:BIAS) analogLib_presistor_schematic c=0 \
        r=5.09913
    re670 (\221\:Vm1 \222\:Vm1) analogLib_presistor_schematic c=0 \
        r=5.02176
    re671 (\223\:Vm1 \224\:Vm1) analogLib_presistor_schematic c=0 \
        r=5.14056
    re672 (\11\:S2 \12\:S2) analogLib_presistor_schematic c=0 r=2.7
    re673 (\13\:S2 \14\:S2) analogLib_presistor_schematic c=0 r=2.7
    re674 (\145\:S \146\:S) analogLib_presistor_schematic c=0 r=5.22815
    re675 (\146\:S \145\:S) analogLib_presistor_schematic c=0 r=0.747849
    re676 (\147\:S \148\:S) analogLib_presistor_schematic c=0 r=5.22815
    re677 (\148\:S \147\:S) analogLib_presistor_schematic c=0 r=0.747849
    re678 (\15\:S2 \2\:S2) analogLib_presistor_schematic c=0 r=5.56519
    re679 (\2\:S2 \17\:S2) analogLib_presistor_schematic c=0 r=0.04388
    re680 (\17\:S2 \18\:S2) analogLib_presistor_schematic c=0 r=5.5488
    re681 (\19\:S2 \4\:S2) analogLib_presistor_schematic c=0 r=5.56519
    re682 (\4\:S2 \21\:S2) analogLib_presistor_schematic c=0 r=0.04388
    re683 (\21\:S2 \22\:S2) analogLib_presistor_schematic c=0 r=5.5488
    re684 (\7\:BIAS \14\:BIAS) analogLib_presistor_schematic c=0 \
        r=0.282018
    re685 (\8\:BIAS \16\:BIAS) analogLib_presistor_schematic c=0 \
        r=0.282018
    re686 (\23\:S2 \24\:S2) analogLib_presistor_schematic c=0 r=6.28353
    re687 (\25\:S2 \26\:S2) analogLib_presistor_schematic c=0 r=6.28353
    re688 (\3\:Vs \4\:Vs) analogLib_presistor_schematic c=0 r=6.83983
    re689 (\7\:D2 \8\:D2) analogLib_presistor_schematic c=0 r=6.83983
    re690 (\19\:Y \16\:Y) analogLib_presistor_schematic c=0 r=0.439828
    re691 (\16\:Y \14\:Y) analogLib_presistor_schematic c=0 r=0.326829
    re692 (\14\:Y \12\:Y) analogLib_presistor_schematic c=0 r=0.54935
    re693 (\12\:Y \10\:Y) analogLib_presistor_schematic c=0 r=0.326829
    re694 (\10\:Y \8\:Y) analogLib_presistor_schematic c=0 r=0.54935
    re695 (\8\:Y \6\:Y) analogLib_presistor_schematic c=0 r=0.326829
    re696 (\6\:Y \4\:Y) analogLib_presistor_schematic c=0 r=0.54935
    re697 (\4\:Y \2\:Y) analogLib_presistor_schematic c=0 r=0.986829
    re698 (\18\:X \16\:X) analogLib_presistor_schematic c=0 r=0.439828
    re699 (\16\:X \14\:X) analogLib_presistor_schematic c=0 r=0.54935
    re700 (\14\:X \12\:X) analogLib_presistor_schematic c=0 r=0.326829
    re701 (\12\:X \10\:X) analogLib_presistor_schematic c=0 r=0.54935
    re702 (\10\:X \8\:X) analogLib_presistor_schematic c=0 r=0.326829
    re703 (\8\:X \6\:X) analogLib_presistor_schematic c=0 r=0.54935
    re704 (\6\:X \4\:X) analogLib_presistor_schematic c=0 r=0.326829
    re705 (\4\:X \2\:X) analogLib_presistor_schematic c=0 r=1.20935
    re706 (\137\:GNDA \138\:GNDA) analogLib_presistor_schematic c=0 \
        r=3.39536
    re707 (\139\:GNDA \140\:GNDA) analogLib_presistor_schematic c=0 \
        r=3.40939
    re708 (\5\:Vs \6\:Vs) analogLib_presistor_schematic c=0 r=3.68754
    re709 (\9\:D2 \10\:D2) analogLib_presistor_schematic c=0 r=3.9657
    re710 (\27\:S2 \28\:S2) analogLib_presistor_schematic c=0 r=6.28353
    re711 (\29\:S2 \30\:S2) analogLib_presistor_schematic c=0 r=6.28353
    re712 (\17\:BIAS \19\:BIAS) analogLib_presistor_schematic c=0 \
        r=0.233399
    re713 (\19\:BIAS \21\:BIAS) analogLib_presistor_schematic c=0 \
        r=0.613044
    re714 (\21\:BIAS \22\:BIAS) analogLib_presistor_schematic c=0 \
        r=0.14913
    re715 (\19\:BIAS \23\:BIAS) analogLib_presistor_schematic c=0 \
        r=0.233449
    re716 (\18\:BIAS \19\:BIAS) analogLib_presistor_schematic c=0 r=4.95
    re717 (\20\:BIAS \21\:BIAS) analogLib_presistor_schematic c=0 r=4.95
    re718 (\24\:BIAS \26\:BIAS) analogLib_presistor_schematic c=0 \
        r=0.233399
    re719 (\26\:BIAS \28\:BIAS) analogLib_presistor_schematic c=0 \
        r=0.613044
    re720 (\28\:BIAS \29\:BIAS) analogLib_presistor_schematic c=0 \
        r=0.14913
    re721 (\26\:BIAS \30\:BIAS) analogLib_presistor_schematic c=0 \
        r=0.233449
    re722 (\25\:BIAS \26\:BIAS) analogLib_presistor_schematic c=0 r=4.95
    re723 (\27\:BIAS \28\:BIAS) analogLib_presistor_schematic c=0 r=4.95
    re724 (\11\:D2 \12\:D2) analogLib_presistor_schematic c=0 r=6.56168
    re725 (\7\:Vs \8\:Vs) analogLib_presistor_schematic c=0 r=6.56168
    re726 (\150\:S \151\:S) analogLib_presistor_schematic c=0 r=0.038632
    re727 (\151\:S \152\:S) analogLib_presistor_schematic c=0 r=1.5195
    re728 (\152\:S \153\:S) analogLib_presistor_schematic c=0 r=1.58944
    re729 (\153\:S \154\:S) analogLib_presistor_schematic c=0 r=1.58944
    re730 (\154\:S \155\:S) analogLib_presistor_schematic c=0 r=1.53937
    re731 (\155\:S \156\:S) analogLib_presistor_schematic c=0 r=0.030906
    re732 (\156\:S \157\:S) analogLib_presistor_schematic c=0 r=1.19963
    re733 (\157\:S \158\:S) analogLib_presistor_schematic c=0 r=0.544868
    re734 (\158\:S \159\:S) analogLib_presistor_schematic c=0 r=0.62434
    re735 (\159\:S \160\:S) analogLib_presistor_schematic c=0 r=1.58944
    re736 (\160\:S \161\:S) analogLib_presistor_schematic c=0 r=1.58944
    re737 (\161\:S \162\:S) analogLib_presistor_schematic c=0 r=1.58944
    re738 (\162\:S \163\:S) analogLib_presistor_schematic c=0 r=1.36939
    re739 (\163\:S \164\:S) analogLib_presistor_schematic c=0 r=0.171102
    re740 (\164\:S \165\:S) analogLib_presistor_schematic c=0 r=1.56567
    re741 (\165\:S \166\:S) analogLib_presistor_schematic c=0 r=0.038632
    re742 (\166\:S \167\:S) analogLib_presistor_schematic c=0 r=1.5195
    re743 (\167\:S \168\:S) analogLib_presistor_schematic c=0 r=1.59441
    re744 (\168\:S \169\:S) analogLib_presistor_schematic c=0 r=1.59441
    re745 (\169\:S \170\:S) analogLib_presistor_schematic c=0 r=1.52944
    re746 (\170\:S \171\:S) analogLib_presistor_schematic c=0 r=0.034769
    re747 (\168\:S \172\:S) analogLib_presistor_schematic c=0 r=0.737103
    re748 (\172\:S \174\:S) analogLib_presistor_schematic c=0 r=0.40332
    re749 (\174\:S \176\:S) analogLib_presistor_schematic c=0 r=0.886609
    re750 (\176\:S \178\:S) analogLib_presistor_schematic c=0 r=0.877917
    re751 (\178\:S \180\:S) analogLib_presistor_schematic c=0 r=0.893563
    re752 (\180\:S \182\:S) analogLib_presistor_schematic c=0 r=0.940501
    re753 (\182\:S \183\:S) analogLib_presistor_schematic c=0 r=0.775349
    re754 (\183\:S \184\:S) analogLib_presistor_schematic c=0 r=0.406797
    re755 (\171\:S \185\:S) analogLib_presistor_schematic c=0 r=1.55339
    re756 (\185\:S \186\:S) analogLib_presistor_schematic c=0 r=0.187244
    re757 (\184\:S \153\:S) analogLib_presistor_schematic c=0 r=0.330305
    re758 (\186\:S \187\:S) analogLib_presistor_schematic c=0 r=1.33959
    re759 (\187\:S \188\:S) analogLib_presistor_schematic c=0 r=1.58944
    re760 (\188\:S \189\:S) analogLib_presistor_schematic c=0 r=1.58944
    re761 (\189\:S \190\:S) analogLib_presistor_schematic c=0 r=1.58944
    re762 (\190\:S \191\:S) analogLib_presistor_schematic c=0 r=0.654142
    re763 (\191\:S \192\:S) analogLib_presistor_schematic c=0 r=0.529967
    re764 (\192\:S \193\:S) analogLib_presistor_schematic c=0 r=0.831089
    re765 (\193\:S \150\:S) analogLib_presistor_schematic c=0 r=0.375715
    re766 (\149\:S \150\:S) analogLib_presistor_schematic c=0 r=1.485
    re767 (\149\:S \152\:S) analogLib_presistor_schematic c=0 r=1.485
    re768 (\149\:S \153\:S) analogLib_presistor_schematic c=0 r=1.485
    re769 (\149\:S \154\:S) analogLib_presistor_schematic c=0 r=1.485
    re770 (\149\:S \156\:S) analogLib_presistor_schematic c=0 r=1.485
    re771 (\149\:S \157\:S) analogLib_presistor_schematic c=0 r=2.7
    re772 (\149\:S \159\:S) analogLib_presistor_schematic c=0 r=1.485
    re773 (\149\:S \160\:S) analogLib_presistor_schematic c=0 r=1.485
    re774 (\149\:S \161\:S) analogLib_presistor_schematic c=0 r=1.485
    re775 (\149\:S \162\:S) analogLib_presistor_schematic c=0 r=1.485
    re776 (\149\:S \164\:S) analogLib_presistor_schematic c=0 r=1.485
    re777 (\149\:S \165\:S) analogLib_presistor_schematic c=0 r=1.485
    re778 (\149\:S \167\:S) analogLib_presistor_schematic c=0 r=1.485
    re779 (\149\:S \168\:S) analogLib_presistor_schematic c=0 r=1.485
    re780 (\149\:S \169\:S) analogLib_presistor_schematic c=0 r=1.485
    re781 (\149\:S \171\:S) analogLib_presistor_schematic c=0 r=1.485
    re782 (\173\:S \174\:S) analogLib_presistor_schematic c=0 r=2.97
    re783 (\175\:S \176\:S) analogLib_presistor_schematic c=0 r=3.3
    re784 (\177\:S \178\:S) analogLib_presistor_schematic c=0 r=3.3
    re785 (\179\:S \180\:S) analogLib_presistor_schematic c=0 r=3.3
    re786 (\181\:S \182\:S) analogLib_presistor_schematic c=0 r=2.97
    re787 (\149\:S \185\:S) analogLib_presistor_schematic c=0 r=1.485
    re788 (\149\:S \187\:S) analogLib_presistor_schematic c=0 r=1.485
    re789 (\149\:S \188\:S) analogLib_presistor_schematic c=0 r=1.485
    re790 (\149\:S \189\:S) analogLib_presistor_schematic c=0 r=1.485
    re791 (\149\:S \190\:S) analogLib_presistor_schematic c=0 r=1.485
    re792 (\149\:S \192\:S) analogLib_presistor_schematic c=0 r=2.7
    re793 (\13\:D2 \14\:D2) analogLib_presistor_schematic c=0 r=0.855317
    re794 (\14\:D2 \15\:D2) analogLib_presistor_schematic c=0 r=0.824025
    re795 (\13\:D2 \16\:D2) analogLib_presistor_schematic c=0 r=1.08827
    re796 (\31\:S2 \6\:S2) analogLib_presistor_schematic c=0 r=5.56519
    re797 (\6\:S2 \33\:S2) analogLib_presistor_schematic c=0 r=0.04388
    re798 (\33\:S2 \34\:S2) analogLib_presistor_schematic c=0 r=5.5488
    re799 (\35\:S2 \8\:S2) analogLib_presistor_schematic c=0 r=5.56519
    re800 (\8\:S2 \37\:S2) analogLib_presistor_schematic c=0 r=0.04388
    re801 (\37\:S2 \38\:S2) analogLib_presistor_schematic c=0 r=5.5488
    re802 (\39\:S2 \40\:S2) analogLib_presistor_schematic c=0 r=2.7
    re803 (\41\:S2 \42\:S2) analogLib_presistor_schematic c=0 r=2.7
    re804 (Vo2 \2\:Vo2) analogLib_presistor_schematic c=0 r=5.41355
    re805 (\44\:Vo1 \4\:Vo1) analogLib_presistor_schematic c=0 r=0.66
    re806 (\3\:Vo2 \4\:Vo2) analogLib_presistor_schematic c=0 r=4.96116
    re807 (\83\:BG_REF \84\:BG_REF) analogLib_presistor_schematic c=0 \
        r=4.96697
    re808 (Vs \10\:Vs) analogLib_presistor_schematic c=0 r=0.331617
    re809 (\141\:GNDA \142\:GNDA) analogLib_presistor_schematic c=0 \
        r=15.147
    re810 (\143\:GNDA \144\:GNDA) analogLib_presistor_schematic c=0 \
        r=15.147
    re811 (\9\:vv \4\:vv) analogLib_presistor_schematic c=0 r=0.882479
    re812 (\4\:vv \2\:vv) analogLib_presistor_schematic c=0 r=0.332044
    re813 (\2\:vv \12\:vv) analogLib_presistor_schematic c=0 r=0.953755
    re814 (\14\:BG_REF \12\:BG_REF) analogLib_presistor_schematic c=0 \
        r=1.17428
    re815 (\12\:BG_REF \87\:BG_REF) analogLib_presistor_schematic c=0 \
        r=0.910948
    re816 (\145\:GNDA \146\:GNDA) analogLib_presistor_schematic c=0 \
        r=3.39536
    re817 (\147\:GNDA \148\:GNDA) analogLib_presistor_schematic c=0 \
        r=3.40939
    re818 (\43\:S2 \45\:S2) analogLib_presistor_schematic c=0 r=0.023179
    re819 (\45\:S2 \46\:S2) analogLib_presistor_schematic c=0 r=1.5758
    re820 (\46\:S2 \47\:S2) analogLib_presistor_schematic c=0 r=1.48473
    re821 (\47\:S2 \48\:S2) analogLib_presistor_schematic c=0 r=0.052154
    re822 (\48\:S2 \49\:S2) analogLib_presistor_schematic c=0 r=0.979702
    re823 (\49\:S2 \50\:S2) analogLib_presistor_schematic c=0 r=0.743548
    re824 (\50\:S2 \51\:S2) analogLib_presistor_schematic c=0 r=0.236914
    re825 (\51\:S2 \52\:S2) analogLib_presistor_schematic c=0 r=1.31972
    re826 (\52\:S2 \53\:S2) analogLib_presistor_schematic c=0 r=0.202145
    re827 (\53\:S2 \54\:S2) analogLib_presistor_schematic c=0 r=1.53463
    re828 (\54\:S2 \55\:S2) analogLib_presistor_schematic c=0 r=0.038632
    re829 (\55\:S2 \56\:S2) analogLib_presistor_schematic c=0 r=1.53068
    re830 (\56\:S2 \57\:S2) analogLib_presistor_schematic c=0 r=1.55303
    re831 (\57\:S2 \58\:S2) analogLib_presistor_schematic c=0 r=0.02994
    re832 (\58\:S2 \59\:S2) analogLib_presistor_schematic c=0 r=1.5607
    re833 (\59\:S2 \60\:S2) analogLib_presistor_schematic c=0 r=0.184761
    re834 (\60\:S2 \61\:S2) analogLib_presistor_schematic c=0 r=1.32965
    re835 (\61\:S2 \62\:S2) analogLib_presistor_schematic c=0 r=0.22698
    re836 (\62\:S2 \63\:S2) analogLib_presistor_schematic c=0 r=0.775834
    re837 (\63\:S2 \64\:S2) analogLib_presistor_schematic c=0 r=0.585223
    re838 (\64\:S2 \43\:S2) analogLib_presistor_schematic c=0 r=0.414347
    re839 (\44\:S2 \45\:S2) analogLib_presistor_schematic c=0 r=1.485
    re840 (\44\:S2 \46\:S2) analogLib_presistor_schematic c=0 r=1.485
    re841 (\44\:S2 \48\:S2) analogLib_presistor_schematic c=0 r=1.56316
    re842 (\44\:S2 \49\:S2) analogLib_presistor_schematic c=0 r=4.95
    re843 (\44\:S2 \51\:S2) analogLib_presistor_schematic c=0 r=1.485
    re844 (\44\:S2 \53\:S2) analogLib_presistor_schematic c=0 r=1.56316
    re845 (\44\:S2 \54\:S2) analogLib_presistor_schematic c=0 r=1.485
    re846 (\44\:S2 \56\:S2) analogLib_presistor_schematic c=0 r=1.485
    re847 (\44\:S2 \58\:S2) analogLib_presistor_schematic c=0 r=1.485
    re848 (\44\:S2 \59\:S2) analogLib_presistor_schematic c=0 r=1.485
    re849 (\44\:S2 \61\:S2) analogLib_presistor_schematic c=0 r=1.56316
    re850 (\44\:S2 \63\:S2) analogLib_presistor_schematic c=0 r=4.24286
    re851 (\17\:D2 \18\:D2) analogLib_presistor_schematic c=0 r=3.68754
    re852 (\11\:Vs \12\:Vs) analogLib_presistor_schematic c=0 r=3.9657
    re853 (\13\:vv \6\:vv) analogLib_presistor_schematic c=0 r=30.311
    re854 (\6\:vv \15\:vv) analogLib_presistor_schematic c=0 r=0.20176
    re855 (\15\:BG_REF \16\:BG_REF) analogLib_presistor_schematic c=0 \
        r=1.52008
    re856 (\2\:net40 net40) analogLib_presistor_schematic c=0 r=1.10219
    re857 (\18\:Y \17\:Y) analogLib_presistor_schematic c=0 r=0.305538
    re858 (\17\:Y \28\:Y) analogLib_presistor_schematic c=0 r=3.79391
    re859 (\2\:net6 net6) analogLib_presistor_schematic c=0 r=0.579492
    re860 (\2\:net26 net26) analogLib_presistor_schematic c=0 r=1.1045
    re861 (\2\:net36 net36) analogLib_presistor_schematic c=0 r=0.577174
    re862 (\2\:net22 net22) analogLib_presistor_schematic c=0 r=1.83118
    re863 (\2\:net20 net20) analogLib_presistor_schematic c=0 r=0.586446
    re864 (\2\:net16 net16) analogLib_presistor_schematic c=0 r=2.33417
    re865 (\2\:net30 \3\:net30) analogLib_presistor_schematic c=0 \
        r=0.595861
    re866 (\2\:net33 net33) analogLib_presistor_schematic c=0 r=1.06686
    re867 (\2\:net9 net9) analogLib_presistor_schematic c=0 r=1.10219
    re868 (\2\:net41 net41) analogLib_presistor_schematic c=0 r=1.84337
    re869 (\2\:U \3\:U) analogLib_presistor_schematic c=0 r=0.566874
    re870 (\3\:U \4\:U) analogLib_presistor_schematic c=0 r=1.15624
    re871 (\3\:U \5\:U) analogLib_presistor_schematic c=0 r=0.118883
    re872 (\5\:U \6\:U) analogLib_presistor_schematic c=0 r=0.917498
    re873 (\4\:U \7\:U) analogLib_presistor_schematic c=0 r=1.19101
    re874 (\7\:U \8\:U) analogLib_presistor_schematic c=0 r=2.24424
    re875 (\4\:U \9\:U) analogLib_presistor_schematic c=0 r=0.135599
    re876 (\9\:U \10\:U) analogLib_presistor_schematic c=0 r=0.917498
    re877 (\7\:U \11\:U) analogLib_presistor_schematic c=0 r=0.118883
    re878 (\11\:U \12\:U) analogLib_presistor_schematic c=0 r=0.917498
    re879 (\2\:net3 net3) analogLib_presistor_schematic c=0 r=1.1045
    re880 (\4\:GNDA \2\:GNDA) analogLib_presistor_schematic c=0 r=0.836176
    re881 (\27\:X \28\:X) analogLib_presistor_schematic c=0 r=0.548539
    re882 (\28\:X \29\:X) analogLib_presistor_schematic c=0 r=0.548578
    re883 (\28\:X \30\:X) analogLib_presistor_schematic c=0 r=0.153977
    re884 (\30\:X \31\:X) analogLib_presistor_schematic c=0 r=0.917498
    re885 (\2\:net29 net29) analogLib_presistor_schematic c=0 r=1.10219
    re886 (\2\:net11 net11) analogLib_presistor_schematic c=0 r=1.30732
    re887 (\2\:net35 net35) analogLib_presistor_schematic c=0 r=1.02917
    re888 (\2\:net39 net39) analogLib_presistor_schematic c=0 r=1.77786
    re889 (\2\:net25 net25) analogLib_presistor_schematic c=0 r=1.10219
    re890 (\2\:net19 net19) analogLib_presistor_schematic c=0 r=1.03612
    re891 (\2\:net23 net23) analogLib_presistor_schematic c=0 r=0.572538
    re892 (\2\:net15 net15) analogLib_presistor_schematic c=0 r=3.42652
    re893 (\2\:net38 net38) analogLib_presistor_schematic c=0 r=1.09291
    re894 (\2\:net4 net4) analogLib_presistor_schematic c=0 r=2.19283
    re895 (\2\:net8 net8) analogLib_presistor_schematic c=0 r=1.10219
    re896 (\13\:U \14\:U) analogLib_presistor_schematic c=0 r=0.868231
    re897 (\14\:U U) analogLib_presistor_schematic c=0 r=0.008429
    re898 (U \15\:U) analogLib_presistor_schematic c=0 r=0.404996
    re899 (\2\:net1 net1) analogLib_presistor_schematic c=0 r=1.1045
    re900 (\2\:net14 net14) analogLib_presistor_schematic c=0 r=0.579492
    re901 (\2\:net17 net17) analogLib_presistor_schematic c=0 r=1.03149
    re902 (net27 \2\:net27) analogLib_presistor_schematic c=0 r=1.32879
    re903 (\2\:net21 net21) analogLib_presistor_schematic c=0 r=1.7825
    re904 (net7 \2\:net7) analogLib_presistor_schematic c=0 r=1.87174
    re905 (\16\:U \17\:U) analogLib_presistor_schematic c=0 r=2.24424
    re906 (\17\:U \18\:U) analogLib_presistor_schematic c=0 r=1.17015
    re907 (\18\:U \19\:U) analogLib_presistor_schematic c=0 r=1.17711
    re908 (\19\:U \20\:U) analogLib_presistor_schematic c=0 r=0.566909
    re909 (\17\:U \21\:U) analogLib_presistor_schematic c=0 r=0.118883
    re910 (\21\:U \22\:U) analogLib_presistor_schematic c=0 r=0.917498
    re911 (\18\:U \23\:U) analogLib_presistor_schematic c=0 r=0.135599
    re912 (\23\:U \24\:U) analogLib_presistor_schematic c=0 r=0.917498
    re913 (\19\:U \25\:U) analogLib_presistor_schematic c=0 r=0.118883
    re914 (\25\:U \26\:U) analogLib_presistor_schematic c=0 r=0.917498
    re915 (\27\:U \28\:U) analogLib_presistor_schematic c=0 r=2.24945
    re916 (\28\:U \29\:U) analogLib_presistor_schematic c=0 r=1.17015
    re917 (\29\:U \30\:U) analogLib_presistor_schematic c=0 r=1.17711
    re918 (\30\:U \31\:U) analogLib_presistor_schematic c=0 r=1.17206
    re919 (\31\:U \32\:U) analogLib_presistor_schematic c=0 r=1.17206
    re920 (\32\:U \33\:U) analogLib_presistor_schematic c=0 r=1.15624
    re921 (\28\:U \34\:U) analogLib_presistor_schematic c=0 r=0.118883
    re922 (\34\:U \35\:U) analogLib_presistor_schematic c=0 r=0.917498
    re923 (\29\:U \36\:U) analogLib_presistor_schematic c=0 r=0.137338
    re924 (\36\:U \37\:U) analogLib_presistor_schematic c=0 r=0.917498
    re925 (\30\:U \38\:U) analogLib_presistor_schematic c=0 r=0.118883
    re926 (\38\:U \39\:U) analogLib_presistor_schematic c=0 r=0.917498
    re927 (\31\:U \40\:U) analogLib_presistor_schematic c=0 r=0.118883
    re928 (\40\:U \41\:U) analogLib_presistor_schematic c=0 r=0.917498
    re929 (\32\:U \42\:U) analogLib_presistor_schematic c=0 r=0.118883
    re930 (\42\:U \43\:U) analogLib_presistor_schematic c=0 r=0.917498
    re931 (\33\:U \44\:U) analogLib_presistor_schematic c=0 r=1.19101
    re932 (\44\:U \45\:U) analogLib_presistor_schematic c=0 r=2.24945
    re933 (\33\:U \46\:U) analogLib_presistor_schematic c=0 r=0.137338
    re934 (\46\:U \47\:U) analogLib_presistor_schematic c=0 r=0.917498
    re935 (\44\:U \48\:U) analogLib_presistor_schematic c=0 r=0.118883
    re936 (\48\:U \49\:U) analogLib_presistor_schematic c=0 r=0.917498
    re937 (\50\:U \51\:U) analogLib_presistor_schematic c=0 r=2.24945
    re938 (\51\:U \52\:U) analogLib_presistor_schematic c=0 r=1.17015
    re939 (\52\:U \53\:U) analogLib_presistor_schematic c=0 r=2.3523
    re940 (\53\:U \54\:U) analogLib_presistor_schematic c=0 r=2.33144
    re941 (\51\:U \55\:U) analogLib_presistor_schematic c=0 r=0.118883
    re942 (\55\:U \56\:U) analogLib_presistor_schematic c=0 r=0.917498
    re943 (\52\:U \57\:U) analogLib_presistor_schematic c=0 r=0.137338
    re944 (\57\:U \58\:U) analogLib_presistor_schematic c=0 r=0.917498
    re945 (\53\:U \59\:U) analogLib_presistor_schematic c=0 r=0.118883
    re946 (\59\:U \60\:U) analogLib_presistor_schematic c=0 r=0.917498
    re947 (\54\:U \61\:U) analogLib_presistor_schematic c=0 r=1.19101
    re948 (\61\:U \62\:U) analogLib_presistor_schematic c=0 r=2.24945
    re949 (\54\:U \63\:U) analogLib_presistor_schematic c=0 r=0.137338
    re950 (\63\:U \64\:U) analogLib_presistor_schematic c=0 r=0.917498
    re951 (\61\:U \65\:U) analogLib_presistor_schematic c=0 r=0.118883
    re952 (\65\:U \66\:U) analogLib_presistor_schematic c=0 r=0.917498
    re953 (\67\:U \68\:U) analogLib_presistor_schematic c=0 r=2.24945
    re954 (\68\:U \69\:U) analogLib_presistor_schematic c=0 r=1.17015
    re955 (\69\:U \70\:U) analogLib_presistor_schematic c=0 r=1.17711
    re956 (\70\:U \71\:U) analogLib_presistor_schematic c=0 r=1.17206
    re957 (\71\:U \72\:U) analogLib_presistor_schematic c=0 r=1.17206
    re958 (\72\:U \73\:U) analogLib_presistor_schematic c=0 r=1.15624
    re959 (\68\:U \74\:U) analogLib_presistor_schematic c=0 r=0.118883
    re960 (\74\:U \75\:U) analogLib_presistor_schematic c=0 r=0.917498
    re961 (\69\:U \76\:U) analogLib_presistor_schematic c=0 r=0.137338
    re962 (\76\:U \77\:U) analogLib_presistor_schematic c=0 r=0.917498
    re963 (\70\:U \78\:U) analogLib_presistor_schematic c=0 r=0.118883
    re964 (\78\:U \79\:U) analogLib_presistor_schematic c=0 r=0.917498
    re965 (\71\:U \80\:U) analogLib_presistor_schematic c=0 r=0.118883
    re966 (\80\:U \81\:U) analogLib_presistor_schematic c=0 r=0.917498
    re967 (\72\:U \82\:U) analogLib_presistor_schematic c=0 r=0.118883
    re968 (\82\:U \83\:U) analogLib_presistor_schematic c=0 r=0.917498
    re969 (\73\:U \84\:U) analogLib_presistor_schematic c=0 r=1.19101
    re970 (\84\:U \85\:U) analogLib_presistor_schematic c=0 r=2.24945
    re971 (\73\:U \86\:U) analogLib_presistor_schematic c=0 r=0.137338
    re972 (\86\:U \87\:U) analogLib_presistor_schematic c=0 r=0.917498
    re973 (\84\:U \88\:U) analogLib_presistor_schematic c=0 r=0.118883
    re974 (\88\:U \89\:U) analogLib_presistor_schematic c=0 r=0.917498
    re975 (\90\:U \91\:U) analogLib_presistor_schematic c=0 r=2.24945
    re976 (\91\:U \92\:U) analogLib_presistor_schematic c=0 r=1.17015
    re977 (\92\:U \93\:U) analogLib_presistor_schematic c=0 r=1.17711
    re978 (\93\:U \94\:U) analogLib_presistor_schematic c=0 r=2.34726
    re979 (\94\:U \95\:U) analogLib_presistor_schematic c=0 r=1.15624
    re980 (\91\:U \96\:U) analogLib_presistor_schematic c=0 r=0.118883
    re981 (\96\:U \97\:U) analogLib_presistor_schematic c=0 r=0.917498
    re982 (\92\:U \98\:U) analogLib_presistor_schematic c=0 r=0.153977
    re983 (\98\:U \99\:U) analogLib_presistor_schematic c=0 r=0.917498
    re984 (\93\:U \100\:U) analogLib_presistor_schematic c=0 r=0.118883
    re985 (\100\:U \101\:U) analogLib_presistor_schematic c=0 r=0.917498
    re986 (\94\:U \102\:U) analogLib_presistor_schematic c=0 r=0.118883
    re987 (\102\:U \103\:U) analogLib_presistor_schematic c=0 r=0.917498
    re988 (\95\:U \104\:U) analogLib_presistor_schematic c=0 r=1.19101
    re989 (\104\:U \105\:U) analogLib_presistor_schematic c=0 r=2.24945
    re990 (\95\:U \106\:U) analogLib_presistor_schematic c=0 r=0.139076
    re991 (\106\:U \107\:U) analogLib_presistor_schematic c=0 r=0.917498
    re992 (\104\:U \108\:U) analogLib_presistor_schematic c=0 r=0.118883
    re993 (\108\:U \109\:U) analogLib_presistor_schematic c=0 r=0.917498
    re994 (\149\:GNDA \150\:GNDA) analogLib_presistor_schematic c=0 \
        r=0.593444
    re995 (\150\:GNDA \151\:GNDA) analogLib_presistor_schematic c=0 \
        r=0.025477
    re999 (\155\:GNDA \151\:GNDA) analogLib_presistor_schematic c=0 \
        r=0.009984
    re1001 (\151\:GNDA \157\:GNDA) analogLib_presistor_schematic c=0 \
        r=0.037666
    re1004 (\157\:GNDA \162\:GNDA) analogLib_presistor_schematic c=0 \
        r=0.037666
    re1007 (\162\:GNDA \167\:GNDA) analogLib_presistor_schematic c=0 \
        r=0.037666
    re1010 (\167\:GNDA \172\:GNDA) analogLib_presistor_schematic c=0 \
        r=0.037666
    re1013 (\172\:GNDA \177\:GNDA) analogLib_presistor_schematic c=0 \
        r=0.037666
    re1016 (\177\:GNDA \182\:GNDA) analogLib_presistor_schematic c=0 \
        r=0.037666
    re1019 (\182\:GNDA \187\:GNDA) analogLib_presistor_schematic c=0 \
        r=0.037666
    re1022 (\187\:GNDA \192\:GNDA) analogLib_presistor_schematic c=0 \
        r=0.037666
    re1024 (\192\:GNDA \195\:GNDA) analogLib_presistor_schematic c=0 \
        r=0.009884
    re1028 (\198\:GNDA \192\:GNDA) analogLib_presistor_schematic c=0 \
        r=0.009984
    re1030 (\192\:GNDA \200\:GNDA) analogLib_presistor_schematic c=0 \
        r=0.211542
    re1031 (\200\:GNDA \201\:GNDA) analogLib_presistor_schematic c=0 \
        r=0.090584
    re1032 (\201\:GNDA \202\:GNDA) analogLib_presistor_schematic c=0 \
        r=0.010437
    re1033 (\202\:GNDA \204\:GNDA) analogLib_presistor_schematic c=0 \
        r=0.028819
    re1034 (\204\:GNDA \205\:GNDA) analogLib_presistor_schematic c=0 \
        r=0.067933
    re1035 (\205\:GNDA \206\:GNDA) analogLib_presistor_schematic c=0 \
        r=0.103237
    re1036 (\206\:GNDA \207\:GNDA) analogLib_presistor_schematic c=0 \
        r=0.10404
    re1037 (\207\:GNDA \208\:GNDA) analogLib_presistor_schematic c=0 \
        r=0.067666
    re1038 (\208\:GNDA \209\:GNDA) analogLib_presistor_schematic c=0 \
        r=0.073015
    re1039 (\209\:GNDA \210\:GNDA) analogLib_presistor_schematic c=0 \
        r=0.052154
    re1040 (\210\:GNDA \211\:GNDA) analogLib_presistor_schematic c=0 \
        r=0.046537
    re1041 (\211\:GNDA \212\:GNDA) analogLib_presistor_schematic c=0 \
        r=0.064189
    re1042 (\212\:GNDA \213\:GNDA) analogLib_presistor_schematic c=0 \
        r=0.080865
    re1043 (\213\:GNDA \214\:GNDA) analogLib_presistor_schematic c=0 \
        r=0.021491
    re1044 (\214\:GNDA \215\:GNDA) analogLib_presistor_schematic c=0 \
        r=0.17117
    re1045 (\215\:GNDA \216\:GNDA) analogLib_presistor_schematic c=0 \
        r=0.17117
    re1046 (\216\:GNDA \217\:GNDA) analogLib_presistor_schematic c=0 \
        r=0.018555
    re1047 (\217\:GNDA \219\:GNDA) analogLib_presistor_schematic c=0 \
        r=0.103312
    re1048 (\219\:GNDA \220\:GNDA) analogLib_presistor_schematic c=0 \
        r=0.088195
    re1049 (\220\:GNDA \221\:GNDA) analogLib_presistor_schematic c=0 \
        r=0.135684
    re1050 (\221\:GNDA \222\:GNDA) analogLib_presistor_schematic c=0 \
        r=0.135684
    re1051 (\222\:GNDA \223\:GNDA) analogLib_presistor_schematic c=0 \
        r=0.064801
    re1052 (\223\:GNDA \224\:GNDA) analogLib_presistor_schematic c=0 \
        r=0.233359
    re1053 (\224\:GNDA \225\:GNDA) analogLib_presistor_schematic c=0 \
        r=0.087792
    re1054 (\225\:GNDA \226\:GNDA) analogLib_presistor_schematic c=0 \
        r=0.084484
    re1055 (\226\:GNDA \227\:GNDA) analogLib_presistor_schematic c=0 \
        r=0.17117
    re1056 (\227\:GNDA \228\:GNDA) analogLib_presistor_schematic c=0 \
        r=0.17331
    re1057 (\228\:GNDA \229\:GNDA) analogLib_presistor_schematic c=0 \
        r=0.099092
    re1058 (\229\:GNDA \231\:GNDA) analogLib_presistor_schematic c=0 \
        r=0.060043
    re1059 (\231\:GNDA \232\:GNDA) analogLib_presistor_schematic c=0 \
        r=0.055576
    re1060 (\232\:GNDA \233\:GNDA) analogLib_presistor_schematic c=0 \
        r=0.047579
    re1061 (\233\:GNDA \234\:GNDA) analogLib_presistor_schematic c=0 \
        r=0.111261
    re1062 (\234\:GNDA \235\:GNDA) analogLib_presistor_schematic c=0 \
        r=0.111261
    re1063 (\235\:GNDA \236\:GNDA) analogLib_presistor_schematic c=0 \
        r=0.111261
    re1064 (\236\:GNDA \237\:GNDA) analogLib_presistor_schematic c=0 \
        r=0.111261
    re1065 (\237\:GNDA \238\:GNDA) analogLib_presistor_schematic c=0 \
        r=0.111261
    re1066 (\238\:GNDA \239\:GNDA) analogLib_presistor_schematic c=0 \
        r=0.111261
    re1067 (\239\:GNDA \240\:GNDA) analogLib_presistor_schematic c=0 \
        r=0.088313
    re1068 (\240\:GNDA \241\:GNDA) analogLib_presistor_schematic c=0 \
        r=0.022948
    re1069 (\241\:GNDA \242\:GNDA) analogLib_presistor_schematic c=0 \
        r=0.111261
    re1070 (\242\:GNDA \243\:GNDA) analogLib_presistor_schematic c=0 \
        r=0.068495
    re1071 (\243\:GNDA \244\:GNDA) analogLib_presistor_schematic c=0 \
        r=0.042766
    re1072 (\244\:GNDA \245\:GNDA) analogLib_presistor_schematic c=0 \
        r=0.080664
    re1073 (\245\:GNDA \246\:GNDA) analogLib_presistor_schematic c=0 \
        r=0.030597
    re1074 (\246\:GNDA \247\:GNDA) analogLib_presistor_schematic c=0 \
        r=0.111261
    re1075 (\247\:GNDA \248\:GNDA) analogLib_presistor_schematic c=0 \
        r=0.111261
    re1076 (\248\:GNDA \249\:GNDA) analogLib_presistor_schematic c=0 \
        r=0.111261
    re1077 (\249\:GNDA \250\:GNDA) analogLib_presistor_schematic c=0 \
        r=0.026701
    re1078 (\250\:GNDA GNDA) analogLib_presistor_schematic c=0 r=0.019399
    re1079 (GNDA \251\:GNDA) analogLib_presistor_schematic c=0 r=0.491776
    re1080 (\251\:GNDA \252\:GNDA) analogLib_presistor_schematic c=0 \
        r=1.58944
    re1081 (\252\:GNDA \253\:GNDA) analogLib_presistor_schematic c=0 \
        r=1.58944
    re1082 (\253\:GNDA \254\:GNDA) analogLib_presistor_schematic c=0 \
        r=1.58944
    re1083 (\254\:GNDA \255\:GNDA) analogLib_presistor_schematic c=0 \
        r=1.58944
    re1084 (\255\:GNDA \256\:GNDA) analogLib_presistor_schematic c=0 \
        r=1.58944
    re1085 (\256\:GNDA \257\:GNDA) analogLib_presistor_schematic c=0 \
        r=1.58944
    re1086 (\257\:GNDA \258\:GNDA) analogLib_presistor_schematic c=0 \
        r=1.58944
    re1087 (\258\:GNDA \259\:GNDA) analogLib_presistor_schematic c=0 \
        r=1.58944
    re1088 (\259\:GNDA \260\:GNDA) analogLib_presistor_schematic c=0 \
        r=1.58944
    re1089 (\260\:GNDA \261\:GNDA) analogLib_presistor_schematic c=0 \
        r=1.58944
    re1090 (\261\:GNDA \262\:GNDA) analogLib_presistor_schematic c=0 \
        r=1.58944
    re1091 (\262\:GNDA \263\:GNDA) analogLib_presistor_schematic c=0 \
        r=1.58944
    re1092 (\263\:GNDA \264\:GNDA) analogLib_presistor_schematic c=0 \
        r=1.58944
    re1093 (\264\:GNDA \265\:GNDA) analogLib_presistor_schematic c=0 \
        r=1.58944
    re1094 (\265\:GNDA \266\:GNDA) analogLib_presistor_schematic c=0 \
        r=1.58944
    re1095 (\266\:GNDA \267\:GNDA) analogLib_presistor_schematic c=0 \
        r=1.11261
    re1096 (\267\:GNDA \268\:GNDA) analogLib_presistor_schematic c=0 \
        r=1.08813
    re1097 (\268\:GNDA \269\:GNDA) analogLib_presistor_schematic c=0 \
        r=1.59316
    re1098 (\269\:GNDA \270\:GNDA) analogLib_presistor_schematic c=0 \
        r=1.58944
    re1099 (\270\:GNDA \271\:GNDA) analogLib_presistor_schematic c=0 \
        r=1.58944
    re1100 (\271\:GNDA \272\:GNDA) analogLib_presistor_schematic c=0 \
        r=1.58944
    re1101 (\272\:GNDA \273\:GNDA) analogLib_presistor_schematic c=0 \
        r=1.58944
    re1102 (\273\:GNDA \274\:GNDA) analogLib_presistor_schematic c=0 \
        r=1.58944
    re1103 (\274\:GNDA \275\:GNDA) analogLib_presistor_schematic c=0 \
        r=1.58944
    re1104 (\275\:GNDA \276\:GNDA) analogLib_presistor_schematic c=0 \
        r=1.58944
    re1105 (\276\:GNDA \277\:GNDA) analogLib_presistor_schematic c=0 \
        r=1.58944
    re1106 (\277\:GNDA \278\:GNDA) analogLib_presistor_schematic c=0 \
        r=1.58944
    re1107 (\278\:GNDA \279\:GNDA) analogLib_presistor_schematic c=0 \
        r=1.58944
    re1108 (\279\:GNDA \280\:GNDA) analogLib_presistor_schematic c=0 \
        r=1.59441
    re1109 (\280\:GNDA \281\:GNDA) analogLib_presistor_schematic c=0 \
        r=1.59441
    re1110 (\281\:GNDA \282\:GNDA) analogLib_presistor_schematic c=0 \
        r=1.58944
    re1111 (\282\:GNDA \283\:GNDA) analogLib_presistor_schematic c=0 \
        r=1.58944
    re1112 (\283\:GNDA \284\:GNDA) analogLib_presistor_schematic c=0 \
        r=1.58944
    re1113 (\284\:GNDA \285\:GNDA) analogLib_presistor_schematic c=0 \
        r=1.58944
    re1114 (\285\:GNDA \286\:GNDA) analogLib_presistor_schematic c=0 \
        r=1.58944
    re1115 (\286\:GNDA \287\:GNDA) analogLib_presistor_schematic c=0 \
        r=1.58944
    re1116 (\287\:GNDA \288\:GNDA) analogLib_presistor_schematic c=0 \
        r=1.58944
    re1117 (\288\:GNDA \289\:GNDA) analogLib_presistor_schematic c=0 \
        r=1.58944
    re1118 (\289\:GNDA \290\:GNDA) analogLib_presistor_schematic c=0 \
        r=1.58944
    re1119 (\290\:GNDA \291\:GNDA) analogLib_presistor_schematic c=0 \
        r=1.58944
    re1120 (\291\:GNDA \292\:GNDA) analogLib_presistor_schematic c=0 \
        r=1.58944
    re1121 (\292\:GNDA \293\:GNDA) analogLib_presistor_schematic c=0 \
        r=1.19208
    re1122 (\293\:GNDA \294\:GNDA) analogLib_presistor_schematic c=0 \
        r=0.684563
    re1123 (\294\:GNDA \295\:GNDA) analogLib_presistor_schematic c=0 \
        r=1.11261
    re1124 (\295\:GNDA \296\:GNDA) analogLib_presistor_schematic c=0 \
        r=1.58944
    re1125 (\296\:GNDA \297\:GNDA) analogLib_presistor_schematic c=0 \
        r=1.58944
    re1126 (\297\:GNDA \298\:GNDA) analogLib_presistor_schematic c=0 \
        r=1.58944
    re1127 (\298\:GNDA \299\:GNDA) analogLib_presistor_schematic c=0 \
        r=1.58944
    re1128 (\299\:GNDA \300\:GNDA) analogLib_presistor_schematic c=0 \
        r=1.58944
    re1129 (\300\:GNDA \301\:GNDA) analogLib_presistor_schematic c=0 \
        r=1.58944
    re1130 (\301\:GNDA \302\:GNDA) analogLib_presistor_schematic c=0 \
        r=1.58944
    re1131 (\302\:GNDA \303\:GNDA) analogLib_presistor_schematic c=0 \
        r=1.58944
    re1132 (\303\:GNDA \304\:GNDA) analogLib_presistor_schematic c=0 \
        r=1.58944
    re1133 (\304\:GNDA \305\:GNDA) analogLib_presistor_schematic c=0 \
        r=1.58944
    re1134 (\305\:GNDA \306\:GNDA) analogLib_presistor_schematic c=0 \
        r=1.58944
    re1135 (\306\:GNDA \307\:GNDA) analogLib_presistor_schematic c=0 \
        r=1.58944
    re1136 (\307\:GNDA \308\:GNDA) analogLib_presistor_schematic c=0 \
        r=1.58944
    re1137 (\308\:GNDA \309\:GNDA) analogLib_presistor_schematic c=0 \
        r=1.58944
    re1138 (\309\:GNDA \310\:GNDA) analogLib_presistor_schematic c=0 \
        r=1.58944
    re1139 (\310\:GNDA \311\:GNDA) analogLib_presistor_schematic c=0 \
        r=0.510777
    re1140 (\311\:GNDA \312\:GNDA) analogLib_presistor_schematic c=0 \
        r=0.084054
    re1141 (\312\:GNDA \313\:GNDA) analogLib_presistor_schematic c=0 \
        r=0.111261
    re1142 (\313\:GNDA \314\:GNDA) analogLib_presistor_schematic c=0 \
        r=0.089781
    re1144 (\314\:GNDA \316\:GNDA) analogLib_presistor_schematic c=0 \
        r=0.111261
    re1145 (\316\:GNDA \317\:GNDA) analogLib_presistor_schematic c=0 \
        r=0.078578
    re1146 (\317\:GNDA \318\:GNDA) analogLib_presistor_schematic c=0 \
        r=0.032683
    re1147 (\318\:GNDA \319\:GNDA) analogLib_presistor_schematic c=0 \
        r=0.111261
    re1148 (\319\:GNDA \320\:GNDA) analogLib_presistor_schematic c=0 \
        r=0.0113
    re1149 (\320\:GNDA \321\:GNDA) analogLib_presistor_schematic c=0 \
        r=0.035638
    re1150 (\321\:GNDA \322\:GNDA) analogLib_presistor_schematic c=0 \
        r=0.064323
    re1151 (\322\:GNDA \323\:GNDA) analogLib_presistor_schematic c=0 \
        r=0.111261
    re1152 (\323\:GNDA \324\:GNDA) analogLib_presistor_schematic c=0 \
        r=0.015136
    re1153 (\324\:GNDA \325\:GNDA) analogLib_presistor_schematic c=0 \
        r=0.153463
    re1154 (\324\:GNDA \326\:GNDA) analogLib_presistor_schematic c=0 \
        r=0.245972
    re1155 (\326\:GNDA \327\:GNDA) analogLib_presistor_schematic c=0 \
        r=0.101048
    re1156 (\327\:GNDA \328\:GNDA) analogLib_presistor_schematic c=0 \
        r=0.209805
    re1157 (\328\:GNDA \329\:GNDA) analogLib_presistor_schematic c=0 \
        r=0.156681
    re1158 (\329\:GNDA \330\:GNDA) analogLib_presistor_schematic c=0 \
        r=0.177419
    re1159 (\330\:GNDA \331\:GNDA) analogLib_presistor_schematic c=0 \
        r=0.185519
    re1160 (\331\:GNDA \332\:GNDA) analogLib_presistor_schematic c=0 \
        r=0.185519
    re1161 (\332\:GNDA \333\:GNDA) analogLib_presistor_schematic c=0 \
        r=0.185519
    re1162 (\333\:GNDA \334\:GNDA) analogLib_presistor_schematic c=0 \
        r=0.666448
    re1163 (\334\:GNDA \335\:GNDA) analogLib_presistor_schematic c=0 \
        r=1.58944
    re1164 (\335\:GNDA \336\:GNDA) analogLib_presistor_schematic c=0 \
        r=1.04323
    re1166 (\336\:GNDA \338\:GNDA) analogLib_presistor_schematic c=0 \
        r=0.386446
    re1167 (\338\:GNDA \339\:GNDA) analogLib_presistor_schematic c=0 \
        r=1.57081
    re1168 (\339\:GNDA \340\:GNDA) analogLib_presistor_schematic c=0 \
        r=1.26907
    re1169 (\340\:GNDA \341\:GNDA) analogLib_presistor_schematic c=0 \
        r=1.25701
    re1170 (\341\:GNDA \342\:GNDA) analogLib_presistor_schematic c=0 \
        r=1.58944
    re1171 (\342\:GNDA \343\:GNDA) analogLib_presistor_schematic c=0 \
        r=1.58944
    re1172 (\343\:GNDA \344\:GNDA) analogLib_presistor_schematic c=0 \
        r=1.00917
    re1173 (\344\:GNDA \345\:GNDA) analogLib_presistor_schematic c=0 \
        r=0.577042
    re1174 (\345\:GNDA \346\:GNDA) analogLib_presistor_schematic c=0 \
        r=1.58944
    re1175 (\346\:GNDA \347\:GNDA) analogLib_presistor_schematic c=0 \
        r=1.60186
    re1176 (\347\:GNDA \348\:GNDA) analogLib_presistor_schematic c=0 \
        r=1.05425
    re1177 (\348\:GNDA \349\:GNDA) analogLib_presistor_schematic c=0 \
        r=1.01523
    re1178 (\349\:GNDA \350\:GNDA) analogLib_presistor_schematic c=0 \
        r=0.868229
    re1179 (\350\:GNDA \351\:GNDA) analogLib_presistor_schematic c=0 \
        r=0.990113
    re1180 (\351\:GNDA \352\:GNDA) analogLib_presistor_schematic c=0 \
        r=1.17519
    re1181 (\352\:GNDA \353\:GNDA) analogLib_presistor_schematic c=0 \
        r=1.17519
    re1182 (\353\:GNDA \354\:GNDA) analogLib_presistor_schematic c=0 \
        r=1.17519
    re1183 (\354\:GNDA \355\:GNDA) analogLib_presistor_schematic c=0 \
        r=1.17519
    re1184 (\355\:GNDA \356\:GNDA) analogLib_presistor_schematic c=0 \
        r=1.17519
    re1185 (\356\:GNDA \357\:GNDA) analogLib_presistor_schematic c=0 \
        r=1.17519
    re1186 (\357\:GNDA \358\:GNDA) analogLib_presistor_schematic c=0 \
        r=1.17519
    re1187 (\358\:GNDA \359\:GNDA) analogLib_presistor_schematic c=0 \
        r=1.17363
    re1188 (\359\:GNDA \360\:GNDA) analogLib_presistor_schematic c=0 \
        r=0.140901
    re1189 (\360\:GNDA \361\:GNDA) analogLib_presistor_schematic c=0 \
        r=0.04967
    re1190 (\361\:GNDA \362\:GNDA) analogLib_presistor_schematic c=0 \
        r=0.04967
    re1191 (\362\:GNDA \360\:GNDA) analogLib_presistor_schematic c=0 \
        r=0.049769
    re1192 (\364\:GNDA \360\:GNDA) analogLib_presistor_schematic c=0 \
        r=0.009984
    re1194 (\360\:GNDA \367\:GNDA) analogLib_presistor_schematic c=0 \
        r=0.630602
    re1195 (\367\:GNDA \368\:GNDA) analogLib_presistor_schematic c=0 \
        r=0.865858
    re1196 (\368\:GNDA \369\:GNDA) analogLib_presistor_schematic c=0 \
        r=0.298116
    re1197 (\369\:GNDA \370\:GNDA) analogLib_presistor_schematic c=0 \
        r=0.216161
    re1198 (\370\:GNDA \371\:GNDA) analogLib_presistor_schematic c=0 \
        r=0.868342
    re1199 (\371\:GNDA \360\:GNDA) analogLib_presistor_schematic c=0 \
        r=0.630602
    re1200 (\360\:GNDA \372\:GNDA) analogLib_presistor_schematic c=0 \
        r=0.037666
    re1202 (\372\:GNDA \375\:GNDA) analogLib_presistor_schematic c=0 \
        r=0.009984
    re1203 (\372\:GNDA \376\:GNDA) analogLib_presistor_schematic c=0 \
        r=0.043548
    re1204 (\376\:GNDA \377\:GNDA) analogLib_presistor_schematic c=0 \
        r=0.043461
    re1205 (\377\:GNDA \372\:GNDA) analogLib_presistor_schematic c=0 \
        r=0.043461
    re1206 (\372\:GNDA \378\:GNDA) analogLib_presistor_schematic c=0 \
        r=0.035707
    re1207 (\378\:GNDA \380\:GNDA) analogLib_presistor_schematic c=0 \
        r=0.292392
    re1208 (\380\:GNDA \381\:GNDA) analogLib_presistor_schematic c=0 \
        r=0.865858
    re1209 (\381\:GNDA \372\:GNDA) analogLib_presistor_schematic c=0 \
        r=0.630602
    re1212 (\372\:GNDA \384\:GNDA) analogLib_presistor_schematic c=0 \
        r=0.037666
    re1214 (\384\:GNDA \387\:GNDA) analogLib_presistor_schematic c=0 \
        r=0.009984
    re1215 (\384\:GNDA \388\:GNDA) analogLib_presistor_schematic c=0 \
        r=0.043548
    re1216 (\388\:GNDA \389\:GNDA) analogLib_presistor_schematic c=0 \
        r=0.043461
    re1217 (\389\:GNDA \384\:GNDA) analogLib_presistor_schematic c=0 \
        r=0.043461
    re1218 (\384\:GNDA \390\:GNDA) analogLib_presistor_schematic c=0 \
        r=0.032388
    re1219 (\390\:GNDA \392\:GNDA) analogLib_presistor_schematic c=0 \
        r=0.271442
    re1220 (\392\:GNDA \393\:GNDA) analogLib_presistor_schematic c=0 \
        r=0.865858
    re1221 (\393\:GNDA \384\:GNDA) analogLib_presistor_schematic c=0 \
        r=0.630602
    re1224 (\384\:GNDA \396\:GNDA) analogLib_presistor_schematic c=0 \
        r=0.037666
    re1226 (\396\:GNDA \399\:GNDA) analogLib_presistor_schematic c=0 \
        r=0.009984
    re1227 (\396\:GNDA \400\:GNDA) analogLib_presistor_schematic c=0 \
        r=0.202705
    re1228 (\400\:GNDA \402\:GNDA) analogLib_presistor_schematic c=0 \
        r=0.171538
    re1229 (\402\:GNDA \403\:GNDA) analogLib_presistor_schematic c=0 \
        r=0.865858
    re1230 (\403\:GNDA \396\:GNDA) analogLib_presistor_schematic c=0 \
        r=0.630602
    re1233 (\396\:GNDA \406\:GNDA) analogLib_presistor_schematic c=0 \
        r=0.630602
    re1234 (\406\:GNDA \407\:GNDA) analogLib_presistor_schematic c=0 \
        r=0.868342
    re1235 (\407\:GNDA \408\:GNDA) analogLib_presistor_schematic c=0 \
        r=0.109398
    re1236 (\408\:GNDA \409\:GNDA) analogLib_presistor_schematic c=0 \
        r=0.225699
    re1237 (\409\:GNDA \410\:GNDA) analogLib_presistor_schematic c=0 \
        r=0.236115
    re1238 (\410\:GNDA \396\:GNDA) analogLib_presistor_schematic c=0 \
        r=0.024785
    re1240 (\396\:GNDA \412\:GNDA) analogLib_presistor_schematic c=0 \
        r=0.037666
    re1242 (\412\:GNDA \415\:GNDA) analogLib_presistor_schematic c=0 \
        r=0.009984
    re1243 (\412\:GNDA \416\:GNDA) analogLib_presistor_schematic c=0 \
        r=0.043548
    re1244 (\416\:GNDA \417\:GNDA) analogLib_presistor_schematic c=0 \
        r=0.043461
    re1245 (\417\:GNDA \412\:GNDA) analogLib_presistor_schematic c=0 \
        r=0.043461
    re1246 (\412\:GNDA \418\:GNDA) analogLib_presistor_schematic c=0 \
        r=0.032566
    re1247 (\418\:GNDA \420\:GNDA) analogLib_presistor_schematic c=0 \
        r=0.265659
    re1248 (\420\:GNDA \421\:GNDA) analogLib_presistor_schematic c=0 \
        r=0.865858
    re1249 (\421\:GNDA \412\:GNDA) analogLib_presistor_schematic c=0 \
        r=0.630602
    re1252 (\412\:GNDA \424\:GNDA) analogLib_presistor_schematic c=0 \
        r=0.037666
    re1254 (\424\:GNDA \427\:GNDA) analogLib_presistor_schematic c=0 \
        r=0.009984
    re1255 (\424\:GNDA \428\:GNDA) analogLib_presistor_schematic c=0 \
        r=0.043548
    re1256 (\428\:GNDA \429\:GNDA) analogLib_presistor_schematic c=0 \
        r=0.043461
    re1257 (\429\:GNDA \424\:GNDA) analogLib_presistor_schematic c=0 \
        r=0.043461
    re1258 (\424\:GNDA \430\:GNDA) analogLib_presistor_schematic c=0 \
        r=0.038496
    re1259 (\430\:GNDA \432\:GNDA) analogLib_presistor_schematic c=0 \
        r=0.297613
    re1260 (\432\:GNDA \433\:GNDA) analogLib_presistor_schematic c=0 \
        r=0.865858
    re1261 (\433\:GNDA \424\:GNDA) analogLib_presistor_schematic c=0 \
        r=0.630602
    re1264 (\424\:GNDA \436\:GNDA) analogLib_presistor_schematic c=0 \
        r=0.037666
    re1266 (\436\:GNDA \439\:GNDA) analogLib_presistor_schematic c=0 \
        r=0.009984
    re1267 (\436\:GNDA \440\:GNDA) analogLib_presistor_schematic c=0 \
        r=0.049769
    re1268 (\440\:GNDA \441\:GNDA) analogLib_presistor_schematic c=0 \
        r=0.04967
    re1269 (\441\:GNDA \436\:GNDA) analogLib_presistor_schematic c=0 \
        r=0.04967
    re1270 (\436\:GNDA \442\:GNDA) analogLib_presistor_schematic c=0 \
        r=0.035707
    re1271 (\442\:GNDA \444\:GNDA) analogLib_presistor_schematic c=0 \
        r=0.277491
    re1272 (\444\:GNDA \445\:GNDA) analogLib_presistor_schematic c=0 \
        r=0.865858
    re1273 (\445\:GNDA \436\:GNDA) analogLib_presistor_schematic c=0 \
        r=0.630602
    re1276 (\436\:GNDA \448\:GNDA) analogLib_presistor_schematic c=0 \
        r=0.037666
    re1278 (\448\:GNDA \451\:GNDA) analogLib_presistor_schematic c=0 \
        r=0.009984
    re1279 (\448\:GNDA \452\:GNDA) analogLib_presistor_schematic c=0 \
        r=0.046451
    re1280 (\452\:GNDA \453\:GNDA) analogLib_presistor_schematic c=0 \
        r=0.046359
    re1281 (\453\:GNDA \448\:GNDA) analogLib_presistor_schematic c=0 \
        r=0.046359
    re1282 (\448\:GNDA \454\:GNDA) analogLib_presistor_schematic c=0 \
        r=0.035282
    re1283 (\454\:GNDA \456\:GNDA) analogLib_presistor_schematic c=0 \
        r=0.281594
    re1284 (\456\:GNDA \457\:GNDA) analogLib_presistor_schematic c=0 \
        r=0.865858
    re1285 (\457\:GNDA \448\:GNDA) analogLib_presistor_schematic c=0 \
        r=0.630602
    re1288 (\448\:GNDA \460\:GNDA) analogLib_presistor_schematic c=0 \
        r=0.037666
    re1290 (\460\:GNDA \463\:GNDA) analogLib_presistor_schematic c=0 \
        r=0.009984
    re1291 (\460\:GNDA \464\:GNDA) analogLib_presistor_schematic c=0 \
        r=0.046451
    re1292 (\464\:GNDA \465\:GNDA) analogLib_presistor_schematic c=0 \
        r=0.046359
    re1293 (\465\:GNDA \460\:GNDA) analogLib_presistor_schematic c=0 \
        r=0.046359
    re1294 (\460\:GNDA \466\:GNDA) analogLib_presistor_schematic c=0 \
        r=0.032928
    re1295 (\466\:GNDA \468\:GNDA) analogLib_presistor_schematic c=0 \
        r=0.261544
    re1296 (\468\:GNDA \469\:GNDA) analogLib_presistor_schematic c=0 \
        r=0.865858
    re1297 (\469\:GNDA \460\:GNDA) analogLib_presistor_schematic c=0 \
        r=0.630602
    re1300 (\460\:GNDA \472\:GNDA) analogLib_presistor_schematic c=0 \
        r=0.197039
    re1302 (\157\:GNDA \158\:GNDA) analogLib_presistor_schematic c=0 \
        r=9.90141
    re1303 (\157\:GNDA \474\:GNDA) analogLib_presistor_schematic c=0 \
        r=0.630602
    re1304 (\474\:GNDA \475\:GNDA) analogLib_presistor_schematic c=0 \
        r=0.868342
    re1305 (\475\:GNDA \476\:GNDA) analogLib_presistor_schematic c=0 \
        r=0.331906
    re1306 (\157\:GNDA \477\:GNDA) analogLib_presistor_schematic c=0 \
        r=0.630602
    re1307 (\477\:GNDA \160\:GNDA) analogLib_presistor_schematic c=0 \
        r=6.80586
    re1309 (\157\:GNDA \158\:GNDA) analogLib_presistor_schematic c=0 \
        r=8.48686
    re1311 (\162\:GNDA \163\:GNDA) analogLib_presistor_schematic c=0 \
        r=9.90141
    re1312 (\162\:GNDA \480\:GNDA) analogLib_presistor_schematic c=0 \
        r=0.630602
    re1313 (\480\:GNDA \481\:GNDA) analogLib_presistor_schematic c=0 \
        r=0.868342
    re1314 (\481\:GNDA \482\:GNDA) analogLib_presistor_schematic c=0 \
        r=0.331906
    re1315 (\162\:GNDA \483\:GNDA) analogLib_presistor_schematic c=0 \
        r=0.630602
    re1316 (\483\:GNDA \165\:GNDA) analogLib_presistor_schematic c=0 \
        r=6.80586
    re1318 (\162\:GNDA \163\:GNDA) analogLib_presistor_schematic c=0 \
        r=8.48686
    re1320 (\167\:GNDA \168\:GNDA) analogLib_presistor_schematic c=0 \
        r=9.90141
    re1321 (\167\:GNDA \486\:GNDA) analogLib_presistor_schematic c=0 \
        r=0.630602
    re1322 (\486\:GNDA \487\:GNDA) analogLib_presistor_schematic c=0 \
        r=0.868342
    re1323 (\487\:GNDA \488\:GNDA) analogLib_presistor_schematic c=0 \
        r=0.331906
    re1324 (\167\:GNDA \489\:GNDA) analogLib_presistor_schematic c=0 \
        r=0.630602
    re1325 (\489\:GNDA \170\:GNDA) analogLib_presistor_schematic c=0 \
        r=6.80586
    re1327 (\167\:GNDA \168\:GNDA) analogLib_presistor_schematic c=0 \
        r=8.48686
    re1329 (\172\:GNDA \173\:GNDA) analogLib_presistor_schematic c=0 \
        r=9.90141
    re1330 (\172\:GNDA \492\:GNDA) analogLib_presistor_schematic c=0 \
        r=0.630602
    re1331 (\492\:GNDA \493\:GNDA) analogLib_presistor_schematic c=0 \
        r=0.868342
    re1332 (\493\:GNDA \494\:GNDA) analogLib_presistor_schematic c=0 \
        r=0.331906
    re1333 (\172\:GNDA \495\:GNDA) analogLib_presistor_schematic c=0 \
        r=0.630602
    re1334 (\495\:GNDA \175\:GNDA) analogLib_presistor_schematic c=0 \
        r=6.80586
    re1336 (\172\:GNDA \173\:GNDA) analogLib_presistor_schematic c=0 \
        r=8.48686
    re1338 (\177\:GNDA \178\:GNDA) analogLib_presistor_schematic c=0 \
        r=9.90141
    re1339 (\177\:GNDA \498\:GNDA) analogLib_presistor_schematic c=0 \
        r=0.630602
    re1340 (\498\:GNDA \499\:GNDA) analogLib_presistor_schematic c=0 \
        r=0.868342
    re1341 (\499\:GNDA \500\:GNDA) analogLib_presistor_schematic c=0 \
        r=0.331906
    re1342 (\177\:GNDA \501\:GNDA) analogLib_presistor_schematic c=0 \
        r=0.630602
    re1343 (\501\:GNDA \180\:GNDA) analogLib_presistor_schematic c=0 \
        r=6.80586
    re1345 (\177\:GNDA \178\:GNDA) analogLib_presistor_schematic c=0 \
        r=8.48686
    re1347 (\182\:GNDA \183\:GNDA) analogLib_presistor_schematic c=0 \
        r=9.90141
    re1348 (\182\:GNDA \504\:GNDA) analogLib_presistor_schematic c=0 \
        r=0.630602
    re1349 (\504\:GNDA \505\:GNDA) analogLib_presistor_schematic c=0 \
        r=0.868342
    re1350 (\505\:GNDA \506\:GNDA) analogLib_presistor_schematic c=0 \
        r=0.331906
    re1351 (\182\:GNDA \507\:GNDA) analogLib_presistor_schematic c=0 \
        r=0.630602
    re1352 (\507\:GNDA \185\:GNDA) analogLib_presistor_schematic c=0 \
        r=6.80586
    re1354 (\182\:GNDA \183\:GNDA) analogLib_presistor_schematic c=0 \
        r=8.48686
    re1356 (\187\:GNDA \188\:GNDA) analogLib_presistor_schematic c=0 \
        r=9.90141
    re1357 (\187\:GNDA \510\:GNDA) analogLib_presistor_schematic c=0 \
        r=0.630602
    re1358 (\510\:GNDA \511\:GNDA) analogLib_presistor_schematic c=0 \
        r=0.868342
    re1359 (\511\:GNDA \512\:GNDA) analogLib_presistor_schematic c=0 \
        r=0.331906
    re1360 (\187\:GNDA \513\:GNDA) analogLib_presistor_schematic c=0 \
        r=0.630602
    re1361 (\513\:GNDA \190\:GNDA) analogLib_presistor_schematic c=0 \
        r=6.80586
    re1363 (\187\:GNDA \188\:GNDA) analogLib_presistor_schematic c=0 \
        r=8.48686
    re1364 (\192\:GNDA \516\:GNDA) analogLib_presistor_schematic c=0 \
        r=0.630602
    re1365 (\516\:GNDA \517\:GNDA) analogLib_presistor_schematic c=0 \
        r=0.865858
    re1366 (\517\:GNDA \518\:GNDA) analogLib_presistor_schematic c=0 \
        r=0.334128
    re1367 (\518\:GNDA \519\:GNDA) analogLib_presistor_schematic c=0 \
        r=0.015748
    re1368 (\202\:GNDA \520\:GNDA) analogLib_presistor_schematic c=0 \
        r=0.063884
    re1369 (\520\:GNDA \522\:GNDA) analogLib_presistor_schematic c=0 \
        r=0.168851
    re1370 (\522\:GNDA \523\:GNDA) analogLib_presistor_schematic c=0 \
        r=0.460462
    re1371 (\523\:GNDA \524\:GNDA) analogLib_presistor_schematic c=0 \
        r=0.982224
    re1372 (\524\:GNDA \525\:GNDA) analogLib_presistor_schematic c=0 \
        r=1.56
    re1373 (\525\:GNDA \526\:GNDA) analogLib_presistor_schematic c=0 \
        r=1.60682
    re1374 (\526\:GNDA \527\:GNDA) analogLib_presistor_schematic c=0 \
        r=1.4305
    re1375 (\527\:GNDA \528\:GNDA) analogLib_presistor_schematic c=0 \
        r=1.38491
    re1376 (\528\:GNDA \529\:GNDA) analogLib_presistor_schematic c=0 \
        r=0.983466
    re1377 (\529\:GNDA \530\:GNDA) analogLib_presistor_schematic c=0 \
        r=0.408432
    re1378 (\530\:GNDA \531\:GNDA) analogLib_presistor_schematic c=0 \
        r=0.222634
    re1379 (\531\:GNDA \532\:GNDA) analogLib_presistor_schematic c=0 \
        r=0.268703
    re1380 (\532\:GNDA \533\:GNDA) analogLib_presistor_schematic c=0 \
        r=0.170374
    re1381 (\213\:GNDA \534\:GNDA) analogLib_presistor_schematic c=0 \
        r=0.067141
    re1382 (\534\:GNDA \536\:GNDA) analogLib_presistor_schematic c=0 \
        r=0.749631
    re1383 (\536\:GNDA \537\:GNDA) analogLib_presistor_schematic c=0 \
        r=0.220634
    re1384 (\223\:GNDA \26\:GNDA) analogLib_presistor_schematic c=0 \
        r=20.4725
    re1385 (\232\:GNDA \540\:GNDA) analogLib_presistor_schematic c=0 \
        r=0.723234
    re1386 (\540\:GNDA \541\:GNDA) analogLib_presistor_schematic c=0 \
        r=0.423165
    re1387 (\541\:GNDA \542\:GNDA) analogLib_presistor_schematic c=0 \
        r=0.548854
    re1388 (\542\:GNDA \543\:GNDA) analogLib_presistor_schematic c=0 \
        r=0.87295
    re1389 (\543\:GNDA \544\:GNDA) analogLib_presistor_schematic c=0 \
        r=0.378734
    re1390 (\544\:GNDA \545\:GNDA) analogLib_presistor_schematic c=0 \
        r=0.37625
    re1391 (\545\:GNDA \546\:GNDA) analogLib_presistor_schematic c=0 \
        r=0.871709
    re1392 (\546\:GNDA \547\:GNDA) analogLib_presistor_schematic c=0 \
        r=0.572282
    re1393 (\547\:GNDA \548\:GNDA) analogLib_presistor_schematic c=0 \
        r=0.170242
    re1394 (\250\:GNDA \549\:GNDA) analogLib_presistor_schematic c=0 \
        r=0.386356
    re1395 (\549\:GNDA \551\:GNDA) analogLib_presistor_schematic c=0 \
        r=0.813257
    re1396 (\551\:GNDA \552\:GNDA) analogLib_presistor_schematic c=0 \
        r=1.60931
    re1397 (\552\:GNDA \553\:GNDA) analogLib_presistor_schematic c=0 \
        r=1.58944
    re1398 (\553\:GNDA \554\:GNDA) analogLib_presistor_schematic c=0 \
        r=1.50997
    re1399 (\554\:GNDA \555\:GNDA) analogLib_presistor_schematic c=0 \
        r=1.49791
    re1400 (\555\:GNDA \556\:GNDA) analogLib_presistor_schematic c=0 \
        r=1.60558
    re1401 (\556\:GNDA \557\:GNDA) analogLib_presistor_schematic c=0 \
        r=1.58944
    re1402 (\557\:GNDA \558\:GNDA) analogLib_presistor_schematic c=0 \
        r=1.50997
    re1403 (\558\:GNDA \559\:GNDA) analogLib_presistor_schematic c=0 \
        r=1.41968
    re1404 (\559\:GNDA \560\:GNDA) analogLib_presistor_schematic c=0 \
        r=1.52984
    re1405 (\560\:GNDA \561\:GNDA) analogLib_presistor_schematic c=0 \
        r=1.51012
    re1406 (\561\:GNDA \562\:GNDA) analogLib_presistor_schematic c=0 \
        r=0.030906
    re1407 (\562\:GNDA \563\:GNDA) analogLib_presistor_schematic c=0 \
        r=1.37633
    re1408 (\323\:GNDA \564\:GNDA) analogLib_presistor_schematic c=0 \
        r=0.111261
    re1409 (\564\:GNDA \565\:GNDA) analogLib_presistor_schematic c=0 \
        r=0.066739
    re1410 (\325\:GNDA \566\:GNDA) analogLib_presistor_schematic c=0 \
        r=1.58444
    re1411 (\566\:GNDA \567\:GNDA) analogLib_presistor_schematic c=0 \
        r=0.790995
    re1412 (\324\:GNDA \21\:GNDA) analogLib_presistor_schematic c=0 \
        r=20.511
    re1413 (\326\:GNDA \321\:GNDA) analogLib_presistor_schematic c=0 \
        r=0.146141
    re1414 (\326\:GNDA \20\:GNDA) analogLib_presistor_schematic c=0 \
        r=20.5521
    re1415 (\327\:GNDA \19\:GNDA) analogLib_presistor_schematic c=0 \
        r=20.4478
    re1416 (\328\:GNDA \18\:GNDA) analogLib_presistor_schematic c=0 \
        r=20.4641
    re1417 (\329\:GNDA \572\:GNDA) analogLib_presistor_schematic c=0 \
        r=0.170341
    re1418 (\329\:GNDA \17\:GNDA) analogLib_presistor_schematic c=0 \
        r=20.2845
    re1419 (\330\:GNDA \16\:GNDA) analogLib_presistor_schematic c=0 \
        r=20.4434
    re1420 (\331\:GNDA \15\:GNDA) analogLib_presistor_schematic c=0 \
        r=20.4434
    re1421 (\332\:GNDA \14\:GNDA) analogLib_presistor_schematic c=0 \
        r=20.4434
    re1422 (\333\:GNDA \13\:GNDA) analogLib_presistor_schematic c=0 \
        r=20.4434
    re1423 (\336\:GNDA \314\:GNDA) analogLib_presistor_schematic c=0 \
        r=0.013203
    re1424 (\344\:GNDA \5\:GNDA) analogLib_presistor_schematic c=0 \
        r=20.4365
    re1425 (\349\:GNDA \579\:GNDA) analogLib_presistor_schematic c=0 \
        r=0.02033
    re1426 (\579\:GNDA \580\:GNDA) analogLib_presistor_schematic c=0 \
        r=0.045645
    re1427 (\580\:GNDA \581\:GNDA) analogLib_presistor_schematic c=0 \
        r=0.091291
    re1428 (\581\:GNDA \582\:GNDA) analogLib_presistor_schematic c=0 \
        r=0.091291
    re1429 (\582\:GNDA \583\:GNDA) analogLib_presistor_schematic c=0 \
        r=0.136936
    re1430 (\583\:GNDA \584\:GNDA) analogLib_presistor_schematic c=0 \
        r=0.091291
    re1431 (\584\:GNDA \585\:GNDA) analogLib_presistor_schematic c=0 \
        r=0.136936
    re1432 (\585\:GNDA \586\:GNDA) analogLib_presistor_schematic c=0 \
        r=0.091291
    re1433 (\586\:GNDA \587\:GNDA) analogLib_presistor_schematic c=0 \
        r=0.136936
    re1434 (\587\:GNDA \588\:GNDA) analogLib_presistor_schematic c=0 \
        r=0.088616
    re1435 (\588\:GNDA \589\:GNDA) analogLib_presistor_schematic c=0 \
        r=0.139611
    re1436 (\589\:GNDA \590\:GNDA) analogLib_presistor_schematic c=0 \
        r=0.088616
    re1437 (\590\:GNDA \591\:GNDA) analogLib_presistor_schematic c=0 \
        r=0.038617
    re1438 (\591\:GNDA \592\:GNDA) analogLib_presistor_schematic c=0 \
        r=0.132654
    re1439 (\592\:GNDA \593\:GNDA) analogLib_presistor_schematic c=0 \
        r=0.18255
    re1440 (\593\:GNDA \1\:GNDA) analogLib_presistor_schematic c=0 \
        r=0.432412
    re1441 (\359\:GNDA \594\:GNDA) analogLib_presistor_schematic c=0 \
        r=0.499979
    re1442 (\360\:GNDA \595\:GNDA) analogLib_presistor_schematic c=0 \
        r=0.095962
    re1443 (\369\:GNDA \596\:GNDA) analogLib_presistor_schematic c=0 \
        r=0.020623
    re1444 (\369\:GNDA \597\:GNDA) analogLib_presistor_schematic c=0 \
        r=0.593095
    re1448 (\360\:GNDA \601\:GNDA) analogLib_presistor_schematic c=0 \
        r=0.009884
    re1449 (\372\:GNDA \602\:GNDA) analogLib_presistor_schematic c=0 \
        r=0.049087
    re1450 (\378\:GNDA \603\:GNDA) analogLib_presistor_schematic c=0 \
        r=0.593596
    re1451 (\372\:GNDA \604\:GNDA) analogLib_presistor_schematic c=0 \
        r=0.630602
    re1452 (\604\:GNDA \605\:GNDA) analogLib_presistor_schematic c=0 \
        r=0.868342
    re1453 (\605\:GNDA \606\:GNDA) analogLib_presistor_schematic c=0 \
        r=0.05712
    re1455 (\372\:GNDA \608\:GNDA) analogLib_presistor_schematic c=0 \
        r=0.009884
    re1456 (\384\:GNDA \609\:GNDA) analogLib_presistor_schematic c=0 \
        r=0.048435
    re1457 (\390\:GNDA \610\:GNDA) analogLib_presistor_schematic c=0 \
        r=0.591569
    re1458 (\384\:GNDA \611\:GNDA) analogLib_presistor_schematic c=0 \
        r=0.630602
    re1459 (\611\:GNDA \612\:GNDA) analogLib_presistor_schematic c=0 \
        r=0.868342
    re1460 (\612\:GNDA \613\:GNDA) analogLib_presistor_schematic c=0 \
        r=0.053395
    re1462 (\384\:GNDA \615\:GNDA) analogLib_presistor_schematic c=0 \
        r=0.009884
    re1463 (\409\:GNDA \616\:GNDA) analogLib_presistor_schematic c=0 \
        r=0.042402
    re1464 (\616\:GNDA \617\:GNDA) analogLib_presistor_schematic c=0 \
        r=0.049086
    re1465 (\617\:GNDA \618\:GNDA) analogLib_presistor_schematic c=0 \
        r=0.079472
    re1466 (\412\:GNDA \619\:GNDA) analogLib_presistor_schematic c=0 \
        r=0.04847
    re1467 (\418\:GNDA \620\:GNDA) analogLib_presistor_schematic c=0 \
        r=0.591681
    re1468 (\412\:GNDA \621\:GNDA) analogLib_presistor_schematic c=0 \
        r=0.630602
    re1469 (\621\:GNDA \622\:GNDA) analogLib_presistor_schematic c=0 \
        r=0.868342
    re1470 (\622\:GNDA \623\:GNDA) analogLib_presistor_schematic c=0 \
        r=0.05712
    re1472 (\412\:GNDA \625\:GNDA) analogLib_presistor_schematic c=0 \
        r=0.009884
    re1473 (\424\:GNDA \626\:GNDA) analogLib_presistor_schematic c=0 \
        r=0.049637
    re1474 (\430\:GNDA \627\:GNDA) analogLib_presistor_schematic c=0 \
        r=0.595193
    re1475 (\424\:GNDA \628\:GNDA) analogLib_presistor_schematic c=0 \
        r=0.630602
    re1476 (\628\:GNDA \629\:GNDA) analogLib_presistor_schematic c=0 \
        r=0.868342
    re1477 (\629\:GNDA \630\:GNDA) analogLib_presistor_schematic c=0 \
        r=0.064571
    re1479 (\424\:GNDA \632\:GNDA) analogLib_presistor_schematic c=0 \
        r=0.001412
    re1480 (\436\:GNDA \633\:GNDA) analogLib_presistor_schematic c=0 \
        r=0.050712
    re1481 (\442\:GNDA \634\:GNDA) analogLib_presistor_schematic c=0 \
        r=0.593596
    re1482 (\436\:GNDA \635\:GNDA) analogLib_presistor_schematic c=0 \
        r=0.630602
    re1483 (\635\:GNDA \636\:GNDA) analogLib_presistor_schematic c=0 \
        r=0.868342
    re1484 (\636\:GNDA \637\:GNDA) analogLib_presistor_schematic c=0 \
        r=0.064571
    re1486 (\436\:GNDA \639\:GNDA) analogLib_presistor_schematic c=0 \
        r=0.001412
    re1487 (\448\:GNDA \640\:GNDA) analogLib_presistor_schematic c=0 \
        r=0.049821
    re1488 (\454\:GNDA \641\:GNDA) analogLib_presistor_schematic c=0 \
        r=0.593344
    re1489 (\448\:GNDA \642\:GNDA) analogLib_presistor_schematic c=0 \
        r=0.630602
    re1490 (\642\:GNDA \643\:GNDA) analogLib_presistor_schematic c=0 \
        r=0.868342
    re1491 (\643\:GNDA \644\:GNDA) analogLib_presistor_schematic c=0 \
        r=0.060846
    re1493 (\448\:GNDA \646\:GNDA) analogLib_presistor_schematic c=0 \
        r=0.009884
    re1494 (\460\:GNDA \647\:GNDA) analogLib_presistor_schematic c=0 \
        r=0.049388
    re1495 (\466\:GNDA \648\:GNDA) analogLib_presistor_schematic c=0 \
        r=0.591908
    re1496 (\460\:GNDA \649\:GNDA) analogLib_presistor_schematic c=0 \
        r=0.630602
    re1497 (\649\:GNDA \650\:GNDA) analogLib_presistor_schematic c=0 \
        r=0.868342
    re1498 (\650\:GNDA \651\:GNDA) analogLib_presistor_schematic c=0 \
        r=0.060846
    re1500 (\460\:GNDA \653\:GNDA) analogLib_presistor_schematic c=0 \
        r=0.009884
    re1501 (\472\:GNDA \654\:GNDA) analogLib_presistor_schematic c=0 \
        r=1.03601
    re1502 (\654\:GNDA \655\:GNDA) analogLib_presistor_schematic c=0 \
        r=0.077264
    re1503 (\472\:GNDA \656\:GNDA) analogLib_presistor_schematic c=0 \
        r=0.988985
    re1504 (\656\:GNDA \657\:GNDA) analogLib_presistor_schematic c=0 \
        r=0.082672
    re1505 (\657\:GNDA \658\:GNDA) analogLib_presistor_schematic c=0 \
        r=0.186912
    re1507 (\658\:GNDA \661\:GNDA) analogLib_presistor_schematic c=0 \
        r=0.009884
    re1511 (\518\:GNDA \664\:GNDA) analogLib_presistor_schematic c=0 \
        r=0.598086
    re1512 (\518\:GNDA \665\:GNDA) analogLib_presistor_schematic c=0 \
        r=0.254656
    re1513 (\665\:GNDA \666\:GNDA) analogLib_presistor_schematic c=0 \
        r=0.868342
    re1514 (\666\:GNDA \192\:GNDA) analogLib_presistor_schematic c=0 \
        r=0.630602
    re1517 (\519\:GNDA \192\:GNDA) analogLib_presistor_schematic c=0 \
        r=0.016084
    re1518 (\520\:GNDA \669\:GNDA) analogLib_presistor_schematic c=0 \
        r=4.98549
    re1519 (\531\:GNDA \670\:GNDA) analogLib_presistor_schematic c=0 \
        r=4.97072
    re1520 (\532\:GNDA \671\:GNDA) analogLib_presistor_schematic c=0 \
        r=4.98403
    re1521 (\533\:GNDA \520\:GNDA) analogLib_presistor_schematic c=0 \
        r=0.19036
    re1522 (\533\:GNDA \672\:GNDA) analogLib_presistor_schematic c=0 \
        r=4.98856
    re1523 (\533\:GNDA \201\:GNDA) analogLib_presistor_schematic c=0 \
        r=0.053831
    re1524 (\537\:GNDA \673\:GNDA) analogLib_presistor_schematic c=0 \
        r=1.06999
    re1525 (\673\:GNDA \674\:GNDA) analogLib_presistor_schematic c=0 \
        r=1.57607
    re1526 (\674\:GNDA \675\:GNDA) analogLib_presistor_schematic c=0 \
        r=0.015453
    re1527 (\546\:GNDA \676\:GNDA) analogLib_presistor_schematic c=0 \
        r=0.188632
    re1528 (\547\:GNDA \677\:GNDA) analogLib_presistor_schematic c=0 \
        r=0.080041
    re1529 (\547\:GNDA \678\:GNDA) analogLib_presistor_schematic c=0 \
        r=0.148524
    re1530 (\548\:GNDA \540\:GNDA) analogLib_presistor_schematic c=0 \
        r=0.373475
    re1531 (\563\:GNDA \679\:GNDA) analogLib_presistor_schematic c=0 \
        r=0.841656
    re1532 (\679\:GNDA \680\:GNDA) analogLib_presistor_schematic c=0 \
        r=1.52611
    re1533 (\680\:GNDA \681\:GNDA) analogLib_presistor_schematic c=0 \
        r=1.58944
    re1534 (\681\:GNDA \682\:GNDA) analogLib_presistor_schematic c=0 \
        r=1.58944
    re1535 (\682\:GNDA \683\:GNDA) analogLib_presistor_schematic c=0 \
        r=0.223515
    re1536 (\563\:GNDA \685\:GNDA) analogLib_presistor_schematic c=0 \
        r=0.017516
    re1537 (\685\:GNDA \686\:GNDA) analogLib_presistor_schematic c=0 \
        r=0.625438
    re1538 (\686\:GNDA \687\:GNDA) analogLib_presistor_schematic c=0 \
        r=0.259266
    re1539 (\687\:GNDA \688\:GNDA) analogLib_presistor_schematic c=0 \
        r=1.30601
    re1540 (\688\:GNDA \689\:GNDA) analogLib_presistor_schematic c=0 \
        r=0.021861
    re1541 (\565\:GNDA \231\:GNDA) analogLib_presistor_schematic c=0 \
        r=0.044522
    re1542 (\567\:GNDA \229\:GNDA) analogLib_presistor_schematic c=0 \
        r=0.105769
    re1543 (\572\:GNDA \320\:GNDA) analogLib_presistor_schematic c=0 \
        r=0.21093
    re1544 (\591\:GNDA \690\:GNDA) analogLib_presistor_schematic c=0 \
        r=0.098705
    re1545 (\690\:GNDA \691\:GNDA) analogLib_presistor_schematic c=0 \
        r=0.090934
    re1546 (\691\:GNDA \692\:GNDA) analogLib_presistor_schematic c=0 \
        r=0.137293
    re1547 (\692\:GNDA \693\:GNDA) analogLib_presistor_schematic c=0 \
        r=0.090934
    re1548 (\693\:GNDA \694\:GNDA) analogLib_presistor_schematic c=0 \
        r=0.137293
    re1549 (\694\:GNDA \695\:GNDA) analogLib_presistor_schematic c=0 \
        r=0.090934
    re1550 (\695\:GNDA \696\:GNDA) analogLib_presistor_schematic c=0 \
        r=0.137293
    re1551 (\696\:GNDA \697\:GNDA) analogLib_presistor_schematic c=0 \
        r=0.092896
    re1552 (\697\:GNDA \698\:GNDA) analogLib_presistor_schematic c=0 \
        r=0.138006
    re1553 (\698\:GNDA \699\:GNDA) analogLib_presistor_schematic c=0 \
        r=0.090043
    re1554 (\593\:GNDA \3\:GNDA) analogLib_presistor_schematic c=0 \
        r=0.357079
    re1555 (\594\:GNDA \217\:GNDA) analogLib_presistor_schematic c=0 \
        r=0.733335
    re1556 (\595\:GNDA \215\:GNDA) analogLib_presistor_schematic c=0 \
        r=0.091452
    re1557 (\596\:GNDA \360\:GNDA) analogLib_presistor_schematic c=0 \
        r=0.014243
    re1558 (\601\:GNDA \360\:GNDA) analogLib_presistor_schematic c=0 \
        r=0.355678
    re1559 (\602\:GNDA \358\:GNDA) analogLib_presistor_schematic c=0 \
        r=0.056013
    re1560 (\606\:GNDA \378\:GNDA) analogLib_presistor_schematic c=0 \
        r=0.168217
    re1561 (\609\:GNDA \357\:GNDA) analogLib_presistor_schematic c=0 \
        r=0.056013
    re1562 (\613\:GNDA \390\:GNDA) analogLib_presistor_schematic c=0 \
        r=0.178311
    re1563 (\617\:GNDA \396\:GNDA) analogLib_presistor_schematic c=0 \
        r=0.169775
    re1564 (\617\:GNDA \700\:GNDA) analogLib_presistor_schematic c=0 \
        r=0.051554
    re1565 (\618\:GNDA \356\:GNDA) analogLib_presistor_schematic c=0 \
        r=0.058497
    re1566 (\619\:GNDA \355\:GNDA) analogLib_presistor_schematic c=0 \
        r=0.056013
    re1567 (\623\:GNDA \418\:GNDA) analogLib_presistor_schematic c=0 \
        r=0.18122
    re1568 (\626\:GNDA \354\:GNDA) analogLib_presistor_schematic c=0 \
        r=0.056013
    re1569 (\630\:GNDA \430\:GNDA) analogLib_presistor_schematic c=0 \
        r=0.165987
    re1570 (\633\:GNDA \353\:GNDA) analogLib_presistor_schematic c=0 \
        r=0.058497
    re1571 (\637\:GNDA \442\:GNDA) analogLib_presistor_schematic c=0 \
        r=0.175667
    re1572 (\640\:GNDA \352\:GNDA) analogLib_presistor_schematic c=0 \
        r=0.057255
    re1573 (\644\:GNDA \454\:GNDA) analogLib_presistor_schematic c=0 \
        r=0.173562
    re1574 (\647\:GNDA \351\:GNDA) analogLib_presistor_schematic c=0 \
        r=0.057255
    re1575 (\651\:GNDA \466\:GNDA) analogLib_presistor_schematic c=0 \
        r=0.183314
    re1576 (\655\:GNDA \350\:GNDA) analogLib_presistor_schematic c=0 \
        r=0.029303
    re1577 (\657\:GNDA \701\:GNDA) analogLib_presistor_schematic c=0 \
        r=0.895385
    re1578 (\701\:GNDA \702\:GNDA) analogLib_presistor_schematic c=0 \
        r=0.252545
    re1579 (\702\:GNDA \703\:GNDA) analogLib_presistor_schematic c=0 \
        r=0.186912
    re1581 (\703\:GNDA \706\:GNDA) analogLib_presistor_schematic c=0 \
        r=0.027269
    re1582 (\706\:GNDA \707\:GNDA) analogLib_presistor_schematic c=0 \
        r=0.229922
    re1583 (\707\:GNDA \708\:GNDA) analogLib_presistor_schematic c=0 \
        r=0.006407
    re1584 (\709\:GNDA \658\:GNDA) analogLib_presistor_schematic c=0 \
        r=0.009984
    re1586 (\658\:GNDA \711\:GNDA) analogLib_presistor_schematic c=0 \
        r=0.037666
    re1588 (\711\:GNDA \712\:GNDA) analogLib_presistor_schematic c=0 \
        r=9.90141
    re1589 (\675\:GNDA \714\:GNDA) analogLib_presistor_schematic c=0 \
        r=1.53352
    re1590 (\714\:GNDA \715\:GNDA) analogLib_presistor_schematic c=0 \
        r=0.266716
    re1591 (\676\:GNDA \225\:GNDA) analogLib_presistor_schematic c=0 \
        r=0.076332
    re1592 (\676\:GNDA \717\:GNDA) analogLib_presistor_schematic c=0 \
        r=0.862248
    re1593 (\717\:GNDA \719\:GNDA) analogLib_presistor_schematic c=0 \
        r=0.198394
    re1594 (\719\:GNDA \720\:GNDA) analogLib_presistor_schematic c=0 \
        r=1.24956
    re1595 (\720\:GNDA \721\:GNDA) analogLib_presistor_schematic c=0 \
        r=1.24956
    re1596 (\721\:GNDA \722\:GNDA) analogLib_presistor_schematic c=0 \
        r=0.879159
    re1597 (\722\:GNDA \723\:GNDA) analogLib_presistor_schematic c=0 \
        r=0.522777
    re1598 (\723\:GNDA \724\:GNDA) analogLib_presistor_schematic c=0 \
        r=0.520293
    re1599 (\724\:GNDA \725\:GNDA) analogLib_presistor_schematic c=0 \
        r=0.335645
    re1600 (\677\:GNDA \540\:GNDA) analogLib_presistor_schematic c=0 \
        r=0.030649
    re1601 (\677\:GNDA \726\:GNDA) analogLib_presistor_schematic c=0 \
        r=0.085818
    re1602 (\726\:GNDA \727\:GNDA) analogLib_presistor_schematic c=0 \
        r=0.030793
    re1603 (\677\:GNDA \728\:GNDA) analogLib_presistor_schematic c=0 \
        r=5.66789
    re1604 (\678\:GNDA \225\:GNDA) analogLib_presistor_schematic c=0 \
        r=0.204804
    re1605 (\683\:GNDA \549\:GNDA) analogLib_presistor_schematic c=0 \
        r=0.230172
    re1606 (\688\:GNDA \243\:GNDA) analogLib_presistor_schematic c=0 \
        r=0.052158
    re1607 (\689\:GNDA \729\:GNDA) analogLib_presistor_schematic c=0 \
        r=0.261074
    re1608 (\729\:GNDA \730\:GNDA) analogLib_presistor_schematic c=0 \
        r=0.292539
    re1609 (\730\:GNDA \731\:GNDA) analogLib_presistor_schematic c=0 \
        r=0.014387
    re1610 (\699\:GNDA \219\:GNDA) analogLib_presistor_schematic c=0 \
        r=0.072444
    re1611 (\700\:GNDA \400\:GNDA) analogLib_presistor_schematic c=0 \
        r=0.09177
    re1612 (\700\:GNDA \733\:GNDA) analogLib_presistor_schematic c=0 \
        r=0.135479
    re1613 (\733\:GNDA \734\:GNDA) analogLib_presistor_schematic c=0 \
        r=0.030254
    re1614 (\700\:GNDA \408\:GNDA) analogLib_presistor_schematic c=0 \
        r=0.071042
    re1615 (\702\:GNDA \735\:GNDA) analogLib_presistor_schematic c=0 \
        r=0.728494
    re1616 (\735\:GNDA \736\:GNDA) analogLib_presistor_schematic c=0 \
        r=0.419436
    re1617 (\736\:GNDA \737\:GNDA) analogLib_presistor_schematic c=0 \
        r=0.186912
    re1619 (\737\:GNDA \740\:GNDA) analogLib_presistor_schematic c=0 \
        r=0.009884
    re1623 (\743\:GNDA \737\:GNDA) analogLib_presistor_schematic c=0 \
        r=0.009984
    re1625 (\737\:GNDA \745\:GNDA) analogLib_presistor_schematic c=0 \
        r=0.037666
    re1627 (\745\:GNDA \746\:GNDA) analogLib_presistor_schematic c=0 \
        r=9.90141
    re1628 (\708\:GNDA \703\:GNDA) analogLib_presistor_schematic c=0 \
        r=0.412311
    re1629 (\658\:GNDA \749\:GNDA) analogLib_presistor_schematic c=0 \
        r=0.630602
    re1630 (\749\:GNDA \750\:GNDA) analogLib_presistor_schematic c=0 \
        r=0.865858
    re1631 (\750\:GNDA \751\:GNDA) analogLib_presistor_schematic c=0 \
        r=0.295795
    re1632 (\751\:GNDA \752\:GNDA) analogLib_presistor_schematic c=0 \
        r=0.012109
    re1633 (\711\:GNDA \754\:GNDA) analogLib_presistor_schematic c=0 \
        r=0.630602
    re1634 (\754\:GNDA \755\:GNDA) analogLib_presistor_schematic c=0 \
        r=0.868342
    re1635 (\755\:GNDA \756\:GNDA) analogLib_presistor_schematic c=0 \
        r=0.331906
    re1636 (\715\:GNDA \757\:GNDA) analogLib_presistor_schematic c=0 \
        r=1.27502
    re1637 (\757\:GNDA \758\:GNDA) analogLib_presistor_schematic c=0 \
        r=1.48363
    re1638 (\758\:GNDA \759\:GNDA) analogLib_presistor_schematic c=0 \
        r=0.057948
    re1639 (\717\:GNDA \761\:GNDA) analogLib_presistor_schematic c=0 \
        r=0.023431
    re1640 (\761\:GNDA \762\:GNDA) analogLib_presistor_schematic c=0 \
        r=0.575814
    re1641 (\762\:GNDA \763\:GNDA) analogLib_presistor_schematic c=0 \
        r=0.904353
    re1642 (\763\:GNDA \764\:GNDA) analogLib_presistor_schematic c=0 \
        r=0.901869
    re1643 (\764\:GNDA \765\:GNDA) analogLib_presistor_schematic c=0 \
        r=0.535661
    re1644 (\765\:GNDA \766\:GNDA) analogLib_presistor_schematic c=0 \
        r=2.74303
    re1645 (\766\:GNDA \767\:GNDA) analogLib_presistor_schematic c=0 \
        r=3.0783
    re1646 (\725\:GNDA \719\:GNDA) analogLib_presistor_schematic c=0 \
        r=0.544756
    re1647 (\726\:GNDA \768\:GNDA) analogLib_presistor_schematic c=0 \
        r=5.64067
    re1648 (\727\:GNDA \541\:GNDA) analogLib_presistor_schematic c=0 \
        r=0.01914
    re1649 (\729\:GNDA \240\:GNDA) analogLib_presistor_schematic c=0 \
        r=0.010468
    re1650 (\731\:GNDA \769\:GNDA) analogLib_presistor_schematic c=0 \
        r=0.249588
    re1651 (\769\:GNDA \770\:GNDA) analogLib_presistor_schematic c=0 \
        r=0.843507
    re1652 (\770\:GNDA \771\:GNDA) analogLib_presistor_schematic c=0 \
        r=0.27665
    re1653 (\733\:GNDA \772\:GNDA) analogLib_presistor_schematic c=0 \
        r=0.043075
    re1654 (\734\:GNDA \400\:GNDA) analogLib_presistor_schematic c=0 \
        r=0.042551
    re1655 (\736\:GNDA \773\:GNDA) analogLib_presistor_schematic c=0 \
        r=0.561602
    re1656 (\773\:GNDA \774\:GNDA) analogLib_presistor_schematic c=0 \
        r=0.586327
    re1657 (\774\:GNDA \775\:GNDA) analogLib_presistor_schematic c=0 \
        r=0.186912
    re1659 (\775\:GNDA \778\:GNDA) analogLib_presistor_schematic c=0 \
        r=0.009884
    re1663 (\781\:GNDA \775\:GNDA) analogLib_presistor_schematic c=0 \
        r=0.009984
    re1665 (\775\:GNDA \783\:GNDA) analogLib_presistor_schematic c=0 \
        r=0.037666
    re1667 (\783\:GNDA \784\:GNDA) analogLib_presistor_schematic c=0 \
        r=9.90141
    re1668 (\737\:GNDA \787\:GNDA) analogLib_presistor_schematic c=0 \
        r=0.630602
    re1669 (\787\:GNDA \788\:GNDA) analogLib_presistor_schematic c=0 \
        r=0.865858
    re1670 (\788\:GNDA \789\:GNDA) analogLib_presistor_schematic c=0 \
        r=0.290493
    re1671 (\789\:GNDA \790\:GNDA) analogLib_presistor_schematic c=0 \
        r=0.011632
    re1672 (\745\:GNDA \792\:GNDA) analogLib_presistor_schematic c=0 \
        r=0.630602
    re1673 (\792\:GNDA \793\:GNDA) analogLib_presistor_schematic c=0 \
        r=0.868342
    re1674 (\793\:GNDA \794\:GNDA) analogLib_presistor_schematic c=0 \
        r=0.331906
    re1675 (\795\:GNDA \703\:GNDA) analogLib_presistor_schematic c=0 \
        r=0.009984
    re1677 (\703\:GNDA \797\:GNDA) analogLib_presistor_schematic c=0 \
        r=0.037666
    re1679 (\797\:GNDA \798\:GNDA) analogLib_presistor_schematic c=0 \
        r=9.90141
    re1680 (\751\:GNDA \800\:GNDA) analogLib_presistor_schematic c=0 \
        r=0.592673
    re1681 (\751\:GNDA \801\:GNDA) analogLib_presistor_schematic c=0 \
        r=0.288345
    re1682 (\801\:GNDA \802\:GNDA) analogLib_presistor_schematic c=0 \
        r=0.868342
    re1683 (\802\:GNDA \658\:GNDA) analogLib_presistor_schematic c=0 \
        r=0.630602
    re1686 (\752\:GNDA \658\:GNDA) analogLib_presistor_schematic c=0 \
        r=0.012314
    re1689 (\711\:GNDA \807\:GNDA) analogLib_presistor_schematic c=0 \
        r=0.630602
    re1690 (\807\:GNDA \753\:GNDA) analogLib_presistor_schematic c=0 \
        r=6.80586
    re1691 (\759\:GNDA \808\:GNDA) analogLib_presistor_schematic c=0 \
        r=0.899181
    re1692 (\808\:GNDA \809\:GNDA) analogLib_presistor_schematic c=0 \
        r=0.851681
    re1693 (\809\:GNDA \810\:GNDA) analogLib_presistor_schematic c=0 \
        r=0.003863
    re1694 (\765\:GNDA \761\:GNDA) analogLib_presistor_schematic c=0 \
        r=0.147768
    re1695 (\765\:GNDA \217\:GNDA) analogLib_presistor_schematic c=0 \
        r=0.356382
    re1696 (\766\:GNDA \717\:GNDA) analogLib_presistor_schematic c=0 \
        r=0.002955
    re1697 (\766\:GNDA \222\:GNDA) analogLib_presistor_schematic c=0 \
        r=0.001757
    re1698 (\767\:GNDA \224\:GNDA) analogLib_presistor_schematic c=0 \
        r=0.404813
    re1699 (\767\:GNDA \676\:GNDA) analogLib_presistor_schematic c=0 \
        r=0.027136
    re1700 (\767\:GNDA \223\:GNDA) analogLib_presistor_schematic c=0 \
        r=0.012919
    re1701 (\771\:GNDA \811\:GNDA) analogLib_presistor_schematic c=0 \
        r=1.25763
    re1702 (\811\:GNDA \812\:GNDA) analogLib_presistor_schematic c=0 \
        r=1.47121
    re1703 (\812\:GNDA \813\:GNDA) analogLib_presistor_schematic c=0 \
        r=0.061812
    re1704 (\772\:GNDA \408\:GNDA) analogLib_presistor_schematic c=0 \
        r=0.056668
    re1705 (\774\:GNDA \814\:GNDA) analogLib_presistor_schematic c=0 \
        r=0.394711
    re1706 (\814\:GNDA \815\:GNDA) analogLib_presistor_schematic c=0 \
        r=0.750237
    re1707 (\815\:GNDA \151\:GNDA) analogLib_presistor_schematic c=0 \
        r=0.180393
    re1709 (\151\:GNDA \817\:GNDA) analogLib_presistor_schematic c=0 \
        r=0.009884
    re1710 (\775\:GNDA \819\:GNDA) analogLib_presistor_schematic c=0 \
        r=0.630602
    re1711 (\819\:GNDA \820\:GNDA) analogLib_presistor_schematic c=0 \
        r=0.865858
    re1712 (\820\:GNDA \821\:GNDA) analogLib_presistor_schematic c=0 \
        r=0.322751
    re1713 (\821\:GNDA \822\:GNDA) analogLib_presistor_schematic c=0 \
        r=0.013418
    re1714 (\783\:GNDA \824\:GNDA) analogLib_presistor_schematic c=0 \
        r=0.630602
    re1715 (\824\:GNDA \825\:GNDA) analogLib_presistor_schematic c=0 \
        r=0.868342
    re1716 (\825\:GNDA \826\:GNDA) analogLib_presistor_schematic c=0 \
        r=0.331906
    re1717 (\789\:GNDA \827\:GNDA) analogLib_presistor_schematic c=0 \
        r=0.591964
    re1718 (\789\:GNDA \828\:GNDA) analogLib_presistor_schematic c=0 \
        r=0.292977
    re1719 (\828\:GNDA \829\:GNDA) analogLib_presistor_schematic c=0 \
        r=0.868342
    re1720 (\829\:GNDA \737\:GNDA) analogLib_presistor_schematic c=0 \
        r=0.630602
    re1723 (\790\:GNDA \737\:GNDA) analogLib_presistor_schematic c=0 \
        r=0.011821
    re1726 (\745\:GNDA \834\:GNDA) analogLib_presistor_schematic c=0 \
        r=0.630602
    re1727 (\834\:GNDA \791\:GNDA) analogLib_presistor_schematic c=0 \
        r=6.80586
    re1728 (\703\:GNDA \836\:GNDA) analogLib_presistor_schematic c=0 \
        r=0.630602
    re1729 (\836\:GNDA \837\:GNDA) analogLib_presistor_schematic c=0 \
        r=0.865858
    re1730 (\837\:GNDA \838\:GNDA) analogLib_presistor_schematic c=0 \
        r=0.151587
    re1731 (\797\:GNDA \840\:GNDA) analogLib_presistor_schematic c=0 \
        r=0.630602
    re1732 (\840\:GNDA \841\:GNDA) analogLib_presistor_schematic c=0 \
        r=0.868342
    re1733 (\841\:GNDA \842\:GNDA) analogLib_presistor_schematic c=0 \
        r=0.331906
    re1735 (\711\:GNDA \712\:GNDA) analogLib_presistor_schematic c=0 \
        r=8.48686
    re1736 (\810\:GNDA \844\:GNDA) analogLib_presistor_schematic c=0 \
        r=1.57525
    re1737 (\844\:GNDA \845\:GNDA) analogLib_presistor_schematic c=0 \
        r=1.0806
    re1738 (\813\:GNDA \846\:GNDA) analogLib_presistor_schematic c=0 \
        r=0.887867
    re1739 (\846\:GNDA \847\:GNDA) analogLib_presistor_schematic c=0 \
        r=0.170478
    re1740 (\847\:GNDA \848\:GNDA) analogLib_presistor_schematic c=0 \
        r=0.859445
    re1741 (\848\:GNDA \849\:GNDA) analogLib_presistor_schematic c=0 \
        r=0.057948
    re1742 (\815\:GNDA \850\:GNDA) analogLib_presistor_schematic c=0 \
        r=0.139149
    re1743 (\850\:GNDA \851\:GNDA) analogLib_presistor_schematic c=0 \
        r=0.900916
    re1744 (\851\:GNDA \852\:GNDA) analogLib_presistor_schematic c=0 \
        r=0.083446
    re1745 (\852\:GNDA \853\:GNDA) analogLib_presistor_schematic c=0 \
        r=1.09175
    re1746 (\853\:GNDA \854\:GNDA) analogLib_presistor_schematic c=0 \
        r=0.083446
    re1747 (\854\:GNDA \855\:GNDA) analogLib_presistor_schematic c=0 \
        r=1.09175
    re1748 (\855\:GNDA \856\:GNDA) analogLib_presistor_schematic c=0 \
        r=0.083446
    re1749 (\856\:GNDA \857\:GNDA) analogLib_presistor_schematic c=0 \
        r=1.09175
    re1750 (\857\:GNDA \858\:GNDA) analogLib_presistor_schematic c=0 \
        r=0.083446
    re1751 (\858\:GNDA \859\:GNDA) analogLib_presistor_schematic c=0 \
        r=1.09175
    re1752 (\859\:GNDA \860\:GNDA) analogLib_presistor_schematic c=0 \
        r=0.083446
    re1753 (\860\:GNDA \861\:GNDA) analogLib_presistor_schematic c=0 \
        r=1.09175
    re1754 (\861\:GNDA \862\:GNDA) analogLib_presistor_schematic c=0 \
        r=0.083446
    re1755 (\862\:GNDA \863\:GNDA) analogLib_presistor_schematic c=0 \
        r=1.09175
    re1756 (\863\:GNDA \864\:GNDA) analogLib_presistor_schematic c=0 \
        r=0.083446
    re1757 (\864\:GNDA \865\:GNDA) analogLib_presistor_schematic c=0 \
        r=1.09175
    re1758 (\865\:GNDA \866\:GNDA) analogLib_presistor_schematic c=0 \
        r=0.083446
    re1759 (\866\:GNDA \867\:GNDA) analogLib_presistor_schematic c=0 \
        r=1.09175
    re1760 (\867\:GNDA \868\:GNDA) analogLib_presistor_schematic c=0 \
        r=0.083446
    re1761 (\868\:GNDA \869\:GNDA) analogLib_presistor_schematic c=0 \
        r=1.037
    re1762 (\151\:GNDA \871\:GNDA) analogLib_presistor_schematic c=0 \
        r=0.630602
    re1763 (\871\:GNDA \872\:GNDA) analogLib_presistor_schematic c=0 \
        r=0.868342
    re1764 (\872\:GNDA \873\:GNDA) analogLib_presistor_schematic c=0 \
        r=0.040978
    re1765 (\821\:GNDA \874\:GNDA) analogLib_presistor_schematic c=0 \
        r=0.594618
    re1766 (\821\:GNDA \875\:GNDA) analogLib_presistor_schematic c=0 \
        r=0.263147
    re1767 (\875\:GNDA \876\:GNDA) analogLib_presistor_schematic c=0 \
        r=0.868342
    re1768 (\876\:GNDA \775\:GNDA) analogLib_presistor_schematic c=0 \
        r=0.630602
    re1771 (\822\:GNDA \775\:GNDA) analogLib_presistor_schematic c=0 \
        r=0.013666
    re1774 (\783\:GNDA \881\:GNDA) analogLib_presistor_schematic c=0 \
        r=0.630602
    re1775 (\881\:GNDA \823\:GNDA) analogLib_presistor_schematic c=0 \
        r=6.80586
    re1777 (\745\:GNDA \746\:GNDA) analogLib_presistor_schematic c=0 \
        r=8.48686
    re1778 (\838\:GNDA \703\:GNDA) analogLib_presistor_schematic c=0 \
        r=0.154471
    re1779 (\838\:GNDA \884\:GNDA) analogLib_presistor_schematic c=0 \
        r=0.10708
    re1780 (\884\:GNDA \885\:GNDA) analogLib_presistor_schematic c=0 \
        r=0.084876
    re1783 (\797\:GNDA \888\:GNDA) analogLib_presistor_schematic c=0 \
        r=0.630602
    re1784 (\888\:GNDA \839\:GNDA) analogLib_presistor_schematic c=0 \
        r=6.80586
    re1785 (\711\:GNDA \889\:GNDA) analogLib_presistor_schematic c=0 \
        r=0.037666
    re1787 (\889\:GNDA \890\:GNDA) analogLib_presistor_schematic c=0 \
        r=9.90141
    re1788 (\845\:GNDA \892\:GNDA) analogLib_presistor_schematic c=0 \
        r=0.222549
    re1789 (\892\:GNDA \893\:GNDA) analogLib_presistor_schematic c=0 \
        r=0.535483
    re1790 (\893\:GNDA \894\:GNDA) analogLib_presistor_schematic c=0 \
        r=0.637023
    re1791 (\894\:GNDA \895\:GNDA) analogLib_presistor_schematic c=0 \
        r=0.043461
    re1792 (\895\:GNDA \896\:GNDA) analogLib_presistor_schematic c=0 \
        r=1.27253
    re1793 (\896\:GNDA \897\:GNDA) analogLib_presistor_schematic c=0 \
        r=0.2409
    re1794 (\897\:GNDA \898\:GNDA) analogLib_presistor_schematic c=0 \
        r=1.24521
    re1795 (\898\:GNDA \899\:GNDA) analogLib_presistor_schematic c=0 \
        r=0.281617
    re1796 (\899\:GNDA \900\:GNDA) analogLib_presistor_schematic c=0 \
        r=0.14901
    re1797 (\849\:GNDA \901\:GNDA) analogLib_presistor_schematic c=0 \
        r=1.48363
    re1798 (\901\:GNDA \902\:GNDA) analogLib_presistor_schematic c=0 \
        r=1.32469
    re1799 (\869\:GNDA \200\:GNDA) analogLib_presistor_schematic c=0 \
        r=0.017426
    re1800 (\869\:GNDA \903\:GNDA) analogLib_presistor_schematic c=0 \
        r=0.008594
    re1801 (\903\:GNDA \904\:GNDA) analogLib_presistor_schematic c=0 \
        r=0.171593
    re1802 (\904\:GNDA \905\:GNDA) analogLib_presistor_schematic c=0 \
        r=0.014977
    re1803 (\905\:GNDA \906\:GNDA) analogLib_presistor_schematic c=0 \
        r=0.341148
    re1804 (\906\:GNDA \907\:GNDA) analogLib_presistor_schematic c=0 \
        r=0.468467
    re1805 (\907\:GNDA \908\:GNDA) analogLib_presistor_schematic c=0 \
        r=0.468467
    re1806 (\908\:GNDA \909\:GNDA) analogLib_presistor_schematic c=0 \
        r=0.468467
    re1807 (\909\:GNDA \910\:GNDA) analogLib_presistor_schematic c=0 \
        r=0.468467
    re1808 (\910\:GNDA \911\:GNDA) analogLib_presistor_schematic c=0 \
        r=0.468467
    re1809 (\911\:GNDA \912\:GNDA) analogLib_presistor_schematic c=0 \
        r=0.468467
    re1810 (\912\:GNDA \913\:GNDA) analogLib_presistor_schematic c=0 \
        r=0.468467
    re1811 (\913\:GNDA \914\:GNDA) analogLib_presistor_schematic c=0 \
        r=0.468467
    re1812 (\914\:GNDA \915\:GNDA) analogLib_presistor_schematic c=0 \
        r=0.472492
    re1813 (\915\:GNDA \916\:GNDA) analogLib_presistor_schematic c=0 \
        r=0.286936
    re1814 (\916\:GNDA \917\:GNDA) analogLib_presistor_schematic c=0 \
        r=0.433828
    re1815 (\917\:GNDA \918\:GNDA) analogLib_presistor_schematic c=0 \
        r=0.083446
    re1816 (\918\:GNDA \919\:GNDA) analogLib_presistor_schematic c=0 \
        r=0.988985
    re1817 (\919\:GNDA \920\:GNDA) analogLib_presistor_schematic c=0 \
        r=0.03616
    re1820 (\151\:GNDA \923\:GNDA) analogLib_presistor_schematic c=0 \
        r=0.630602
    re1821 (\923\:GNDA \924\:GNDA) analogLib_presistor_schematic c=0 \
        r=0.865858
    re1822 (\924\:GNDA \925\:GNDA) analogLib_presistor_schematic c=0 \
        r=0.079472
    re1823 (\873\:GNDA \150\:GNDA) analogLib_presistor_schematic c=0 \
        r=0.212953
    re1825 (\783\:GNDA \784\:GNDA) analogLib_presistor_schematic c=0 \
        r=8.48686
    re1826 (\745\:GNDA \927\:GNDA) analogLib_presistor_schematic c=0 \
        r=0.037666
    re1828 (\927\:GNDA \928\:GNDA) analogLib_presistor_schematic c=0 \
        r=9.90141
    re1829 (\885\:GNDA \707\:GNDA) analogLib_presistor_schematic c=0 \
        r=0.035304
    re1830 (\885\:GNDA \838\:GNDA) analogLib_presistor_schematic c=0 \
        r=0.078679
    re1831 (\885\:GNDA \930\:GNDA) analogLib_presistor_schematic c=0 \
        r=0.144336
    re1832 (\930\:GNDA \931\:GNDA) analogLib_presistor_schematic c=0 \
        r=0.868342
    re1833 (\931\:GNDA \703\:GNDA) analogLib_presistor_schematic c=0 \
        r=0.630602
    re1837 (\797\:GNDA \798\:GNDA) analogLib_presistor_schematic c=0 \
        r=8.48686
    re1838 (\889\:GNDA \936\:GNDA) analogLib_presistor_schematic c=0 \
        r=0.630602
    re1839 (\936\:GNDA \937\:GNDA) analogLib_presistor_schematic c=0 \
        r=0.868342
    re1840 (\937\:GNDA \938\:GNDA) analogLib_presistor_schematic c=0 \
        r=0.331906
    re1841 (\893\:GNDA \939\:GNDA) analogLib_presistor_schematic c=0 \
        r=0.023876
    re1842 (\896\:GNDA \940\:GNDA) analogLib_presistor_schematic c=0 \
        r=0.019843
    re1843 (\900\:GNDA \534\:GNDA) analogLib_presistor_schematic c=0 \
        r=0.255642
    re1844 (\902\:GNDA \941\:GNDA) analogLib_presistor_schematic c=0 \
        r=0.202145
    re1845 (\941\:GNDA \942\:GNDA) analogLib_presistor_schematic c=0 \
        r=0.834456
    re1846 (\942\:GNDA \943\:GNDA) analogLib_presistor_schematic c=0 \
        r=0.880401
    re1847 (\943\:GNDA \944\:GNDA) analogLib_presistor_schematic c=0 \
        r=0.111068
    re1848 (\944\:GNDA \945\:GNDA) analogLib_presistor_schematic c=0 \
        r=0.760365
    re1849 (\917\:GNDA \946\:GNDA) analogLib_presistor_schematic c=0 \
        r=5.68575
    re1850 (\918\:GNDA \947\:GNDA) analogLib_presistor_schematic c=0 \
        r=0.196339
    re1852 (\947\:GNDA \950\:GNDA) analogLib_presistor_schematic c=0 \
        r=0.009884
    re1853 (\947\:GNDA \951\:GNDA) analogLib_presistor_schematic c=0 \
        r=0.124975
    re1854 (\947\:GNDA \952\:GNDA) analogLib_presistor_schematic c=0 \
        r=0.046008
    re1855 (\920\:GNDA \850\:GNDA) analogLib_presistor_schematic c=0 \
        r=0.045042
    re1856 (\925\:GNDA \150\:GNDA) analogLib_presistor_schematic c=0 \
        r=0.251447
    re1857 (\783\:GNDA \953\:GNDA) analogLib_presistor_schematic c=0 \
        r=0.037666
    re1859 (\953\:GNDA \954\:GNDA) analogLib_presistor_schematic c=0 \
        r=9.90141
    re1860 (\927\:GNDA \957\:GNDA) analogLib_presistor_schematic c=0 \
        r=0.630602
    re1861 (\957\:GNDA \958\:GNDA) analogLib_presistor_schematic c=0 \
        r=0.868342
    re1862 (\958\:GNDA \959\:GNDA) analogLib_presistor_schematic c=0 \
        r=0.331906
    re1863 (\797\:GNDA \960\:GNDA) analogLib_presistor_schematic c=0 \
        r=0.037666
    re1865 (\960\:GNDA \961\:GNDA) analogLib_presistor_schematic c=0 \
        r=9.90141
    re1868 (\889\:GNDA \965\:GNDA) analogLib_presistor_schematic c=0 \
        r=0.630602
    re1869 (\965\:GNDA \935\:GNDA) analogLib_presistor_schematic c=0 \
        r=6.80586
    re1870 (\939\:GNDA \206\:GNDA) analogLib_presistor_schematic c=0 \
        r=0.082329
    re1871 (\940\:GNDA \209\:GNDA) analogLib_presistor_schematic c=0 \
        r=0.039467
    re1872 (\945\:GNDA \685\:GNDA) analogLib_presistor_schematic c=0 \
        r=0.651967
    re1873 (\946\:GNDA \905\:GNDA) analogLib_presistor_schematic c=0 \
        r=5.72596
    re1874 (\951\:GNDA \966\:GNDA) analogLib_presistor_schematic c=0 \
        r=0.047012
    re1875 (\966\:GNDA \947\:GNDA) analogLib_presistor_schematic c=0 \
        r=0.162601
    re1876 (\966\:GNDA \967\:GNDA) analogLib_presistor_schematic c=0 \
        r=0.040426
    re1877 (\952\:GNDA \851\:GNDA) analogLib_presistor_schematic c=0 \
        r=0.044838
    re1878 (\953\:GNDA \969\:GNDA) analogLib_presistor_schematic c=0 \
        r=0.630602
    re1879 (\969\:GNDA \970\:GNDA) analogLib_presistor_schematic c=0 \
        r=0.868342
    re1880 (\970\:GNDA \971\:GNDA) analogLib_presistor_schematic c=0 \
        r=0.331906
    re1883 (\927\:GNDA \974\:GNDA) analogLib_presistor_schematic c=0 \
        r=0.630602
    re1884 (\974\:GNDA \956\:GNDA) analogLib_presistor_schematic c=0 \
        r=6.80586
    re1885 (\960\:GNDA \976\:GNDA) analogLib_presistor_schematic c=0 \
        r=0.630602
    re1886 (\976\:GNDA \977\:GNDA) analogLib_presistor_schematic c=0 \
        r=0.868342
    re1887 (\977\:GNDA \978\:GNDA) analogLib_presistor_schematic c=0 \
        r=0.331906
    re1889 (\889\:GNDA \890\:GNDA) analogLib_presistor_schematic c=0 \
        r=8.48686
    re1890 (\980\:GNDA \947\:GNDA) analogLib_presistor_schematic c=0 \
        r=0.009984
    re1892 (\947\:GNDA \982\:GNDA) analogLib_presistor_schematic c=0 \
        r=0.037666
    re1894 (\982\:GNDA \985\:GNDA) analogLib_presistor_schematic c=0 \
        r=0.009884
    re1895 (\982\:GNDA \986\:GNDA) analogLib_presistor_schematic c=0 \
        r=0.139056
    re1896 (\982\:GNDA \987\:GNDA) analogLib_presistor_schematic c=0 \
        r=0.047694
    re1897 (\967\:GNDA \852\:GNDA) analogLib_presistor_schematic c=0 \
        r=0.044838
    re1900 (\953\:GNDA \990\:GNDA) analogLib_presistor_schematic c=0 \
        r=0.630602
    re1901 (\990\:GNDA \968\:GNDA) analogLib_presistor_schematic c=0 \
        r=6.80586
    re1903 (\927\:GNDA \928\:GNDA) analogLib_presistor_schematic c=0 \
        r=8.48686
    re1906 (\960\:GNDA \994\:GNDA) analogLib_presistor_schematic c=0 \
        r=0.630602
    re1907 (\994\:GNDA \975\:GNDA) analogLib_presistor_schematic c=0 \
        r=6.80586
    re1908 (\889\:GNDA \995\:GNDA) analogLib_presistor_schematic c=0 \
        r=0.037666
    re1910 (\995\:GNDA \996\:GNDA) analogLib_presistor_schematic c=0 \
        r=9.90141
    re1911 (\947\:GNDA \999\:GNDA) analogLib_presistor_schematic c=0 \
        r=0.630602
    re1912 (\999\:GNDA \1000\:GNDA) analogLib_presistor_schematic c=0 \
        r=0.865858
    re1913 (\1000\:GNDA \1001\:GNDA) analogLib_presistor_schematic c=0 \
        r=0.1813
    re1914 (\986\:GNDA \1002\:GNDA) analogLib_presistor_schematic c=0 \
        r=0.047012
    re1915 (\1002\:GNDA \982\:GNDA) analogLib_presistor_schematic c=0 \
        r=0.162601
    re1916 (\1002\:GNDA \1003\:GNDA) analogLib_presistor_schematic c=0 \
        r=0.043106
    re1917 (\987\:GNDA \853\:GNDA) analogLib_presistor_schematic c=0 \
        r=0.044838
    re1919 (\953\:GNDA \954\:GNDA) analogLib_presistor_schematic c=0 \
        r=8.48686
    re1920 (\927\:GNDA \1005\:GNDA) analogLib_presistor_schematic c=0 \
        r=0.037666
    re1922 (\1005\:GNDA \1006\:GNDA) analogLib_presistor_schematic c=0 \
        r=9.90141
    re1924 (\960\:GNDA \961\:GNDA) analogLib_presistor_schematic c=0 \
        r=8.48686
    re1925 (\995\:GNDA \1010\:GNDA) analogLib_presistor_schematic c=0 \
        r=0.630602
    re1926 (\1010\:GNDA \1011\:GNDA) analogLib_presistor_schematic c=0 \
        r=0.868342
    re1927 (\1011\:GNDA \1012\:GNDA) analogLib_presistor_schematic c=0 \
        r=0.331906
    re1928 (\1001\:GNDA \966\:GNDA) analogLib_presistor_schematic c=0 \
        r=0.075409
    re1929 (\1001\:GNDA \1014\:GNDA) analogLib_presistor_schematic c=0 \
        r=0.08445
    re1930 (\1015\:GNDA \982\:GNDA) analogLib_presistor_schematic c=0 \
        r=0.009984
    re1932 (\982\:GNDA \1017\:GNDA) analogLib_presistor_schematic c=0 \
        r=0.037666
    re1934 (\1017\:GNDA \1020\:GNDA) analogLib_presistor_schematic c=0 \
        r=0.009884
    re1935 (\1017\:GNDA \1021\:GNDA) analogLib_presistor_schematic c=0 \
        r=0.145191
    re1936 (\1017\:GNDA \1022\:GNDA) analogLib_presistor_schematic c=0 \
        r=0.049086
    re1937 (\1003\:GNDA \854\:GNDA) analogLib_presistor_schematic c=0 \
        r=0.044838
    re1938 (\953\:GNDA \1023\:GNDA) analogLib_presistor_schematic c=0 \
        r=0.037666
    re1940 (\1023\:GNDA \1026\:GNDA) analogLib_presistor_schematic c=0 \
        r=0.009884
    re1944 (\1005\:GNDA \1030\:GNDA) analogLib_presistor_schematic c=0 \
        r=0.630602
    re1945 (\1030\:GNDA \1031\:GNDA) analogLib_presistor_schematic c=0 \
        r=0.868342
    re1946 (\1031\:GNDA \1032\:GNDA) analogLib_presistor_schematic c=0 \
        r=0.331906
    re1947 (\960\:GNDA \1033\:GNDA) analogLib_presistor_schematic c=0 \
        r=0.037666
    re1949 (\1033\:GNDA \1034\:GNDA) analogLib_presistor_schematic c=0 \
        r=9.90141
    re1952 (\995\:GNDA \1038\:GNDA) analogLib_presistor_schematic c=0 \
        r=0.630602
    re1953 (\1038\:GNDA \1009\:GNDA) analogLib_presistor_schematic c=0 \
        r=6.80586
    re1954 (\1014\:GNDA \1039\:GNDA) analogLib_presistor_schematic c=0 \
        r=0.071145
    re1955 (\982\:GNDA \1041\:GNDA) analogLib_presistor_schematic c=0 \
        r=0.630602
    re1956 (\1041\:GNDA \1042\:GNDA) analogLib_presistor_schematic c=0 \
        r=0.865858
    re1957 (\1042\:GNDA \1043\:GNDA) analogLib_presistor_schematic c=0 \
        r=0.234517
    re1958 (\1021\:GNDA \1044\:GNDA) analogLib_presistor_schematic c=0 \
        r=0.049086
    re1959 (\1044\:GNDA \1017\:GNDA) analogLib_presistor_schematic c=0 \
        r=0.169775
    re1960 (\1044\:GNDA \1045\:GNDA) analogLib_presistor_schematic c=0 \
        r=0.043783
    re1961 (\1022\:GNDA \855\:GNDA) analogLib_presistor_schematic c=0 \
        r=0.048563
    re1962 (\1046\:GNDA \1023\:GNDA) analogLib_presistor_schematic c=0 \
        r=0.009984
    re1964 (\1023\:GNDA \1048\:GNDA) analogLib_presistor_schematic c=0 \
        r=0.037666
    re1966 (\1048\:GNDA \1049\:GNDA) analogLib_presistor_schematic c=0 \
        r=9.90141
    re1969 (\1005\:GNDA \1053\:GNDA) analogLib_presistor_schematic c=0 \
        r=0.630602
    re1970 (\1053\:GNDA \1029\:GNDA) analogLib_presistor_schematic c=0 \
        r=6.80586
    re1971 (\1033\:GNDA \1055\:GNDA) analogLib_presistor_schematic c=0 \
        r=0.630602
    re1972 (\1055\:GNDA \1056\:GNDA) analogLib_presistor_schematic c=0 \
        r=0.868342
    re1973 (\1056\:GNDA \1057\:GNDA) analogLib_presistor_schematic c=0 \
        r=0.331906
    re1975 (\995\:GNDA \996\:GNDA) analogLib_presistor_schematic c=0 \
        r=8.48686
    re1976 (\1039\:GNDA \947\:GNDA) analogLib_presistor_schematic c=0 \
        r=0.0757
    re1977 (\1039\:GNDA \1001\:GNDA) analogLib_presistor_schematic c=0 \
        r=0.13707
    re1978 (\1039\:GNDA \1059\:GNDA) analogLib_presistor_schematic c=0 \
        r=0.099544
    re1979 (\1059\:GNDA \1060\:GNDA) analogLib_presistor_schematic c=0 \
        r=0.868342
    re1980 (\1060\:GNDA \947\:GNDA) analogLib_presistor_schematic c=0 \
        r=0.630602
    re1983 (\1043\:GNDA \1002\:GNDA) analogLib_presistor_schematic c=0 \
        r=0.099235
    re1984 (\1043\:GNDA \1064\:GNDA) analogLib_presistor_schematic c=0 \
        r=0.094277
    re1985 (\1065\:GNDA \1017\:GNDA) analogLib_presistor_schematic c=0 \
        r=0.009984
    re1987 (\1017\:GNDA \1067\:GNDA) analogLib_presistor_schematic c=0 \
        r=0.037666
    re1989 (\1067\:GNDA \1070\:GNDA) analogLib_presistor_schematic c=0 \
        r=0.028511
    re1990 (\1070\:GNDA \1071\:GNDA) analogLib_presistor_schematic c=0 \
        r=0.255359
    re1991 (\1071\:GNDA \1072\:GNDA) analogLib_presistor_schematic c=0 \
        r=0.044889
    re1992 (\1072\:GNDA \1073\:GNDA) analogLib_presistor_schematic c=0 \
        r=0.069538
    re1993 (\1045\:GNDA \856\:GNDA) analogLib_presistor_schematic c=0 \
        r=0.048563
    re1994 (\1023\:GNDA \1075\:GNDA) analogLib_presistor_schematic c=0 \
        r=0.630602
    re1995 (\1075\:GNDA \1076\:GNDA) analogLib_presistor_schematic c=0 \
        r=0.865858
    re1996 (\1076\:GNDA \1077\:GNDA) analogLib_presistor_schematic c=0 \
        r=0.345552
    re1997 (\1077\:GNDA \1078\:GNDA) analogLib_presistor_schematic c=0 \
        r=0.012235
    re1998 (\1048\:GNDA \1080\:GNDA) analogLib_presistor_schematic c=0 \
        r=0.630602
    re1999 (\1080\:GNDA \1081\:GNDA) analogLib_presistor_schematic c=0 \
        r=0.868342
    re2000 (\1081\:GNDA \1082\:GNDA) analogLib_presistor_schematic c=0 \
        r=0.331906
    re2002 (\1005\:GNDA \1006\:GNDA) analogLib_presistor_schematic c=0 \
        r=8.48686
    re2005 (\1033\:GNDA \1086\:GNDA) analogLib_presistor_schematic c=0 \
        r=0.630602
    re2006 (\1086\:GNDA \1054\:GNDA) analogLib_presistor_schematic c=0 \
        r=6.80586
    re2007 (\995\:GNDA \1087\:GNDA) analogLib_presistor_schematic c=0 \
        r=0.037666
    re2009 (\1087\:GNDA \1090\:GNDA) analogLib_presistor_schematic c=0 \
        r=0.009884
    re2013 (\1093\:GNDA \1087\:GNDA) analogLib_presistor_schematic c=0 \
        r=0.009984
    re2015 (\1087\:GNDA \1095\:GNDA) analogLib_presistor_schematic c=0 \
        r=0.037666
    re2017 (\1095\:GNDA \1096\:GNDA) analogLib_presistor_schematic c=0 \
        r=9.90141
    re2018 (\1064\:GNDA \1098\:GNDA) analogLib_presistor_schematic c=0 \
        r=0.071892
    re2019 (\1017\:GNDA \1100\:GNDA) analogLib_presistor_schematic c=0 \
        r=0.630602
    re2020 (\1100\:GNDA \1101\:GNDA) analogLib_presistor_schematic c=0 \
        r=0.865858
    re2021 (\1101\:GNDA \1102\:GNDA) analogLib_presistor_schematic c=0 \
        r=0.215458
    re2022 (\1072\:GNDA \1103\:GNDA) analogLib_presistor_schematic c=0 \
        r=0.049845
    re2023 (\1103\:GNDA \1104\:GNDA) analogLib_presistor_schematic c=0 \
        r=0.069538
    re2024 (\1073\:GNDA \857\:GNDA) analogLib_presistor_schematic c=0 \
        r=0.048563
    re2025 (\1077\:GNDA \1105\:GNDA) analogLib_presistor_schematic c=0 \
        r=0.59286
    re2026 (\1077\:GNDA \1106\:GNDA) analogLib_presistor_schematic c=0 \
        r=0.238761
    re2027 (\1106\:GNDA \1107\:GNDA) analogLib_presistor_schematic c=0 \
        r=0.868342
    re2028 (\1107\:GNDA \1023\:GNDA) analogLib_presistor_schematic c=0 \
        r=0.630602
    re2031 (\1078\:GNDA \1023\:GNDA) analogLib_presistor_schematic c=0 \
        r=0.012444
    re2034 (\1048\:GNDA \1112\:GNDA) analogLib_presistor_schematic c=0 \
        r=0.630602
    re2035 (\1112\:GNDA \1079\:GNDA) analogLib_presistor_schematic c=0 \
        r=6.80586
    re2036 (\1005\:GNDA \1113\:GNDA) analogLib_presistor_schematic c=0 \
        r=0.037666
    re2038 (\1113\:GNDA \1114\:GNDA) analogLib_presistor_schematic c=0 \
        r=9.90141
    re2040 (\1033\:GNDA \1034\:GNDA) analogLib_presistor_schematic c=0 \
        r=8.48686
    re2041 (\1087\:GNDA \1118\:GNDA) analogLib_presistor_schematic c=0 \
        r=0.630602
    re2042 (\1118\:GNDA \1119\:GNDA) analogLib_presistor_schematic c=0 \
        r=0.865858
    re2043 (\1119\:GNDA \1120\:GNDA) analogLib_presistor_schematic c=0 \
        r=0.324457
    re2044 (\1120\:GNDA \1121\:GNDA) analogLib_presistor_schematic c=0 \
        r=0.014142
    re2045 (\1095\:GNDA \1123\:GNDA) analogLib_presistor_schematic c=0 \
        r=0.630602
    re2046 (\1123\:GNDA \1124\:GNDA) analogLib_presistor_schematic c=0 \
        r=0.868342
    re2047 (\1124\:GNDA \1125\:GNDA) analogLib_presistor_schematic c=0 \
        r=0.331906
    re2048 (\1098\:GNDA \982\:GNDA) analogLib_presistor_schematic c=0 \
        r=0.096456
    re2049 (\1098\:GNDA \1043\:GNDA) analogLib_presistor_schematic c=0 \
        r=0.106982
    re2050 (\1098\:GNDA \1126\:GNDA) analogLib_presistor_schematic c=0 \
        r=0.132294
    re2051 (\1126\:GNDA \1127\:GNDA) analogLib_presistor_schematic c=0 \
        r=0.868342
    re2052 (\1127\:GNDA \982\:GNDA) analogLib_presistor_schematic c=0 \
        r=0.630602
    re2055 (\1102\:GNDA \1044\:GNDA) analogLib_presistor_schematic c=0 \
        r=0.089565
    re2056 (\1102\:GNDA \1131\:GNDA) analogLib_presistor_schematic c=0 \
        r=0.090373
    re2057 (\1103\:GNDA \1067\:GNDA) analogLib_presistor_schematic c=0 \
        r=0.170294
    re2058 (\1104\:GNDA \858\:GNDA) analogLib_presistor_schematic c=0 \
        r=0.048563
    re2060 (\1048\:GNDA \1049\:GNDA) analogLib_presistor_schematic c=0 \
        r=8.48686
    re2061 (\1113\:GNDA \1134\:GNDA) analogLib_presistor_schematic c=0 \
        r=0.630602
    re2062 (\1134\:GNDA \1135\:GNDA) analogLib_presistor_schematic c=0 \
        r=0.868342
    re2063 (\1135\:GNDA \1136\:GNDA) analogLib_presistor_schematic c=0 \
        r=0.331906
    re2064 (\1033\:GNDA \1137\:GNDA) analogLib_presistor_schematic c=0 \
        r=0.037666
    re2066 (\1137\:GNDA \1138\:GNDA) analogLib_presistor_schematic c=0 \
        r=9.90141
    re2067 (\1120\:GNDA \1140\:GNDA) analogLib_presistor_schematic c=0 \
        r=0.595695
    re2068 (\1120\:GNDA \1141\:GNDA) analogLib_presistor_schematic c=0 \
        r=0.26237
    re2069 (\1141\:GNDA \1142\:GNDA) analogLib_presistor_schematic c=0 \
        r=0.868342
    re2070 (\1142\:GNDA \1087\:GNDA) analogLib_presistor_schematic c=0 \
        r=0.630602
    re2073 (\1121\:GNDA \1087\:GNDA) analogLib_presistor_schematic c=0 \
        r=0.014416
    re2076 (\1095\:GNDA \1147\:GNDA) analogLib_presistor_schematic c=0 \
        r=0.630602
    re2077 (\1147\:GNDA \1122\:GNDA) analogLib_presistor_schematic c=0 \
        r=6.80586
    re2078 (\1131\:GNDA \1148\:GNDA) analogLib_presistor_schematic c=0 \
        r=0.071799
    re2079 (\1149\:GNDA \1067\:GNDA) analogLib_presistor_schematic c=0 \
        r=0.009984
    re2081 (\1067\:GNDA \1151\:GNDA) analogLib_presistor_schematic c=0 \
        r=0.037666
    re2083 (\1151\:GNDA \1154\:GNDA) analogLib_presistor_schematic c=0 \
        r=0.002476
    re2084 (\1154\:GNDA \1155\:GNDA) analogLib_presistor_schematic c=0 \
        r=0.271949
    re2085 (\1155\:GNDA \1156\:GNDA) analogLib_presistor_schematic c=0 \
        r=0.039128
    re2086 (\1156\:GNDA \1157\:GNDA) analogLib_presistor_schematic c=0 \
        r=0.069538
    re2087 (\1048\:GNDA \1158\:GNDA) analogLib_presistor_schematic c=0 \
        r=0.037666
    re2089 (\1158\:GNDA \1161\:GNDA) analogLib_presistor_schematic c=0 \
        r=0.009884
    re2093 (\1164\:GNDA \1158\:GNDA) analogLib_presistor_schematic c=0 \
        r=0.009984
    re2095 (\1158\:GNDA \1166\:GNDA) analogLib_presistor_schematic c=0 \
        r=0.037666
    re2097 (\1166\:GNDA \1167\:GNDA) analogLib_presistor_schematic c=0 \
        r=9.90141
    re2100 (\1113\:GNDA \1171\:GNDA) analogLib_presistor_schematic c=0 \
        r=0.630602
    re2101 (\1171\:GNDA \1133\:GNDA) analogLib_presistor_schematic c=0 \
        r=6.80586
    re2102 (\1137\:GNDA \1173\:GNDA) analogLib_presistor_schematic c=0 \
        r=0.630602
    re2103 (\1173\:GNDA \1174\:GNDA) analogLib_presistor_schematic c=0 \
        r=0.868342
    re2104 (\1174\:GNDA \1175\:GNDA) analogLib_presistor_schematic c=0 \
        r=0.331906
    re2106 (\1095\:GNDA \1096\:GNDA) analogLib_presistor_schematic c=0 \
        r=8.48686
    re2107 (\1148\:GNDA \1017\:GNDA) analogLib_presistor_schematic c=0 \
        r=0.083728
    re2108 (\1148\:GNDA \1102\:GNDA) analogLib_presistor_schematic c=0 \
        r=0.115005
    re2109 (\1148\:GNDA \1177\:GNDA) analogLib_presistor_schematic c=0 \
        r=0.128433
    re2110 (\1177\:GNDA \1178\:GNDA) analogLib_presistor_schematic c=0 \
        r=0.868342
    re2111 (\1178\:GNDA \1017\:GNDA) analogLib_presistor_schematic c=0 \
        r=0.630602
    re2114 (\1067\:GNDA \1182\:GNDA) analogLib_presistor_schematic c=0 \
        r=0.630602
    re2115 (\1182\:GNDA \1183\:GNDA) analogLib_presistor_schematic c=0 \
        r=0.865858
    re2116 (\1183\:GNDA \1184\:GNDA) analogLib_presistor_schematic c=0 \
        r=0.202457
    re2117 (\1156\:GNDA \1185\:GNDA) analogLib_presistor_schematic c=0 \
        r=0.049845
    re2118 (\1185\:GNDA \1186\:GNDA) analogLib_presistor_schematic c=0 \
        r=0.069538
    re2119 (\1157\:GNDA \859\:GNDA) analogLib_presistor_schematic c=0 \
        r=0.048563
    re2120 (\1158\:GNDA \1188\:GNDA) analogLib_presistor_schematic c=0 \
        r=0.630602
    re2121 (\1188\:GNDA \1189\:GNDA) analogLib_presistor_schematic c=0 \
        r=0.865858
    re2122 (\1189\:GNDA \1190\:GNDA) analogLib_presistor_schematic c=0 \
        r=0.341217
    re2123 (\1190\:GNDA \1191\:GNDA) analogLib_presistor_schematic c=0 \
        r=0.015141
    re2124 (\1166\:GNDA \1193\:GNDA) analogLib_presistor_schematic c=0 \
        r=0.630602
    re2125 (\1193\:GNDA \1194\:GNDA) analogLib_presistor_schematic c=0 \
        r=0.868342
    re2126 (\1194\:GNDA \1195\:GNDA) analogLib_presistor_schematic c=0 \
        r=0.331906
    re2128 (\1113\:GNDA \1114\:GNDA) analogLib_presistor_schematic c=0 \
        r=8.48686
    re2131 (\1137\:GNDA \1199\:GNDA) analogLib_presistor_schematic c=0 \
        r=0.630602
    re2132 (\1199\:GNDA \1172\:GNDA) analogLib_presistor_schematic c=0 \
        r=6.80586
    re2133 (\1095\:GNDA \1200\:GNDA) analogLib_presistor_schematic c=0 \
        r=0.037666
    re2135 (\1200\:GNDA \1201\:GNDA) analogLib_presistor_schematic c=0 \
        r=9.90141
    re2136 (\1184\:GNDA \1067\:GNDA) analogLib_presistor_schematic c=0 \
        r=0.305484
    re2137 (\1184\:GNDA \1204\:GNDA) analogLib_presistor_schematic c=0 \
        r=0.073654
    re2138 (\1204\:GNDA \1205\:GNDA) analogLib_presistor_schematic c=0 \
        r=0.231112
    re2139 (\1185\:GNDA \1151\:GNDA) analogLib_presistor_schematic c=0 \
        r=0.170294
    re2140 (\1186\:GNDA \860\:GNDA) analogLib_presistor_schematic c=0 \
        r=0.048563
    re2141 (\1190\:GNDA \1206\:GNDA) analogLib_presistor_schematic c=0 \
        r=0.597182
    re2142 (\1190\:GNDA \1207\:GNDA) analogLib_presistor_schematic c=0 \
        r=0.246844
    re2143 (\1207\:GNDA \1208\:GNDA) analogLib_presistor_schematic c=0 \
        r=0.868342
    re2144 (\1208\:GNDA \1158\:GNDA) analogLib_presistor_schematic c=0 \
        r=0.630602
    re2147 (\1191\:GNDA \1158\:GNDA) analogLib_presistor_schematic c=0 \
        r=0.015453
    re2150 (\1166\:GNDA \1213\:GNDA) analogLib_presistor_schematic c=0 \
        r=0.630602
    re2151 (\1213\:GNDA \1192\:GNDA) analogLib_presistor_schematic c=0 \
        r=6.80586
    re2152 (\1113\:GNDA \1214\:GNDA) analogLib_presistor_schematic c=0 \
        r=0.037666
    re2154 (\1214\:GNDA \1215\:GNDA) analogLib_presistor_schematic c=0 \
        r=9.90141
    re2156 (\1137\:GNDA \1138\:GNDA) analogLib_presistor_schematic c=0 \
        r=8.48686
    re2157 (\1200\:GNDA \1219\:GNDA) analogLib_presistor_schematic c=0 \
        r=0.630602
    re2158 (\1219\:GNDA \1220\:GNDA) analogLib_presistor_schematic c=0 \
        r=0.868342
    re2159 (\1220\:GNDA \1221\:GNDA) analogLib_presistor_schematic c=0 \
        r=0.331906
    re2160 (\1205\:GNDA \1103\:GNDA) analogLib_presistor_schematic c=0 \
        r=0.087945
    re2161 (\1205\:GNDA \1184\:GNDA) analogLib_presistor_schematic c=0 \
        r=0.054995
    re2162 (\1205\:GNDA \1222\:GNDA) analogLib_presistor_schematic c=0 \
        r=0.063019
    re2163 (\1223\:GNDA \1151\:GNDA) analogLib_presistor_schematic c=0 \
        r=0.009984
    re2165 (\1151\:GNDA \1225\:GNDA) analogLib_presistor_schematic c=0 \
        r=0.037666
    re2167 (\1225\:GNDA \1228\:GNDA) analogLib_presistor_schematic c=0 \
        r=0.02106
    re2168 (\1228\:GNDA \1229\:GNDA) analogLib_presistor_schematic c=0 \
        r=0.266419
    re2169 (\1229\:GNDA \1230\:GNDA) analogLib_presistor_schematic c=0 \
        r=0.041049
    re2170 (\1230\:GNDA \1231\:GNDA) analogLib_presistor_schematic c=0 \
        r=0.069538
    re2172 (\1166\:GNDA \1167\:GNDA) analogLib_presistor_schematic c=0 \
        r=8.48686
    re2173 (\1214\:GNDA \1234\:GNDA) analogLib_presistor_schematic c=0 \
        r=0.630602
    re2174 (\1234\:GNDA \1235\:GNDA) analogLib_presistor_schematic c=0 \
        r=0.868342
    re2175 (\1235\:GNDA \1236\:GNDA) analogLib_presistor_schematic c=0 \
        r=0.331906
    re2176 (\1137\:GNDA \1237\:GNDA) analogLib_presistor_schematic c=0 \
        r=0.037666
    re2178 (\1237\:GNDA \1238\:GNDA) analogLib_presistor_schematic c=0 \
        r=9.90141
    re2181 (\1200\:GNDA \1242\:GNDA) analogLib_presistor_schematic c=0 \
        r=0.630602
    re2182 (\1242\:GNDA \1218\:GNDA) analogLib_presistor_schematic c=0 \
        r=6.80586
    re2183 (\1222\:GNDA \1072\:GNDA) analogLib_presistor_schematic c=0 \
        r=0.124589
    re2184 (\1222\:GNDA \1243\:GNDA) analogLib_presistor_schematic c=0 \
        r=0.09938
    re2185 (\1151\:GNDA \1245\:GNDA) analogLib_presistor_schematic c=0 \
        r=0.630602
    re2186 (\1245\:GNDA \1246\:GNDA) analogLib_presistor_schematic c=0 \
        r=0.865858
    re2187 (\1246\:GNDA \1247\:GNDA) analogLib_presistor_schematic c=0 \
        r=0.183151
    re2188 (\1230\:GNDA \1248\:GNDA) analogLib_presistor_schematic c=0 \
        r=0.049845
    re2189 (\1248\:GNDA \1249\:GNDA) analogLib_presistor_schematic c=0 \
        r=0.069538
    re2190 (\1231\:GNDA \861\:GNDA) analogLib_presistor_schematic c=0 \
        r=0.048563
    re2191 (\1166\:GNDA \1250\:GNDA) analogLib_presistor_schematic c=0 \
        r=0.037666
    re2193 (\1250\:GNDA \1251\:GNDA) analogLib_presistor_schematic c=0 \
        r=9.90141
    re2196 (\1214\:GNDA \1255\:GNDA) analogLib_presistor_schematic c=0 \
        r=0.630602
    re2197 (\1255\:GNDA \1233\:GNDA) analogLib_presistor_schematic c=0 \
        r=6.80586
    re2198 (\1237\:GNDA \1257\:GNDA) analogLib_presistor_schematic c=0 \
        r=0.630602
    re2199 (\1257\:GNDA \1258\:GNDA) analogLib_presistor_schematic c=0 \
        r=0.868342
    re2200 (\1258\:GNDA \1259\:GNDA) analogLib_presistor_schematic c=0 \
        r=0.331906
    re2202 (\1200\:GNDA \1201\:GNDA) analogLib_presistor_schematic c=0 \
        r=8.48686
    re2203 (\1243\:GNDA \1204\:GNDA) analogLib_presistor_schematic c=0 \
        r=0.010395
    re2204 (\1243\:GNDA \1261\:GNDA) analogLib_presistor_schematic c=0 \
        r=0.088992
    re2205 (\1247\:GNDA \1151\:GNDA) analogLib_presistor_schematic c=0 \
        r=0.231809
    re2206 (\1247\:GNDA \1263\:GNDA) analogLib_presistor_schematic c=0 \
        r=0.073114
    re2207 (\1263\:GNDA \1264\:GNDA) analogLib_presistor_schematic c=0 \
        r=0.231112
    re2208 (\1248\:GNDA \1225\:GNDA) analogLib_presistor_schematic c=0 \
        r=0.170294
    re2209 (\1249\:GNDA \862\:GNDA) analogLib_presistor_schematic c=0 \
        r=0.048563
    re2210 (\1250\:GNDA \1266\:GNDA) analogLib_presistor_schematic c=0 \
        r=0.630602
    re2211 (\1266\:GNDA \1267\:GNDA) analogLib_presistor_schematic c=0 \
        r=0.868342
    re2212 (\1267\:GNDA \1268\:GNDA) analogLib_presistor_schematic c=0 \
        r=0.331906
    re2214 (\1214\:GNDA \1215\:GNDA) analogLib_presistor_schematic c=0 \
        r=8.48686
    re2217 (\1237\:GNDA \1272\:GNDA) analogLib_presistor_schematic c=0 \
        r=0.630602
    re2218 (\1272\:GNDA \1256\:GNDA) analogLib_presistor_schematic c=0 \
        r=6.80586
    re2219 (\1200\:GNDA \1273\:GNDA) analogLib_presistor_schematic c=0 \
        r=0.037666
    re2221 (\1273\:GNDA \1274\:GNDA) analogLib_presistor_schematic c=0 \
        r=9.90141
    re2222 (\1261\:GNDA \1071\:GNDA) analogLib_presistor_schematic c=0 \
        r=0.183483
    re2223 (\1261\:GNDA \1222\:GNDA) analogLib_presistor_schematic c=0 \
        r=0.036106
    re2224 (\1261\:GNDA \1276\:GNDA) analogLib_presistor_schematic c=0 \
        r=0.103723
    re2225 (\1276\:GNDA \1277\:GNDA) analogLib_presistor_schematic c=0 \
        r=0.868342
    re2226 (\1277\:GNDA \1067\:GNDA) analogLib_presistor_schematic c=0 \
        r=0.630602
    re2229 (\1264\:GNDA \1185\:GNDA) analogLib_presistor_schematic c=0 \
        r=0.087945
    re2230 (\1264\:GNDA \1247\:GNDA) analogLib_presistor_schematic c=0 \
        r=0.061682
    re2231 (\1264\:GNDA \1280\:GNDA) analogLib_presistor_schematic c=0 \
        r=0.063019
    re2232 (\1281\:GNDA \1225\:GNDA) analogLib_presistor_schematic c=0 \
        r=0.009984
    re2234 (\1225\:GNDA \1283\:GNDA) analogLib_presistor_schematic c=0 \
        r=0.037666
    re2236 (\1283\:GNDA \1286\:GNDA) analogLib_presistor_schematic c=0 \
        r=0.024785
    re2237 (\1286\:GNDA \1287\:GNDA) analogLib_presistor_schematic c=0 \
        r=0.260934
    re2238 (\1287\:GNDA \1288\:GNDA) analogLib_presistor_schematic c=0 \
        r=0.043549
    re2239 (\1288\:GNDA \1289\:GNDA) analogLib_presistor_schematic c=0 \
        r=0.069538
    re2242 (\1250\:GNDA \1292\:GNDA) analogLib_presistor_schematic c=0 \
        r=0.630602
    re2243 (\1292\:GNDA \1265\:GNDA) analogLib_presistor_schematic c=0 \
        r=6.80586
    re2244 (\1214\:GNDA \1293\:GNDA) analogLib_presistor_schematic c=0 \
        r=0.037666
    re2246 (\1293\:GNDA \1294\:GNDA) analogLib_presistor_schematic c=0 \
        r=9.90141
    re2248 (\1237\:GNDA \1238\:GNDA) analogLib_presistor_schematic c=0 \
        r=8.48686
    re2249 (\1273\:GNDA \1298\:GNDA) analogLib_presistor_schematic c=0 \
        r=0.630602
    re2250 (\1298\:GNDA \1299\:GNDA) analogLib_presistor_schematic c=0 \
        r=0.868342
    re2251 (\1299\:GNDA \1300\:GNDA) analogLib_presistor_schematic c=0 \
        r=0.331906
    re2252 (\1280\:GNDA \1156\:GNDA) analogLib_presistor_schematic c=0 \
        r=0.124589
    re2253 (\1280\:GNDA \1301\:GNDA) analogLib_presistor_schematic c=0 \
        r=0.09938
    re2254 (\1225\:GNDA \1303\:GNDA) analogLib_presistor_schematic c=0 \
        r=0.630602
    re2255 (\1303\:GNDA \1304\:GNDA) analogLib_presistor_schematic c=0 \
        r=0.865858
    re2256 (\1304\:GNDA \1305\:GNDA) analogLib_presistor_schematic c=0 \
        r=0.169601
    re2257 (\1288\:GNDA \1306\:GNDA) analogLib_presistor_schematic c=0 \
        r=0.050666
    re2258 (\1306\:GNDA \1307\:GNDA) analogLib_presistor_schematic c=0 \
        r=0.069538
    re2259 (\1289\:GNDA \863\:GNDA) analogLib_presistor_schematic c=0 \
        r=0.048563
    re2261 (\1250\:GNDA \1251\:GNDA) analogLib_presistor_schematic c=0 \
        r=8.48686
    re2262 (\1293\:GNDA \1310\:GNDA) analogLib_presistor_schematic c=0 \
        r=0.630602
    re2263 (\1310\:GNDA \1311\:GNDA) analogLib_presistor_schematic c=0 \
        r=0.868342
    re2264 (\1311\:GNDA \1312\:GNDA) analogLib_presistor_schematic c=0 \
        r=0.331906
    re2265 (\1237\:GNDA \1313\:GNDA) analogLib_presistor_schematic c=0 \
        r=0.037666
    re2267 (\1313\:GNDA \1314\:GNDA) analogLib_presistor_schematic c=0 \
        r=9.90141
    re2270 (\1273\:GNDA \1318\:GNDA) analogLib_presistor_schematic c=0 \
        r=0.630602
    re2271 (\1318\:GNDA \1297\:GNDA) analogLib_presistor_schematic c=0 \
        r=6.80586
    re2272 (\1301\:GNDA \1263\:GNDA) analogLib_presistor_schematic c=0 \
        r=0.010395
    re2273 (\1301\:GNDA \1319\:GNDA) analogLib_presistor_schematic c=0 \
        r=0.090086
    re2274 (\1305\:GNDA \1225\:GNDA) analogLib_presistor_schematic c=0 \
        r=0.198545
    re2275 (\1305\:GNDA \1321\:GNDA) analogLib_presistor_schematic c=0 \
        r=0.072756
    re2276 (\1321\:GNDA \1322\:GNDA) analogLib_presistor_schematic c=0 \
        r=0.231112
    re2277 (\1306\:GNDA \1283\:GNDA) analogLib_presistor_schematic c=0 \
        r=0.170829
    re2278 (\1307\:GNDA \864\:GNDA) analogLib_presistor_schematic c=0 \
        r=0.048563
    re2279 (\1250\:GNDA \1323\:GNDA) analogLib_presistor_schematic c=0 \
        r=0.037666
    re2281 (\1323\:GNDA \1326\:GNDA) analogLib_presistor_schematic c=0 \
        r=0.002122
    re2282 (\1326\:GNDA \1327\:GNDA) analogLib_presistor_schematic c=0 \
        r=0.253422
    re2283 (\1327\:GNDA \1328\:GNDA) analogLib_presistor_schematic c=0 \
        r=0.006407
    re2286 (\1293\:GNDA \1331\:GNDA) analogLib_presistor_schematic c=0 \
        r=0.630602
    re2287 (\1331\:GNDA \1309\:GNDA) analogLib_presistor_schematic c=0 \
        r=6.80586
    re2288 (\1313\:GNDA \1333\:GNDA) analogLib_presistor_schematic c=0 \
        r=0.630602
    re2289 (\1333\:GNDA \1334\:GNDA) analogLib_presistor_schematic c=0 \
        r=0.868342
    re2290 (\1334\:GNDA \1335\:GNDA) analogLib_presistor_schematic c=0 \
        r=0.331906
    re2292 (\1273\:GNDA \1274\:GNDA) analogLib_presistor_schematic c=0 \
        r=8.48686
    re2293 (\1319\:GNDA \1155\:GNDA) analogLib_presistor_schematic c=0 \
        r=0.426404
    re2294 (\1319\:GNDA \1280\:GNDA) analogLib_presistor_schematic c=0 \
        r=0.030089
    re2295 (\1319\:GNDA \1337\:GNDA) analogLib_presistor_schematic c=0 \
        r=0.12063
    re2296 (\1337\:GNDA \1338\:GNDA) analogLib_presistor_schematic c=0 \
        r=0.868342
    re2297 (\1338\:GNDA \1151\:GNDA) analogLib_presistor_schematic c=0 \
        r=0.630602
    re2300 (\1322\:GNDA \1248\:GNDA) analogLib_presistor_schematic c=0 \
        r=0.087945
    re2301 (\1322\:GNDA \1305\:GNDA) analogLib_presistor_schematic c=0 \
        r=0.066362
    re2302 (\1322\:GNDA \1341\:GNDA) analogLib_presistor_schematic c=0 \
        r=0.063019
    re2303 (\1342\:GNDA \1283\:GNDA) analogLib_presistor_schematic c=0 \
        r=0.009984
    re2305 (\1283\:GNDA \1344\:GNDA) analogLib_presistor_schematic c=0 \
        r=0.037666
    re2307 (\1344\:GNDA \1347\:GNDA) analogLib_presistor_schematic c=0 \
        r=0.009884
    re2308 (\1344\:GNDA \1348\:GNDA) analogLib_presistor_schematic c=0 \
        r=0.143087
    re2309 (\1344\:GNDA \1349\:GNDA) analogLib_presistor_schematic c=0 \
        r=0.048644
    re2310 (\1328\:GNDA \1323\:GNDA) analogLib_presistor_schematic c=0 \
        r=0.412311
    re2312 (\1293\:GNDA \1294\:GNDA) analogLib_presistor_schematic c=0 \
        r=8.48686
    re2315 (\1313\:GNDA \1353\:GNDA) analogLib_presistor_schematic c=0 \
        r=0.630602
    re2316 (\1353\:GNDA \1332\:GNDA) analogLib_presistor_schematic c=0 \
        r=6.80586
    re2317 (\1273\:GNDA \1354\:GNDA) analogLib_presistor_schematic c=0 \
        r=0.037666
    re2319 (\1354\:GNDA \1357\:GNDA) analogLib_presistor_schematic c=0 \
        r=0.009884
    re2323 (\1360\:GNDA \1354\:GNDA) analogLib_presistor_schematic c=0 \
        r=0.009984
    re2325 (\1354\:GNDA \1362\:GNDA) analogLib_presistor_schematic c=0 \
        r=0.095962
    re2326 (\1341\:GNDA \1230\:GNDA) analogLib_presistor_schematic c=0 \
        r=0.124589
    re2327 (\1341\:GNDA \1363\:GNDA) analogLib_presistor_schematic c=0 \
        r=0.09938
    re2328 (\1283\:GNDA \1365\:GNDA) analogLib_presistor_schematic c=0 \
        r=0.630602
    re2329 (\1365\:GNDA \1366\:GNDA) analogLib_presistor_schematic c=0 \
        r=0.865858
    re2330 (\1366\:GNDA \1367\:GNDA) analogLib_presistor_schematic c=0 \
        r=0.163792
    re2331 (\1348\:GNDA \1368\:GNDA) analogLib_presistor_schematic c=0 \
        r=0.048374
    re2332 (\1368\:GNDA \1344\:GNDA) analogLib_presistor_schematic c=0 \
        r=0.167314
    re2333 (\1368\:GNDA \1369\:GNDA) analogLib_presistor_schematic c=0 \
        r=0.041872
    re2334 (\1349\:GNDA \865\:GNDA) analogLib_presistor_schematic c=0 \
        r=0.047321
    re2335 (\1370\:GNDA \1323\:GNDA) analogLib_presistor_schematic c=0 \
        r=0.009984
    re2337 (\1323\:GNDA \1372\:GNDA) analogLib_presistor_schematic c=0 \
        r=0.095962
    re2338 (\1293\:GNDA \1373\:GNDA) analogLib_presistor_schematic c=0 \
        r=0.037666
    re2340 (\1373\:GNDA \1374\:GNDA) analogLib_presistor_schematic c=0 \
        r=9.90141
    re2342 (\1313\:GNDA \1314\:GNDA) analogLib_presistor_schematic c=0 \
        r=8.48686
    re2343 (\1354\:GNDA \1378\:GNDA) analogLib_presistor_schematic c=0 \
        r=0.630602
    re2344 (\1378\:GNDA \1379\:GNDA) analogLib_presistor_schematic c=0 \
        r=0.865858
    re2345 (\1379\:GNDA \1380\:GNDA) analogLib_presistor_schematic c=0 \
        r=0.343246
    re2346 (\1380\:GNDA \1381\:GNDA) analogLib_presistor_schematic c=0 \
        r=0.014401
    re2347 (\1362\:GNDA \213\:GNDA) analogLib_presistor_schematic c=0 \
        r=0.147801
    re2348 (\1363\:GNDA \1321\:GNDA) analogLib_presistor_schematic c=0 \
        r=0.010395
    re2349 (\1363\:GNDA \1382\:GNDA) analogLib_presistor_schematic c=0 \
        r=0.089712
    re2350 (\1367\:GNDA \1283\:GNDA) analogLib_presistor_schematic c=0 \
        r=0.187008
    re2351 (\1367\:GNDA \1384\:GNDA) analogLib_presistor_schematic c=0 \
        r=0.072606
    re2352 (\1384\:GNDA \1385\:GNDA) analogLib_presistor_schematic c=0 \
        r=0.231112
    re2353 (\1386\:GNDA \1344\:GNDA) analogLib_presistor_schematic c=0 \
        r=0.009984
    re2355 (\1344\:GNDA \1388\:GNDA) analogLib_presistor_schematic c=0 \
        r=0.037666
    re2357 (\1388\:GNDA \1391\:GNDA) analogLib_presistor_schematic c=0 \
        r=0.009884
    re2358 (\1388\:GNDA \1392\:GNDA) analogLib_presistor_schematic c=0 \
        r=0.145191
    re2359 (\1388\:GNDA \1393\:GNDA) analogLib_presistor_schematic c=0 \
        r=0.049086
    re2360 (\1369\:GNDA \866\:GNDA) analogLib_presistor_schematic c=0 \
        r=0.047321
    re2361 (\1323\:GNDA \1395\:GNDA) analogLib_presistor_schematic c=0 \
        r=0.630602
    re2362 (\1395\:GNDA \1396\:GNDA) analogLib_presistor_schematic c=0 \
        r=0.865858
    re2363 (\1396\:GNDA \1397\:GNDA) analogLib_presistor_schematic c=0 \
        r=0.172743
    re2364 (\1372\:GNDA \205\:GNDA) analogLib_presistor_schematic c=0 \
        r=0.114431
    re2365 (\1373\:GNDA \1399\:GNDA) analogLib_presistor_schematic c=0 \
        r=0.630602
    re2366 (\1399\:GNDA \1400\:GNDA) analogLib_presistor_schematic c=0 \
        r=0.868342
    re2367 (\1400\:GNDA \1401\:GNDA) analogLib_presistor_schematic c=0 \
        r=0.331906
    re2368 (\1313\:GNDA \1402\:GNDA) analogLib_presistor_schematic c=0 \
        r=0.037666
    re2370 (\1402\:GNDA \1403\:GNDA) analogLib_presistor_schematic c=0 \
        r=9.90141
    re2371 (\1380\:GNDA \1405\:GNDA) analogLib_presistor_schematic c=0 \
        r=0.596081
    re2372 (\1380\:GNDA \1406\:GNDA) analogLib_presistor_schematic c=0 \
        r=0.243906
    re2373 (\1406\:GNDA \1407\:GNDA) analogLib_presistor_schematic c=0 \
        r=0.868342
    re2374 (\1407\:GNDA \1354\:GNDA) analogLib_presistor_schematic c=0 \
        r=0.630602
    re2377 (\1381\:GNDA \1354\:GNDA) analogLib_presistor_schematic c=0 \
        r=0.014685
    re2378 (\1382\:GNDA \1229\:GNDA) analogLib_presistor_schematic c=0 \
        r=0.293778
    re2379 (\1382\:GNDA \1341\:GNDA) analogLib_presistor_schematic c=0 \
        r=0.032094
    re2380 (\1382\:GNDA \1410\:GNDA) analogLib_presistor_schematic c=0 \
        r=0.115036
    re2381 (\1410\:GNDA \1411\:GNDA) analogLib_presistor_schematic c=0 \
        r=0.868342
    re2382 (\1411\:GNDA \1225\:GNDA) analogLib_presistor_schematic c=0 \
        r=0.630602
    re2385 (\1385\:GNDA \1306\:GNDA) analogLib_presistor_schematic c=0 \
        r=0.087945
    re2386 (\1385\:GNDA \1367\:GNDA) analogLib_presistor_schematic c=0 \
        r=0.068368
    re2387 (\1385\:GNDA \1414\:GNDA) analogLib_presistor_schematic c=0 \
        r=0.063019
    re2388 (\1344\:GNDA \1416\:GNDA) analogLib_presistor_schematic c=0 \
        r=0.630602
    re2389 (\1416\:GNDA \1417\:GNDA) analogLib_presistor_schematic c=0 \
        r=0.865858
    re2390 (\1417\:GNDA \1418\:GNDA) analogLib_presistor_schematic c=0 \
        r=0.183193
    re2391 (\1392\:GNDA \1419\:GNDA) analogLib_presistor_schematic c=0 \
        r=0.049086
    re2392 (\1419\:GNDA \1388\:GNDA) analogLib_presistor_schematic c=0 \
        r=0.169775
    re2393 (\1419\:GNDA \1420\:GNDA) analogLib_presistor_schematic c=0 \
        r=0.04354
    re2394 (\1393\:GNDA \867\:GNDA) analogLib_presistor_schematic c=0 \
        r=0.048563
    re2395 (\1397\:GNDA \1323\:GNDA) analogLib_presistor_schematic c=0 \
        r=0.189792
    re2396 (\1397\:GNDA \1422\:GNDA) analogLib_presistor_schematic c=0 \
        r=0.109772
    re2397 (\1422\:GNDA \1423\:GNDA) analogLib_presistor_schematic c=0 \
        r=0.085501
    re2400 (\1373\:GNDA \1426\:GNDA) analogLib_presistor_schematic c=0 \
        r=0.630602
    re2401 (\1426\:GNDA \1398\:GNDA) analogLib_presistor_schematic c=0 \
        r=6.80586
    re2402 (\1402\:GNDA \1428\:GNDA) analogLib_presistor_schematic c=0 \
        r=0.630602
    re2403 (\1428\:GNDA \1429\:GNDA) analogLib_presistor_schematic c=0 \
        r=0.868342
    re2404 (\1429\:GNDA \1430\:GNDA) analogLib_presistor_schematic c=0 \
        r=0.331906
    re2405 (\1414\:GNDA \1288\:GNDA) analogLib_presistor_schematic c=0 \
        r=0.124589
    re2406 (\1414\:GNDA \1431\:GNDA) analogLib_presistor_schematic c=0 \
        r=0.09938
    re2407 (\1418\:GNDA \1368\:GNDA) analogLib_presistor_schematic c=0 \
        r=0.076107
    re2408 (\1418\:GNDA \1433\:GNDA) analogLib_presistor_schematic c=0 \
        r=0.084747
    re2409 (\1434\:GNDA \1388\:GNDA) analogLib_presistor_schematic c=0 \
        r=0.009984
    re2411 (\1388\:GNDA \1436\:GNDA) analogLib_presistor_schematic c=0 \
        r=0.095962
    re2412 (\1420\:GNDA \868\:GNDA) analogLib_presistor_schematic c=0 \
        r=0.048563
    re2413 (\1423\:GNDA \1327\:GNDA) analogLib_presistor_schematic c=0 \
        r=0.038246
    re2414 (\1423\:GNDA \1397\:GNDA) analogLib_presistor_schematic c=0 \
        r=0.069839
    re2415 (\1423\:GNDA \1437\:GNDA) analogLib_presistor_schematic c=0 \
        r=0.165439
    re2416 (\1437\:GNDA \1438\:GNDA) analogLib_presistor_schematic c=0 \
        r=0.868342
    re2417 (\1438\:GNDA \1323\:GNDA) analogLib_presistor_schematic c=0 \
        r=0.630602
    re2421 (\1373\:GNDA \1374\:GNDA) analogLib_presistor_schematic c=0 \
        r=8.48686
    re2424 (\1402\:GNDA \1444\:GNDA) analogLib_presistor_schematic c=0 \
        r=0.630602
    re2425 (\1444\:GNDA \1427\:GNDA) analogLib_presistor_schematic c=0 \
        r=6.80586
    re2426 (\1431\:GNDA \1384\:GNDA) analogLib_presistor_schematic c=0 \
        r=0.010395
    re2427 (\1431\:GNDA \1445\:GNDA) analogLib_presistor_schematic c=0 \
        r=0.089348
    re2428 (\1433\:GNDA \1446\:GNDA) analogLib_presistor_schematic c=0 \
        r=0.07203
    re2429 (\1388\:GNDA \1448\:GNDA) analogLib_presistor_schematic c=0 \
        r=0.630602
    re2430 (\1448\:GNDA \1449\:GNDA) analogLib_presistor_schematic c=0 \
        r=0.865858
    re2431 (\1449\:GNDA \1450\:GNDA) analogLib_presistor_schematic c=0 \
        r=0.209752
    re2432 (\1436\:GNDA \904\:GNDA) analogLib_presistor_schematic c=0 \
        r=0.091452
    re2433 (\1373\:GNDA \1451\:GNDA) analogLib_presistor_schematic c=0 \
        r=0.037666
    re2435 (\1451\:GNDA \1454\:GNDA) analogLib_presistor_schematic c=0 \
        r=0.009884
    re2440 (\1402\:GNDA \1403\:GNDA) analogLib_presistor_schematic c=0 \
        r=8.48686
    re2441 (\1445\:GNDA \1287\:GNDA) analogLib_presistor_schematic c=0 \
        r=0.225428
    re2442 (\1445\:GNDA \1414\:GNDA) analogLib_presistor_schematic c=0 \
        r=0.0341
    re2443 (\1445\:GNDA \1458\:GNDA) analogLib_presistor_schematic c=0 \
        r=0.109398
    re2444 (\1458\:GNDA \1459\:GNDA) analogLib_presistor_schematic c=0 \
        r=0.868342
    re2445 (\1459\:GNDA \1283\:GNDA) analogLib_presistor_schematic c=0 \
        r=0.630602
    re2448 (\1446\:GNDA \1344\:GNDA) analogLib_presistor_schematic c=0 \
        r=0.10136
    re2449 (\1446\:GNDA \1418\:GNDA) analogLib_presistor_schematic c=0 \
        r=0.123029
    re2450 (\1446\:GNDA \1462\:GNDA) analogLib_presistor_schematic c=0 \
        r=0.138091
    re2451 (\1462\:GNDA \1463\:GNDA) analogLib_presistor_schematic c=0 \
        r=0.868342
    re2452 (\1463\:GNDA \1344\:GNDA) analogLib_presistor_schematic c=0 \
        r=0.630602
    re2455 (\1450\:GNDA \1419\:GNDA) analogLib_presistor_schematic c=0 \
        r=0.086945
    re2456 (\1450\:GNDA \1467\:GNDA) analogLib_presistor_schematic c=0 \
        r=0.089293
    re2457 (\1468\:GNDA \1451\:GNDA) analogLib_presistor_schematic c=0 \
        r=0.009984
    re2459 (\1451\:GNDA \1470\:GNDA) analogLib_presistor_schematic c=0 \
        r=0.095962
    re2460 (\1402\:GNDA \1471\:GNDA) analogLib_presistor_schematic c=0 \
        r=0.037666
    re2462 (\1471\:GNDA \1474\:GNDA) analogLib_presistor_schematic c=0 \
        r=0.009884
    re2466 (\1477\:GNDA \1471\:GNDA) analogLib_presistor_schematic c=0 \
        r=0.009984
    re2468 (\1471\:GNDA \1479\:GNDA) analogLib_presistor_schematic c=0 \
        r=0.095962
    re2469 (\1467\:GNDA \1480\:GNDA) analogLib_presistor_schematic c=0 \
        r=0.071845
    re2470 (\1451\:GNDA \1482\:GNDA) analogLib_presistor_schematic c=0 \
        r=0.630602
    re2471 (\1482\:GNDA \1483\:GNDA) analogLib_presistor_schematic c=0 \
        r=0.865858
    re2472 (\1483\:GNDA \1484\:GNDA) analogLib_presistor_schematic c=0 \
        r=0.3249
    re2473 (\1484\:GNDA \1485\:GNDA) analogLib_presistor_schematic c=0 \
        r=0.014855
    re2474 (\1470\:GNDA \207\:GNDA) analogLib_presistor_schematic c=0 \
        r=0.134513
    re2475 (\1471\:GNDA \1487\:GNDA) analogLib_presistor_schematic c=0 \
        r=0.630602
    re2476 (\1487\:GNDA \1488\:GNDA) analogLib_presistor_schematic c=0 \
        r=0.865858
    re2477 (\1488\:GNDA \1489\:GNDA) analogLib_presistor_schematic c=0 \
        r=0.335308
    re2478 (\1489\:GNDA \1490\:GNDA) analogLib_presistor_schematic c=0 \
        r=0.015644
    re2479 (\1479\:GNDA \210\:GNDA) analogLib_presistor_schematic c=0 \
        r=0.114431
    re2480 (\1480\:GNDA \1388\:GNDA) analogLib_presistor_schematic c=0 \
        r=0.094925
    re2481 (\1480\:GNDA \1450\:GNDA) analogLib_presistor_schematic c=0 \
        r=0.116342
    re2482 (\1480\:GNDA \1491\:GNDA) analogLib_presistor_schematic c=0 \
        r=0.130363
    re2483 (\1491\:GNDA \1492\:GNDA) analogLib_presistor_schematic c=0 \
        r=0.868342
    re2484 (\1492\:GNDA \1388\:GNDA) analogLib_presistor_schematic c=0 \
        r=0.630602
    re2487 (\1484\:GNDA \1495\:GNDA) analogLib_presistor_schematic c=0 \
        r=0.596756
    re2488 (\1484\:GNDA \1496\:GNDA) analogLib_presistor_schematic c=0 \
        r=0.262813
    re2489 (\1496\:GNDA \1497\:GNDA) analogLib_presistor_schematic c=0 \
        r=0.868342
    re2490 (\1497\:GNDA \1451\:GNDA) analogLib_presistor_schematic c=0 \
        r=0.630602
    re2493 (\1485\:GNDA \1451\:GNDA) analogLib_presistor_schematic c=0 \
        r=0.015156
    re2494 (\1489\:GNDA \1500\:GNDA) analogLib_presistor_schematic c=0 \
        r=0.59793
    re2495 (\1489\:GNDA \1501\:GNDA) analogLib_presistor_schematic c=0 \
        r=0.253353
    re2496 (\1501\:GNDA \1502\:GNDA) analogLib_presistor_schematic c=0 \
        r=0.868342
    re2497 (\1502\:GNDA \1471\:GNDA) analogLib_presistor_schematic c=0 \
        r=0.630602
    re2500 (\1490\:GNDA \1471\:GNDA) analogLib_presistor_schematic c=0 \
        r=0.015975
    re2501 (\154\:GNDA \155\:GNDA) analogLib_presistor_schematic c=0 \
        r=8.48571
    re2502 (\154\:GNDA \151\:GNDA) analogLib_presistor_schematic c=0 r=3.3
    re2503 (\158\:GNDA \157\:GNDA) analogLib_presistor_schematic c=0 \
        r=3.7125
    re2504 (\160\:GNDA \157\:GNDA) analogLib_presistor_schematic c=0 \
        r=2.475
    re2505 (\163\:GNDA \162\:GNDA) analogLib_presistor_schematic c=0 \
        r=3.7125
    re2506 (\165\:GNDA \162\:GNDA) analogLib_presistor_schematic c=0 \
        r=2.475
    re2507 (\168\:GNDA \167\:GNDA) analogLib_presistor_schematic c=0 \
        r=3.7125
    re2508 (\170\:GNDA \167\:GNDA) analogLib_presistor_schematic c=0 \
        r=2.475
    re2509 (\173\:GNDA \172\:GNDA) analogLib_presistor_schematic c=0 \
        r=3.7125
    re2510 (\175\:GNDA \172\:GNDA) analogLib_presistor_schematic c=0 \
        r=2.475
    re2511 (\178\:GNDA \177\:GNDA) analogLib_presistor_schematic c=0 \
        r=3.7125
    re2512 (\180\:GNDA \177\:GNDA) analogLib_presistor_schematic c=0 \
        r=2.475
    re2513 (\183\:GNDA \182\:GNDA) analogLib_presistor_schematic c=0 \
        r=3.7125
    re2514 (\185\:GNDA \182\:GNDA) analogLib_presistor_schematic c=0 \
        r=2.475
    re2515 (\188\:GNDA \187\:GNDA) analogLib_presistor_schematic c=0 \
        r=3.7125
    re2516 (\190\:GNDA \187\:GNDA) analogLib_presistor_schematic c=0 \
        r=2.475
    re2517 (\193\:GNDA \192\:GNDA) analogLib_presistor_schematic c=0 r=3.3
    re2518 (\193\:GNDA \195\:GNDA) analogLib_presistor_schematic c=0 r=9.9
    re2519 (\193\:GNDA \198\:GNDA) analogLib_presistor_schematic c=0 \
        r=8.48571
    re2520 (\193\:GNDA \192\:GNDA) analogLib_presistor_schematic c=0 r=3.3
    re2521 (\203\:GNDA \204\:GNDA) analogLib_presistor_schematic c=0 \
        r=2.97
    re2522 (\203\:GNDA \206\:GNDA) analogLib_presistor_schematic c=0 \
        r=2.97
    re2523 (\203\:GNDA \208\:GNDA) analogLib_presistor_schematic c=0 \
        r=2.97
    re2524 (\203\:GNDA \211\:GNDA) analogLib_presistor_schematic c=0 \
        r=2.97
    re2525 (\203\:GNDA \214\:GNDA) analogLib_presistor_schematic c=0 \
        r=2.97
    re2526 (\203\:GNDA \215\:GNDA) analogLib_presistor_schematic c=0 \
        r=2.97
    re2527 (\203\:GNDA \216\:GNDA) analogLib_presistor_schematic c=0 \
        r=2.97
    re2528 (\218\:GNDA \219\:GNDA) analogLib_presistor_schematic c=0 \
        r=4.95
    re2529 (\218\:GNDA \220\:GNDA) analogLib_presistor_schematic c=0 \
        r=1.485
    re2530 (\218\:GNDA \221\:GNDA) analogLib_presistor_schematic c=0 \
        r=1.485
    re2531 (\218\:GNDA \222\:GNDA) analogLib_presistor_schematic c=0 \
        r=1.485
    re2532 (\218\:GNDA \226\:GNDA) analogLib_presistor_schematic c=0 \
        r=1.485
    re2533 (\218\:GNDA \227\:GNDA) analogLib_presistor_schematic c=0 \
        r=1.485
    re2534 (\218\:GNDA \228\:GNDA) analogLib_presistor_schematic c=0 \
        r=1.485
    re2535 (\230\:GNDA \231\:GNDA) analogLib_presistor_schematic c=0 \
        r=2.97
    re2536 (\230\:GNDA \233\:GNDA) analogLib_presistor_schematic c=0 \
        r=2.97
    re2537 (\230\:GNDA \234\:GNDA) analogLib_presistor_schematic c=0 \
        r=2.97
    re2538 (\230\:GNDA \235\:GNDA) analogLib_presistor_schematic c=0 \
        r=2.97
    re2539 (\230\:GNDA \236\:GNDA) analogLib_presistor_schematic c=0 \
        r=2.97
    re2540 (\230\:GNDA \237\:GNDA) analogLib_presistor_schematic c=0 \
        r=2.97
    re2541 (\230\:GNDA \238\:GNDA) analogLib_presistor_schematic c=0 \
        r=2.97
    re2542 (\230\:GNDA \239\:GNDA) analogLib_presistor_schematic c=0 \
        r=2.97
    re2543 (\230\:GNDA \241\:GNDA) analogLib_presistor_schematic c=0 \
        r=2.97
    re2544 (\230\:GNDA \242\:GNDA) analogLib_presistor_schematic c=0 \
        r=2.97
    re2545 (\230\:GNDA \244\:GNDA) analogLib_presistor_schematic c=0 \
        r=2.97
    re2546 (\230\:GNDA \246\:GNDA) analogLib_presistor_schematic c=0 \
        r=2.97
    re2547 (\230\:GNDA \247\:GNDA) analogLib_presistor_schematic c=0 \
        r=2.97
    re2548 (\230\:GNDA \248\:GNDA) analogLib_presistor_schematic c=0 \
        r=2.97
    re2549 (\230\:GNDA \249\:GNDA) analogLib_presistor_schematic c=0 \
        r=2.97
    re2550 (\230\:GNDA \251\:GNDA) analogLib_presistor_schematic c=0 \
        r=2.97
    re2551 (\230\:GNDA \252\:GNDA) analogLib_presistor_schematic c=0 \
        r=2.97
    re2552 (\230\:GNDA \253\:GNDA) analogLib_presistor_schematic c=0 \
        r=2.97
    re2553 (\230\:GNDA \254\:GNDA) analogLib_presistor_schematic c=0 \
        r=2.97
    re2554 (\230\:GNDA \255\:GNDA) analogLib_presistor_schematic c=0 \
        r=2.97
    re2555 (\230\:GNDA \256\:GNDA) analogLib_presistor_schematic c=0 \
        r=2.97
    re2556 (\230\:GNDA \257\:GNDA) analogLib_presistor_schematic c=0 \
        r=2.97
    re2557 (\230\:GNDA \258\:GNDA) analogLib_presistor_schematic c=0 \
        r=2.97
    re2558 (\230\:GNDA \259\:GNDA) analogLib_presistor_schematic c=0 \
        r=2.97
    re2559 (\230\:GNDA \260\:GNDA) analogLib_presistor_schematic c=0 \
        r=2.97
    re2560 (\230\:GNDA \261\:GNDA) analogLib_presistor_schematic c=0 \
        r=2.97
    re2561 (\230\:GNDA \262\:GNDA) analogLib_presistor_schematic c=0 \
        r=2.97
    re2562 (\230\:GNDA \263\:GNDA) analogLib_presistor_schematic c=0 \
        r=2.97
    re2563 (\230\:GNDA \264\:GNDA) analogLib_presistor_schematic c=0 \
        r=2.97
    re2564 (\230\:GNDA \265\:GNDA) analogLib_presistor_schematic c=0 \
        r=2.97
    re2565 (\230\:GNDA \266\:GNDA) analogLib_presistor_schematic c=0 \
        r=2.97
    re2566 (\230\:GNDA \267\:GNDA) analogLib_presistor_schematic c=0 \
        r=7.425
    re2567 (\230\:GNDA \268\:GNDA) analogLib_presistor_schematic c=0 \
        r=2.97
    re2568 (\230\:GNDA \269\:GNDA) analogLib_presistor_schematic c=0 \
        r=2.97
    re2569 (\230\:GNDA \270\:GNDA) analogLib_presistor_schematic c=0 \
        r=2.97
    re2570 (\230\:GNDA \271\:GNDA) analogLib_presistor_schematic c=0 \
        r=2.97
    re2571 (\230\:GNDA \272\:GNDA) analogLib_presistor_schematic c=0 \
        r=2.97
    re2572 (\230\:GNDA \273\:GNDA) analogLib_presistor_schematic c=0 \
        r=2.97
    re2573 (\230\:GNDA \274\:GNDA) analogLib_presistor_schematic c=0 \
        r=2.97
    re2574 (\230\:GNDA \275\:GNDA) analogLib_presistor_schematic c=0 \
        r=2.97
    re2575 (\230\:GNDA \276\:GNDA) analogLib_presistor_schematic c=0 \
        r=2.97
    re2576 (\230\:GNDA \277\:GNDA) analogLib_presistor_schematic c=0 \
        r=2.97
    re2577 (\230\:GNDA \278\:GNDA) analogLib_presistor_schematic c=0 \
        r=2.97
    re2578 (\230\:GNDA \279\:GNDA) analogLib_presistor_schematic c=0 \
        r=2.97
    re2579 (\230\:GNDA \280\:GNDA) analogLib_presistor_schematic c=0 \
        r=2.97
    re2580 (\230\:GNDA \281\:GNDA) analogLib_presistor_schematic c=0 \
        r=2.97
    re2581 (\230\:GNDA \282\:GNDA) analogLib_presistor_schematic c=0 \
        r=2.97
    re2582 (\230\:GNDA \283\:GNDA) analogLib_presistor_schematic c=0 \
        r=2.97
    re2583 (\230\:GNDA \284\:GNDA) analogLib_presistor_schematic c=0 \
        r=2.97
    re2584 (\230\:GNDA \285\:GNDA) analogLib_presistor_schematic c=0 \
        r=2.97
    re2585 (\230\:GNDA \286\:GNDA) analogLib_presistor_schematic c=0 \
        r=2.97
    re2586 (\230\:GNDA \287\:GNDA) analogLib_presistor_schematic c=0 \
        r=2.97
    re2587 (\230\:GNDA \288\:GNDA) analogLib_presistor_schematic c=0 \
        r=2.97
    re2588 (\230\:GNDA \289\:GNDA) analogLib_presistor_schematic c=0 \
        r=2.97
    re2589 (\230\:GNDA \290\:GNDA) analogLib_presistor_schematic c=0 \
        r=2.97
    re2590 (\230\:GNDA \291\:GNDA) analogLib_presistor_schematic c=0 \
        r=2.97
    re2591 (\230\:GNDA \292\:GNDA) analogLib_presistor_schematic c=0 \
        r=2.97
    re2592 (\230\:GNDA \293\:GNDA) analogLib_presistor_schematic c=0 \
        r=5.94
    re2593 (\230\:GNDA \294\:GNDA) analogLib_presistor_schematic c=0 \
        r=7.425
    re2594 (\230\:GNDA \295\:GNDA) analogLib_presistor_schematic c=0 \
        r=2.97
    re2595 (\230\:GNDA \296\:GNDA) analogLib_presistor_schematic c=0 \
        r=2.97
    re2596 (\230\:GNDA \297\:GNDA) analogLib_presistor_schematic c=0 \
        r=2.97
    re2597 (\230\:GNDA \298\:GNDA) analogLib_presistor_schematic c=0 \
        r=2.97
    re2598 (\230\:GNDA \299\:GNDA) analogLib_presistor_schematic c=0 \
        r=2.97
    re2599 (\230\:GNDA \300\:GNDA) analogLib_presistor_schematic c=0 \
        r=2.97
    re2600 (\230\:GNDA \301\:GNDA) analogLib_presistor_schematic c=0 \
        r=2.97
    re2601 (\230\:GNDA \302\:GNDA) analogLib_presistor_schematic c=0 \
        r=2.97
    re2602 (\230\:GNDA \303\:GNDA) analogLib_presistor_schematic c=0 \
        r=2.97
    re2603 (\230\:GNDA \304\:GNDA) analogLib_presistor_schematic c=0 \
        r=2.97
    re2604 (\230\:GNDA \305\:GNDA) analogLib_presistor_schematic c=0 \
        r=2.97
    re2605 (\230\:GNDA \306\:GNDA) analogLib_presistor_schematic c=0 \
        r=2.97
    re2606 (\230\:GNDA \307\:GNDA) analogLib_presistor_schematic c=0 \
        r=2.97
    re2607 (\230\:GNDA \308\:GNDA) analogLib_presistor_schematic c=0 \
        r=2.97
    re2608 (\230\:GNDA \309\:GNDA) analogLib_presistor_schematic c=0 \
        r=2.97
    re2609 (\230\:GNDA \310\:GNDA) analogLib_presistor_schematic c=0 \
        r=2.97
    re2610 (\230\:GNDA \311\:GNDA) analogLib_presistor_schematic c=0 \
        r=5.94
    re2611 (\230\:GNDA \312\:GNDA) analogLib_presistor_schematic c=0 \
        r=2.97
    re2612 (\230\:GNDA \313\:GNDA) analogLib_presistor_schematic c=0 \
        r=2.97
    re2613 (\230\:GNDA \314\:GNDA) analogLib_presistor_schematic c=0 \
        r=2.97
    re2614 (\230\:GNDA \314\:GNDA) analogLib_presistor_schematic c=0 \
        r=2.97
    re2615 (\230\:GNDA \316\:GNDA) analogLib_presistor_schematic c=0 \
        r=2.97
    re2616 (\230\:GNDA \318\:GNDA) analogLib_presistor_schematic c=0 \
        r=2.97
    re2617 (\230\:GNDA \319\:GNDA) analogLib_presistor_schematic c=0 \
        r=2.97
    re2618 (\230\:GNDA \322\:GNDA) analogLib_presistor_schematic c=0 \
        r=2.97
    re2619 (\230\:GNDA \323\:GNDA) analogLib_presistor_schematic c=0 \
        r=2.97
    re2620 (\218\:GNDA \324\:GNDA) analogLib_presistor_schematic c=0 \
        r=1.485
    re2621 (\218\:GNDA \325\:GNDA) analogLib_presistor_schematic c=0 \
        r=1.485
    re2622 (\218\:GNDA \328\:GNDA) analogLib_presistor_schematic c=0 \
        r=1.485
    re2623 (\218\:GNDA \334\:GNDA) analogLib_presistor_schematic c=0 \
        r=1.485
    re2624 (\218\:GNDA \335\:GNDA) analogLib_presistor_schematic c=0 \
        r=1.485
    re2625 (\218\:GNDA \336\:GNDA) analogLib_presistor_schematic c=0 \
        r=1.485
    re2626 (\218\:GNDA \336\:GNDA) analogLib_presistor_schematic c=0 \
        r=1.485
    re2627 (\218\:GNDA \338\:GNDA) analogLib_presistor_schematic c=0 \
        r=1.485
    re2628 (\218\:GNDA \339\:GNDA) analogLib_presistor_schematic c=0 \
        r=1.56316
    re2629 (\218\:GNDA \340\:GNDA) analogLib_presistor_schematic c=0 \
        r=2.475
    re2630 (\218\:GNDA \341\:GNDA) analogLib_presistor_schematic c=0 \
        r=1.485
    re2631 (\218\:GNDA \342\:GNDA) analogLib_presistor_schematic c=0 \
        r=1.485
    re2632 (\218\:GNDA \343\:GNDA) analogLib_presistor_schematic c=0 \
        r=1.485
    re2633 (\218\:GNDA \345\:GNDA) analogLib_presistor_schematic c=0 \
        r=1.485
    re2634 (\218\:GNDA \346\:GNDA) analogLib_presistor_schematic c=0 \
        r=1.485
    re2635 (\218\:GNDA \347\:GNDA) analogLib_presistor_schematic c=0 \
        r=1.485
    re2636 (\218\:GNDA \348\:GNDA) analogLib_presistor_schematic c=0 \
        r=4.95
    re2637 (\363\:GNDA \364\:GNDA) analogLib_presistor_schematic c=0 \
        r=8.48571
    re2638 (\363\:GNDA \360\:GNDA) analogLib_presistor_schematic c=0 r=3.3
    re2639 (\366\:GNDA \367\:GNDA) analogLib_presistor_schematic c=0 \
        r=2.12143
    re2640 (\366\:GNDA \368\:GNDA) analogLib_presistor_schematic c=0 \
        r=5.94
    re2641 (\366\:GNDA \370\:GNDA) analogLib_presistor_schematic c=0 \
        r=5.94
    re2642 (\366\:GNDA \371\:GNDA) analogLib_presistor_schematic c=0 \
        r=2.12143
    re2643 (\373\:GNDA \372\:GNDA) analogLib_presistor_schematic c=0 r=3.3
    re2644 (\373\:GNDA \375\:GNDA) analogLib_presistor_schematic c=0 \
        r=8.48571
    re2645 (\379\:GNDA \380\:GNDA) analogLib_presistor_schematic c=0 \
        r=5.94
    re2646 (\379\:GNDA \381\:GNDA) analogLib_presistor_schematic c=0 \
        r=2.12143
    re2647 (\373\:GNDA \372\:GNDA) analogLib_presistor_schematic c=0 \
        r=3.7125
    re2648 (\379\:GNDA \372\:GNDA) analogLib_presistor_schematic c=0 \
        r=2.475
    re2649 (\385\:GNDA \384\:GNDA) analogLib_presistor_schematic c=0 r=3.3
    re2650 (\385\:GNDA \387\:GNDA) analogLib_presistor_schematic c=0 \
        r=8.48571
    re2651 (\391\:GNDA \392\:GNDA) analogLib_presistor_schematic c=0 \
        r=5.94
    re2652 (\391\:GNDA \393\:GNDA) analogLib_presistor_schematic c=0 \
        r=2.12143
    re2653 (\385\:GNDA \384\:GNDA) analogLib_presistor_schematic c=0 \
        r=3.7125
    re2654 (\391\:GNDA \384\:GNDA) analogLib_presistor_schematic c=0 \
        r=2.475
    re2655 (\397\:GNDA \396\:GNDA) analogLib_presistor_schematic c=0 r=3.3
    re2656 (\397\:GNDA \399\:GNDA) analogLib_presistor_schematic c=0 \
        r=8.48571
    re2657 (\401\:GNDA \402\:GNDA) analogLib_presistor_schematic c=0 \
        r=5.94
    re2658 (\401\:GNDA \403\:GNDA) analogLib_presistor_schematic c=0 \
        r=2.12143
    re2659 (\397\:GNDA \396\:GNDA) analogLib_presistor_schematic c=0 \
        r=3.7125
    re2660 (\401\:GNDA \396\:GNDA) analogLib_presistor_schematic c=0 \
        r=2.475
    re2661 (\401\:GNDA \406\:GNDA) analogLib_presistor_schematic c=0 \
        r=2.12143
    re2662 (\401\:GNDA \407\:GNDA) analogLib_presistor_schematic c=0 \
        r=5.94
    re2663 (\397\:GNDA \410\:GNDA) analogLib_presistor_schematic c=0 r=9.9
    re2664 (\397\:GNDA \396\:GNDA) analogLib_presistor_schematic c=0 r=3.3
    re2665 (\413\:GNDA \412\:GNDA) analogLib_presistor_schematic c=0 r=3.3
    re2666 (\413\:GNDA \415\:GNDA) analogLib_presistor_schematic c=0 \
        r=8.48571
    re2667 (\419\:GNDA \420\:GNDA) analogLib_presistor_schematic c=0 \
        r=5.94
    re2668 (\419\:GNDA \421\:GNDA) analogLib_presistor_schematic c=0 \
        r=2.12143
    re2669 (\413\:GNDA \412\:GNDA) analogLib_presistor_schematic c=0 \
        r=3.7125
    re2670 (\419\:GNDA \412\:GNDA) analogLib_presistor_schematic c=0 \
        r=2.475
    re2671 (\425\:GNDA \424\:GNDA) analogLib_presistor_schematic c=0 r=3.3
    re2672 (\425\:GNDA \427\:GNDA) analogLib_presistor_schematic c=0 \
        r=8.48571
    re2673 (\431\:GNDA \432\:GNDA) analogLib_presistor_schematic c=0 \
        r=5.94
    re2674 (\431\:GNDA \433\:GNDA) analogLib_presistor_schematic c=0 \
        r=2.12143
    re2675 (\425\:GNDA \424\:GNDA) analogLib_presistor_schematic c=0 \
        r=3.7125
    re2676 (\431\:GNDA \424\:GNDA) analogLib_presistor_schematic c=0 \
        r=2.475
    re2677 (\437\:GNDA \436\:GNDA) analogLib_presistor_schematic c=0 r=3.3
    re2678 (\437\:GNDA \439\:GNDA) analogLib_presistor_schematic c=0 \
        r=8.48571
    re2679 (\443\:GNDA \444\:GNDA) analogLib_presistor_schematic c=0 \
        r=5.94
    re2680 (\443\:GNDA \445\:GNDA) analogLib_presistor_schematic c=0 \
        r=2.12143
    re2681 (\437\:GNDA \436\:GNDA) analogLib_presistor_schematic c=0 \
        r=3.7125
    re2682 (\443\:GNDA \436\:GNDA) analogLib_presistor_schematic c=0 \
        r=2.475
    re2683 (\449\:GNDA \448\:GNDA) analogLib_presistor_schematic c=0 r=3.3
    re2684 (\449\:GNDA \451\:GNDA) analogLib_presistor_schematic c=0 \
        r=8.48571
    re2685 (\455\:GNDA \456\:GNDA) analogLib_presistor_schematic c=0 \
        r=5.94
    re2686 (\455\:GNDA \457\:GNDA) analogLib_presistor_schematic c=0 \
        r=2.12143
    re2687 (\449\:GNDA \448\:GNDA) analogLib_presistor_schematic c=0 \
        r=3.7125
    re2688 (\455\:GNDA \448\:GNDA) analogLib_presistor_schematic c=0 \
        r=2.475
    re2689 (\461\:GNDA \460\:GNDA) analogLib_presistor_schematic c=0 r=3.3
    re2690 (\461\:GNDA \463\:GNDA) analogLib_presistor_schematic c=0 \
        r=8.48571
    re2691 (\467\:GNDA \468\:GNDA) analogLib_presistor_schematic c=0 \
        r=5.94
    re2692 (\467\:GNDA \469\:GNDA) analogLib_presistor_schematic c=0 \
        r=2.12143
    re2693 (\461\:GNDA \460\:GNDA) analogLib_presistor_schematic c=0 \
        r=3.7125
    re2694 (\467\:GNDA \460\:GNDA) analogLib_presistor_schematic c=0 \
        r=2.475
    re2695 (\203\:GNDA \472\:GNDA) analogLib_presistor_schematic c=0 \
        r=2.97
    re2696 (\158\:GNDA \157\:GNDA) analogLib_presistor_schematic c=0 r=3.3
    re2697 (\160\:GNDA \474\:GNDA) analogLib_presistor_schematic c=0 \
        r=2.12143
    re2698 (\160\:GNDA \475\:GNDA) analogLib_presistor_schematic c=0 \
        r=5.94
    re2699 (\160\:GNDA \477\:GNDA) analogLib_presistor_schematic c=0 \
        r=2.12143
    re2700 (\158\:GNDA \157\:GNDA) analogLib_presistor_schematic c=0 r=3.3
    re2701 (\163\:GNDA \162\:GNDA) analogLib_presistor_schematic c=0 r=3.3
    re2702 (\165\:GNDA \480\:GNDA) analogLib_presistor_schematic c=0 \
        r=2.12143
    re2703 (\165\:GNDA \481\:GNDA) analogLib_presistor_schematic c=0 \
        r=5.94
    re2704 (\165\:GNDA \483\:GNDA) analogLib_presistor_schematic c=0 \
        r=2.12143
    re2705 (\163\:GNDA \162\:GNDA) analogLib_presistor_schematic c=0 r=3.3
    re2706 (\168\:GNDA \167\:GNDA) analogLib_presistor_schematic c=0 r=3.3
    re2707 (\170\:GNDA \486\:GNDA) analogLib_presistor_schematic c=0 \
        r=2.12143
    re2708 (\170\:GNDA \487\:GNDA) analogLib_presistor_schematic c=0 \
        r=5.94
    re2709 (\170\:GNDA \489\:GNDA) analogLib_presistor_schematic c=0 \
        r=2.12143
    re2710 (\168\:GNDA \167\:GNDA) analogLib_presistor_schematic c=0 r=3.3
    re2711 (\173\:GNDA \172\:GNDA) analogLib_presistor_schematic c=0 r=3.3
    re2712 (\175\:GNDA \492\:GNDA) analogLib_presistor_schematic c=0 \
        r=2.12143
    re2713 (\175\:GNDA \493\:GNDA) analogLib_presistor_schematic c=0 \
        r=5.94
    re2714 (\175\:GNDA \495\:GNDA) analogLib_presistor_schematic c=0 \
        r=2.12143
    re2715 (\173\:GNDA \172\:GNDA) analogLib_presistor_schematic c=0 r=3.3
    re2716 (\178\:GNDA \177\:GNDA) analogLib_presistor_schematic c=0 r=3.3
    re2717 (\180\:GNDA \498\:GNDA) analogLib_presistor_schematic c=0 \
        r=2.12143
    re2718 (\180\:GNDA \499\:GNDA) analogLib_presistor_schematic c=0 \
        r=5.94
    re2719 (\180\:GNDA \501\:GNDA) analogLib_presistor_schematic c=0 \
        r=2.12143
    re2720 (\178\:GNDA \177\:GNDA) analogLib_presistor_schematic c=0 r=3.3
    re2721 (\183\:GNDA \182\:GNDA) analogLib_presistor_schematic c=0 r=3.3
    re2722 (\185\:GNDA \504\:GNDA) analogLib_presistor_schematic c=0 \
        r=2.12143
    re2723 (\185\:GNDA \505\:GNDA) analogLib_presistor_schematic c=0 \
        r=5.94
    re2724 (\185\:GNDA \507\:GNDA) analogLib_presistor_schematic c=0 \
        r=2.12143
    re2725 (\183\:GNDA \182\:GNDA) analogLib_presistor_schematic c=0 r=3.3
    re2726 (\188\:GNDA \187\:GNDA) analogLib_presistor_schematic c=0 r=3.3
    re2727 (\190\:GNDA \510\:GNDA) analogLib_presistor_schematic c=0 \
        r=2.12143
    re2728 (\190\:GNDA \511\:GNDA) analogLib_presistor_schematic c=0 \
        r=5.94
    re2729 (\190\:GNDA \513\:GNDA) analogLib_presistor_schematic c=0 \
        r=2.12143
    re2730 (\188\:GNDA \187\:GNDA) analogLib_presistor_schematic c=0 r=3.3
    re2731 (\515\:GNDA \516\:GNDA) analogLib_presistor_schematic c=0 \
        r=2.12143
    re2732 (\515\:GNDA \517\:GNDA) analogLib_presistor_schematic c=0 \
        r=5.94
    re2733 (\521\:GNDA \522\:GNDA) analogLib_presistor_schematic c=0 \
        r=2.97
    re2734 (\521\:GNDA \523\:GNDA) analogLib_presistor_schematic c=0 \
        r=11.88
    re2735 (\521\:GNDA \524\:GNDA) analogLib_presistor_schematic c=0 \
        r=3.12632
    re2736 (\521\:GNDA \525\:GNDA) analogLib_presistor_schematic c=0 \
        r=2.97
    re2737 (\521\:GNDA \526\:GNDA) analogLib_presistor_schematic c=0 \
        r=2.97
    re2738 (\521\:GNDA \527\:GNDA) analogLib_presistor_schematic c=0 \
        r=3.7125
    re2739 (\521\:GNDA \528\:GNDA) analogLib_presistor_schematic c=0 \
        r=3.12632
    re2740 (\521\:GNDA \529\:GNDA) analogLib_presistor_schematic c=0 \
        r=11.88
    re2741 (\521\:GNDA \530\:GNDA) analogLib_presistor_schematic c=0 \
        r=3.7125
    re2742 (\521\:GNDA \532\:GNDA) analogLib_presistor_schematic c=0 \
        r=2.97
    re2743 (\535\:GNDA \536\:GNDA) analogLib_presistor_schematic c=0 \
        r=4.56923
    re2744 (\539\:GNDA \540\:GNDA) analogLib_presistor_schematic c=0 \
        r=7.425
    re2745 (\539\:GNDA \542\:GNDA) analogLib_presistor_schematic c=0 r=3.3
    re2746 (\539\:GNDA \543\:GNDA) analogLib_presistor_schematic c=0 \
        r=29.7
    re2747 (\539\:GNDA \544\:GNDA) analogLib_presistor_schematic c=0 \
        r=7.425
    re2748 (\539\:GNDA \545\:GNDA) analogLib_presistor_schematic c=0 \
        r=29.7
    re2749 (\539\:GNDA \546\:GNDA) analogLib_presistor_schematic c=0 \
        r=3.12632
    re2750 (\550\:GNDA \551\:GNDA) analogLib_presistor_schematic c=0 \
        r=1.485
    re2751 (\550\:GNDA \552\:GNDA) analogLib_presistor_schematic c=0 \
        r=1.485
    re2752 (\550\:GNDA \553\:GNDA) analogLib_presistor_schematic c=0 \
        r=1.485
    re2753 (\550\:GNDA \554\:GNDA) analogLib_presistor_schematic c=0 \
        r=1.65
    re2754 (\550\:GNDA \555\:GNDA) analogLib_presistor_schematic c=0 \
        r=1.485
    re2755 (\550\:GNDA \556\:GNDA) analogLib_presistor_schematic c=0 \
        r=1.485
    re2756 (\550\:GNDA \557\:GNDA) analogLib_presistor_schematic c=0 \
        r=1.485
    re2757 (\550\:GNDA \558\:GNDA) analogLib_presistor_schematic c=0 \
        r=1.65
    re2758 (\550\:GNDA \559\:GNDA) analogLib_presistor_schematic c=0 \
        r=1.65
    re2759 (\550\:GNDA \560\:GNDA) analogLib_presistor_schematic c=0 \
        r=1.485
    re2760 (\550\:GNDA \562\:GNDA) analogLib_presistor_schematic c=0 \
        r=1.485
    re2761 (\550\:GNDA \563\:GNDA) analogLib_presistor_schematic c=0 \
        r=1.485
    re2762 (\230\:GNDA \564\:GNDA) analogLib_presistor_schematic c=0 \
        r=2.97
    re2763 (\218\:GNDA \566\:GNDA) analogLib_presistor_schematic c=0 \
        r=1.485
    re2764 (\203\:GNDA \579\:GNDA) analogLib_presistor_schematic c=0 \
        r=14.85
    re2765 (\218\:GNDA \580\:GNDA) analogLib_presistor_schematic c=0 \
        r=2.475
    re2766 (\203\:GNDA \581\:GNDA) analogLib_presistor_schematic c=0 \
        r=2.97
    re2767 (\218\:GNDA \582\:GNDA) analogLib_presistor_schematic c=0 \
        r=1.485
    re2768 (\203\:GNDA \583\:GNDA) analogLib_presistor_schematic c=0 \
        r=2.97
    re2769 (\218\:GNDA \584\:GNDA) analogLib_presistor_schematic c=0 \
        r=1.485
    re2770 (\203\:GNDA \585\:GNDA) analogLib_presistor_schematic c=0 \
        r=2.97
    re2771 (\218\:GNDA \586\:GNDA) analogLib_presistor_schematic c=0 \
        r=1.485
    re2772 (\203\:GNDA \587\:GNDA) analogLib_presistor_schematic c=0 \
        r=2.97
    re2773 (\218\:GNDA \588\:GNDA) analogLib_presistor_schematic c=0 \
        r=1.56316
    re2774 (\203\:GNDA \589\:GNDA) analogLib_presistor_schematic c=0 \
        r=2.97
    re2775 (\218\:GNDA \590\:GNDA) analogLib_presistor_schematic c=0 \
        r=1.485
    re2776 (\363\:GNDA \360\:GNDA) analogLib_presistor_schematic c=0 \
        r=3.7125
    re2777 (\366\:GNDA \360\:GNDA) analogLib_presistor_schematic c=0 \
        r=2.475
    re2778 (\363\:GNDA \360\:GNDA) analogLib_presistor_schematic c=0 r=3.3
    re2779 (\363\:GNDA \601\:GNDA) analogLib_presistor_schematic c=0 r=9.9
    re2780 (\379\:GNDA \604\:GNDA) analogLib_presistor_schematic c=0 \
        r=2.12143
    re2781 (\379\:GNDA \605\:GNDA) analogLib_presistor_schematic c=0 \
        r=5.94
    re2782 (\373\:GNDA \372\:GNDA) analogLib_presistor_schematic c=0 r=3.3
    re2783 (\373\:GNDA \608\:GNDA) analogLib_presistor_schematic c=0 r=9.9
    re2784 (\391\:GNDA \611\:GNDA) analogLib_presistor_schematic c=0 \
        r=2.12143
    re2785 (\391\:GNDA \612\:GNDA) analogLib_presistor_schematic c=0 \
        r=5.94
    re2786 (\385\:GNDA \384\:GNDA) analogLib_presistor_schematic c=0 r=3.3
    re2787 (\385\:GNDA \615\:GNDA) analogLib_presistor_schematic c=0 r=9.9
    re2788 (\419\:GNDA \621\:GNDA) analogLib_presistor_schematic c=0 \
        r=2.12143
    re2789 (\419\:GNDA \622\:GNDA) analogLib_presistor_schematic c=0 \
        r=5.94
    re2790 (\413\:GNDA \412\:GNDA) analogLib_presistor_schematic c=0 r=3.3
    re2791 (\413\:GNDA \625\:GNDA) analogLib_presistor_schematic c=0 r=9.9
    re2792 (\431\:GNDA \628\:GNDA) analogLib_presistor_schematic c=0 \
        r=2.12143
    re2793 (\431\:GNDA \629\:GNDA) analogLib_presistor_schematic c=0 \
        r=5.94
    re2794 (\425\:GNDA \424\:GNDA) analogLib_presistor_schematic c=0 r=3.3
    re2795 (\425\:GNDA \632\:GNDA) analogLib_presistor_schematic c=0 r=9.9
    re2796 (\443\:GNDA \635\:GNDA) analogLib_presistor_schematic c=0 \
        r=2.12143
    re2797 (\443\:GNDA \636\:GNDA) analogLib_presistor_schematic c=0 \
        r=5.94
    re2798 (\437\:GNDA \436\:GNDA) analogLib_presistor_schematic c=0 r=3.3
    re2799 (\437\:GNDA \639\:GNDA) analogLib_presistor_schematic c=0 r=9.9
    re2800 (\455\:GNDA \642\:GNDA) analogLib_presistor_schematic c=0 \
        r=2.12143
    re2801 (\455\:GNDA \643\:GNDA) analogLib_presistor_schematic c=0 \
        r=5.94
    re2802 (\449\:GNDA \448\:GNDA) analogLib_presistor_schematic c=0 r=3.3
    re2803 (\449\:GNDA \646\:GNDA) analogLib_presistor_schematic c=0 r=9.9
    re2804 (\467\:GNDA \649\:GNDA) analogLib_presistor_schematic c=0 \
        r=2.12143
    re2805 (\467\:GNDA \650\:GNDA) analogLib_presistor_schematic c=0 \
        r=5.94
    re2806 (\461\:GNDA \460\:GNDA) analogLib_presistor_schematic c=0 r=3.3
    re2807 (\461\:GNDA \653\:GNDA) analogLib_presistor_schematic c=0 r=9.9
    re2808 (\203\:GNDA \654\:GNDA) analogLib_presistor_schematic c=0 \
        r=2.97
    re2809 (\203\:GNDA \656\:GNDA) analogLib_presistor_schematic c=0 \
        r=2.97
    re2810 (\659\:GNDA \658\:GNDA) analogLib_presistor_schematic c=0 r=3.3
    re2811 (\659\:GNDA \661\:GNDA) analogLib_presistor_schematic c=0 r=9.9
    re2812 (\515\:GNDA \665\:GNDA) analogLib_presistor_schematic c=0 \
        r=5.94
    re2813 (\515\:GNDA \666\:GNDA) analogLib_presistor_schematic c=0 \
        r=2.12143
    re2814 (\193\:GNDA \192\:GNDA) analogLib_presistor_schematic c=0 \
        r=3.7125
    re2815 (\515\:GNDA \192\:GNDA) analogLib_presistor_schematic c=0 \
        r=2.475
    re2816 (\535\:GNDA \673\:GNDA) analogLib_presistor_schematic c=0 \
        r=2.97
    re2817 (\535\:GNDA \674\:GNDA) analogLib_presistor_schematic c=0 \
        r=2.97
    re2818 (\550\:GNDA \679\:GNDA) analogLib_presistor_schematic c=0 \
        r=1.65
    re2819 (\550\:GNDA \680\:GNDA) analogLib_presistor_schematic c=0 \
        r=1.485
    re2820 (\550\:GNDA \681\:GNDA) analogLib_presistor_schematic c=0 \
        r=1.485
    re2821 (\550\:GNDA \682\:GNDA) analogLib_presistor_schematic c=0 \
        r=1.485
    re2822 (\684\:GNDA \685\:GNDA) analogLib_presistor_schematic c=0 \
        r=2.97
    re2823 (\684\:GNDA \687\:GNDA) analogLib_presistor_schematic c=0 \
        r=2.97
    re2824 (\684\:GNDA \688\:GNDA) analogLib_presistor_schematic c=0 \
        r=2.97
    re2825 (\203\:GNDA \690\:GNDA) analogLib_presistor_schematic c=0 \
        r=2.97
    re2826 (\218\:GNDA \691\:GNDA) analogLib_presistor_schematic c=0 \
        r=1.485
    re2827 (\203\:GNDA \692\:GNDA) analogLib_presistor_schematic c=0 \
        r=2.97
    re2828 (\218\:GNDA \693\:GNDA) analogLib_presistor_schematic c=0 \
        r=1.485
    re2829 (\203\:GNDA \694\:GNDA) analogLib_presistor_schematic c=0 \
        r=2.97
    re2830 (\218\:GNDA \695\:GNDA) analogLib_presistor_schematic c=0 \
        r=1.485
    re2831 (\203\:GNDA \696\:GNDA) analogLib_presistor_schematic c=0 \
        r=2.97
    re2832 (\218\:GNDA \697\:GNDA) analogLib_presistor_schematic c=0 \
        r=1.485
    re2833 (\203\:GNDA \698\:GNDA) analogLib_presistor_schematic c=0 \
        r=2.97
    re2834 (\218\:GNDA \699\:GNDA) analogLib_presistor_schematic c=0 \
        r=1.56316
    re2835 (\203\:GNDA \701\:GNDA) analogLib_presistor_schematic c=0 \
        r=2.97
    re2836 (\704\:GNDA \703\:GNDA) analogLib_presistor_schematic c=0 r=3.3
    re2837 (\704\:GNDA \706\:GNDA) analogLib_presistor_schematic c=0 r=9.9
    re2838 (\659\:GNDA \709\:GNDA) analogLib_presistor_schematic c=0 \
        r=8.48571
    re2839 (\659\:GNDA \658\:GNDA) analogLib_presistor_schematic c=0 r=3.3
    re2840 (\712\:GNDA \711\:GNDA) analogLib_presistor_schematic c=0 r=3.3
    re2841 (\535\:GNDA \714\:GNDA) analogLib_presistor_schematic c=0 \
        r=2.97
    re2842 (\716\:GNDA \717\:GNDA) analogLib_presistor_schematic c=0 \
        r=14.85
    re2843 (\718\:GNDA \719\:GNDA) analogLib_presistor_schematic c=0 \
        r=2.97
    re2844 (\718\:GNDA \720\:GNDA) analogLib_presistor_schematic c=0 \
        r=4.95
    re2845 (\718\:GNDA \721\:GNDA) analogLib_presistor_schematic c=0 \
        r=2.97
    re2846 (\718\:GNDA \722\:GNDA) analogLib_presistor_schematic c=0 \
        r=29.7
    re2847 (\718\:GNDA \723\:GNDA) analogLib_presistor_schematic c=0 \
        r=4.95
    re2848 (\718\:GNDA \724\:GNDA) analogLib_presistor_schematic c=0 \
        r=29.7
    re2849 (\684\:GNDA \729\:GNDA) analogLib_presistor_schematic c=0 \
        r=2.97
    re2850 (\684\:GNDA \731\:GNDA) analogLib_presistor_schematic c=0 \
        r=2.97
    re2851 (\732\:GNDA \733\:GNDA) analogLib_presistor_schematic c=0 \
        r=0.54
    re2852 (\203\:GNDA \735\:GNDA) analogLib_presistor_schematic c=0 \
        r=2.97
    re2853 (\738\:GNDA \737\:GNDA) analogLib_presistor_schematic c=0 r=3.3
    re2854 (\738\:GNDA \740\:GNDA) analogLib_presistor_schematic c=0 r=9.9
    re2855 (\738\:GNDA \743\:GNDA) analogLib_presistor_schematic c=0 \
        r=8.48571
    re2856 (\738\:GNDA \737\:GNDA) analogLib_presistor_schematic c=0 r=3.3
    re2857 (\746\:GNDA \745\:GNDA) analogLib_presistor_schematic c=0 r=3.3
    re2858 (\748\:GNDA \749\:GNDA) analogLib_presistor_schematic c=0 \
        r=2.12143
    re2859 (\748\:GNDA \750\:GNDA) analogLib_presistor_schematic c=0 \
        r=5.94
    re2860 (\753\:GNDA \754\:GNDA) analogLib_presistor_schematic c=0 \
        r=2.12143
    re2861 (\753\:GNDA \755\:GNDA) analogLib_presistor_schematic c=0 \
        r=5.94
    re2862 (\535\:GNDA \757\:GNDA) analogLib_presistor_schematic c=0 \
        r=2.97
    re2863 (\535\:GNDA \759\:GNDA) analogLib_presistor_schematic c=0 \
        r=2.97
    re2864 (\760\:GNDA \761\:GNDA) analogLib_presistor_schematic c=0 \
        r=29.7
    re2865 (\716\:GNDA \762\:GNDA) analogLib_presistor_schematic c=0 r=3.3
    re2866 (\716\:GNDA \763\:GNDA) analogLib_presistor_schematic c=0 \
        r=14.85
    re2867 (\716\:GNDA \764\:GNDA) analogLib_presistor_schematic c=0 r=3.3
    re2868 (\684\:GNDA \769\:GNDA) analogLib_presistor_schematic c=0 \
        r=29.7
    re2869 (\684\:GNDA \770\:GNDA) analogLib_presistor_schematic c=0 \
        r=2.97
    re2870 (\203\:GNDA \773\:GNDA) analogLib_presistor_schematic c=0 \
        r=2.97
    re2871 (\776\:GNDA \775\:GNDA) analogLib_presistor_schematic c=0 r=3.3
    re2872 (\776\:GNDA \778\:GNDA) analogLib_presistor_schematic c=0 r=9.9
    re2873 (\776\:GNDA \781\:GNDA) analogLib_presistor_schematic c=0 \
        r=8.48571
    re2874 (\776\:GNDA \775\:GNDA) analogLib_presistor_schematic c=0 r=3.3
    re2875 (\784\:GNDA \783\:GNDA) analogLib_presistor_schematic c=0 r=3.3
    re2876 (\786\:GNDA \787\:GNDA) analogLib_presistor_schematic c=0 \
        r=2.12143
    re2877 (\786\:GNDA \788\:GNDA) analogLib_presistor_schematic c=0 \
        r=5.94
    re2878 (\791\:GNDA \792\:GNDA) analogLib_presistor_schematic c=0 \
        r=2.12143
    re2879 (\791\:GNDA \793\:GNDA) analogLib_presistor_schematic c=0 \
        r=5.94
    re2880 (\704\:GNDA \795\:GNDA) analogLib_presistor_schematic c=0 \
        r=8.48571
    re2881 (\704\:GNDA \703\:GNDA) analogLib_presistor_schematic c=0 r=3.3
    re2882 (\798\:GNDA \797\:GNDA) analogLib_presistor_schematic c=0 r=3.3
    re2883 (\748\:GNDA \801\:GNDA) analogLib_presistor_schematic c=0 \
        r=5.94
    re2884 (\748\:GNDA \802\:GNDA) analogLib_presistor_schematic c=0 \
        r=2.12143
    re2885 (\659\:GNDA \658\:GNDA) analogLib_presistor_schematic c=0 \
        r=3.7125
    re2886 (\748\:GNDA \658\:GNDA) analogLib_presistor_schematic c=0 \
        r=2.475
    re2887 (\712\:GNDA \711\:GNDA) analogLib_presistor_schematic c=0 \
        r=3.7125
    re2888 (\753\:GNDA \711\:GNDA) analogLib_presistor_schematic c=0 \
        r=2.475
    re2889 (\753\:GNDA \807\:GNDA) analogLib_presistor_schematic c=0 \
        r=2.12143
    re2890 (\535\:GNDA \808\:GNDA) analogLib_presistor_schematic c=0 \
        r=19.8
    re2891 (\535\:GNDA \810\:GNDA) analogLib_presistor_schematic c=0 \
        r=3.12632
    re2892 (\684\:GNDA \811\:GNDA) analogLib_presistor_schematic c=0 \
        r=2.97
    re2893 (\684\:GNDA \813\:GNDA) analogLib_presistor_schematic c=0 \
        r=3.12632
    re2894 (\203\:GNDA \814\:GNDA) analogLib_presistor_schematic c=0 \
        r=2.97
    re2895 (\154\:GNDA \151\:GNDA) analogLib_presistor_schematic c=0 r=3.3
    re2896 (\154\:GNDA \817\:GNDA) analogLib_presistor_schematic c=0 r=9.9
    re2897 (\818\:GNDA \819\:GNDA) analogLib_presistor_schematic c=0 \
        r=2.12143
    re2898 (\818\:GNDA \820\:GNDA) analogLib_presistor_schematic c=0 \
        r=5.94
    re2899 (\823\:GNDA \824\:GNDA) analogLib_presistor_schematic c=0 \
        r=2.12143
    re2900 (\823\:GNDA \825\:GNDA) analogLib_presistor_schematic c=0 \
        r=5.94
    re2901 (\786\:GNDA \828\:GNDA) analogLib_presistor_schematic c=0 \
        r=5.94
    re2902 (\786\:GNDA \829\:GNDA) analogLib_presistor_schematic c=0 \
        r=2.12143
    re2903 (\738\:GNDA \737\:GNDA) analogLib_presistor_schematic c=0 \
        r=3.7125
    re2904 (\786\:GNDA \737\:GNDA) analogLib_presistor_schematic c=0 \
        r=2.475
    re2905 (\746\:GNDA \745\:GNDA) analogLib_presistor_schematic c=0 \
        r=3.7125
    re2906 (\791\:GNDA \745\:GNDA) analogLib_presistor_schematic c=0 \
        r=2.475
    re2907 (\791\:GNDA \834\:GNDA) analogLib_presistor_schematic c=0 \
        r=2.12143
    re2908 (\835\:GNDA \836\:GNDA) analogLib_presistor_schematic c=0 \
        r=2.12143
    re2909 (\835\:GNDA \837\:GNDA) analogLib_presistor_schematic c=0 \
        r=5.94
    re2910 (\839\:GNDA \840\:GNDA) analogLib_presistor_schematic c=0 \
        r=2.12143
    re2911 (\839\:GNDA \841\:GNDA) analogLib_presistor_schematic c=0 \
        r=5.94
    re2912 (\712\:GNDA \711\:GNDA) analogLib_presistor_schematic c=0 r=3.3
    re2913 (\535\:GNDA \844\:GNDA) analogLib_presistor_schematic c=0 \
        r=2.97
    re2914 (\684\:GNDA \846\:GNDA) analogLib_presistor_schematic c=0 \
        r=19.8
    re2915 (\684\:GNDA \847\:GNDA) analogLib_presistor_schematic c=0 \
        r=29.7
    re2916 (\684\:GNDA \848\:GNDA) analogLib_presistor_schematic c=0 \
        r=2.97
    re2917 (\870\:GNDA \871\:GNDA) analogLib_presistor_schematic c=0 \
        r=2.12143
    re2918 (\870\:GNDA \872\:GNDA) analogLib_presistor_schematic c=0 \
        r=5.94
    re2919 (\818\:GNDA \875\:GNDA) analogLib_presistor_schematic c=0 \
        r=5.94
    re2920 (\818\:GNDA \876\:GNDA) analogLib_presistor_schematic c=0 \
        r=2.12143
    re2921 (\776\:GNDA \775\:GNDA) analogLib_presistor_schematic c=0 \
        r=3.7125
    re2922 (\818\:GNDA \775\:GNDA) analogLib_presistor_schematic c=0 \
        r=2.475
    re2923 (\784\:GNDA \783\:GNDA) analogLib_presistor_schematic c=0 \
        r=3.7125
    re2924 (\823\:GNDA \783\:GNDA) analogLib_presistor_schematic c=0 \
        r=2.475
    re2925 (\823\:GNDA \881\:GNDA) analogLib_presistor_schematic c=0 \
        r=2.12143
    re2926 (\746\:GNDA \745\:GNDA) analogLib_presistor_schematic c=0 r=3.3
    re2927 (\883\:GNDA \884\:GNDA) analogLib_presistor_schematic c=0 \
        r=0.54
    re2928 (\798\:GNDA \797\:GNDA) analogLib_presistor_schematic c=0 \
        r=3.7125
    re2929 (\839\:GNDA \797\:GNDA) analogLib_presistor_schematic c=0 \
        r=2.475
    re2930 (\839\:GNDA \888\:GNDA) analogLib_presistor_schematic c=0 \
        r=2.12143
    re2931 (\890\:GNDA \889\:GNDA) analogLib_presistor_schematic c=0 r=3.3
    re2932 (\535\:GNDA \892\:GNDA) analogLib_presistor_schematic c=0 \
        r=4.56923
    re2933 (\535\:GNDA \893\:GNDA) analogLib_presistor_schematic c=0 \
        r=19.8
    re2934 (\535\:GNDA \894\:GNDA) analogLib_presistor_schematic c=0 \
        r=2.97
    re2935 (\535\:GNDA \897\:GNDA) analogLib_presistor_schematic c=0 \
        r=2.97
    re2936 (\535\:GNDA \899\:GNDA) analogLib_presistor_schematic c=0 \
        r=2.97
    re2937 (\684\:GNDA \901\:GNDA) analogLib_presistor_schematic c=0 \
        r=2.97
    re2938 (\203\:GNDA \903\:GNDA) analogLib_presistor_schematic c=0 \
        r=2.97
    re2939 (\203\:GNDA \904\:GNDA) analogLib_presistor_schematic c=0 \
        r=2.97
    re2940 (\203\:GNDA \906\:GNDA) analogLib_presistor_schematic c=0 \
        r=2.97
    re2941 (\203\:GNDA \907\:GNDA) analogLib_presistor_schematic c=0 \
        r=2.97
    re2942 (\203\:GNDA \908\:GNDA) analogLib_presistor_schematic c=0 \
        r=2.97
    re2943 (\203\:GNDA \909\:GNDA) analogLib_presistor_schematic c=0 \
        r=2.97
    re2944 (\203\:GNDA \910\:GNDA) analogLib_presistor_schematic c=0 \
        r=2.97
    re2945 (\203\:GNDA \911\:GNDA) analogLib_presistor_schematic c=0 \
        r=2.97
    re2946 (\203\:GNDA \912\:GNDA) analogLib_presistor_schematic c=0 \
        r=2.97
    re2947 (\203\:GNDA \913\:GNDA) analogLib_presistor_schematic c=0 \
        r=2.97
    re2948 (\203\:GNDA \914\:GNDA) analogLib_presistor_schematic c=0 \
        r=2.97
    re2949 (\203\:GNDA \915\:GNDA) analogLib_presistor_schematic c=0 \
        r=2.97
    re2950 (\203\:GNDA \916\:GNDA) analogLib_presistor_schematic c=0 \
        r=14.85
    re2951 (\203\:GNDA \918\:GNDA) analogLib_presistor_schematic c=0 \
        r=2.97
    re2952 (\203\:GNDA \919\:GNDA) analogLib_presistor_schematic c=0 \
        r=2.97
    re2953 (\154\:GNDA \151\:GNDA) analogLib_presistor_schematic c=0 \
        r=3.7125
    re2954 (\870\:GNDA \151\:GNDA) analogLib_presistor_schematic c=0 \
        r=2.475
    re2955 (\870\:GNDA \923\:GNDA) analogLib_presistor_schematic c=0 \
        r=2.12143
    re2956 (\870\:GNDA \924\:GNDA) analogLib_presistor_schematic c=0 \
        r=5.94
    re2957 (\784\:GNDA \783\:GNDA) analogLib_presistor_schematic c=0 r=3.3
    re2958 (\928\:GNDA \927\:GNDA) analogLib_presistor_schematic c=0 r=3.3
    re2959 (\835\:GNDA \930\:GNDA) analogLib_presistor_schematic c=0 \
        r=5.94
    re2960 (\835\:GNDA \931\:GNDA) analogLib_presistor_schematic c=0 \
        r=2.12143
    re2961 (\704\:GNDA \703\:GNDA) analogLib_presistor_schematic c=0 \
        r=3.7125
    re2962 (\835\:GNDA \703\:GNDA) analogLib_presistor_schematic c=0 \
        r=2.475
    re2963 (\798\:GNDA \797\:GNDA) analogLib_presistor_schematic c=0 r=3.3
    re2964 (\935\:GNDA \936\:GNDA) analogLib_presistor_schematic c=0 \
        r=2.12143
    re2965 (\935\:GNDA \937\:GNDA) analogLib_presistor_schematic c=0 \
        r=5.94
    re2966 (\684\:GNDA \941\:GNDA) analogLib_presistor_schematic c=0 \
        r=2.97
    re2967 (\684\:GNDA \942\:GNDA) analogLib_presistor_schematic c=0 \
        r=29.7
    re2968 (\684\:GNDA \943\:GNDA) analogLib_presistor_schematic c=0 \
        r=2.97
    re2969 (\948\:GNDA \947\:GNDA) analogLib_presistor_schematic c=0 r=3.3
    re2970 (\948\:GNDA \950\:GNDA) analogLib_presistor_schematic c=0 r=9.9
    re2971 (\954\:GNDA \953\:GNDA) analogLib_presistor_schematic c=0 r=3.3
    re2972 (\956\:GNDA \957\:GNDA) analogLib_presistor_schematic c=0 \
        r=2.12143
    re2973 (\956\:GNDA \958\:GNDA) analogLib_presistor_schematic c=0 \
        r=5.94
    re2974 (\961\:GNDA \960\:GNDA) analogLib_presistor_schematic c=0 r=3.3
    re2975 (\890\:GNDA \889\:GNDA) analogLib_presistor_schematic c=0 \
        r=3.7125
    re2976 (\935\:GNDA \889\:GNDA) analogLib_presistor_schematic c=0 \
        r=2.475
    re2977 (\935\:GNDA \965\:GNDA) analogLib_presistor_schematic c=0 \
        r=2.12143
    re2978 (\968\:GNDA \969\:GNDA) analogLib_presistor_schematic c=0 \
        r=2.12143
    re2979 (\968\:GNDA \970\:GNDA) analogLib_presistor_schematic c=0 \
        r=5.94
    re2980 (\928\:GNDA \927\:GNDA) analogLib_presistor_schematic c=0 \
        r=3.7125
    re2981 (\956\:GNDA \927\:GNDA) analogLib_presistor_schematic c=0 \
        r=2.475
    re2982 (\956\:GNDA \974\:GNDA) analogLib_presistor_schematic c=0 \
        r=2.12143
    re2983 (\975\:GNDA \976\:GNDA) analogLib_presistor_schematic c=0 \
        r=2.12143
    re2984 (\975\:GNDA \977\:GNDA) analogLib_presistor_schematic c=0 \
        r=5.94
    re2985 (\890\:GNDA \889\:GNDA) analogLib_presistor_schematic c=0 r=3.3
    re2986 (\948\:GNDA \980\:GNDA) analogLib_presistor_schematic c=0 \
        r=8.48571
    re2987 (\948\:GNDA \947\:GNDA) analogLib_presistor_schematic c=0 r=3.3
    re2988 (\983\:GNDA \982\:GNDA) analogLib_presistor_schematic c=0 r=3.3
    re2989 (\983\:GNDA \985\:GNDA) analogLib_presistor_schematic c=0 r=9.9
    re2990 (\954\:GNDA \953\:GNDA) analogLib_presistor_schematic c=0 \
        r=3.7125
    re2991 (\968\:GNDA \953\:GNDA) analogLib_presistor_schematic c=0 \
        r=2.475
    re2992 (\968\:GNDA \990\:GNDA) analogLib_presistor_schematic c=0 \
        r=2.12143
    re2993 (\928\:GNDA \927\:GNDA) analogLib_presistor_schematic c=0 r=3.3
    re2994 (\961\:GNDA \960\:GNDA) analogLib_presistor_schematic c=0 \
        r=3.7125
    re2995 (\975\:GNDA \960\:GNDA) analogLib_presistor_schematic c=0 \
        r=2.475
    re2996 (\975\:GNDA \994\:GNDA) analogLib_presistor_schematic c=0 \
        r=2.12143
    re2997 (\996\:GNDA \995\:GNDA) analogLib_presistor_schematic c=0 r=3.3
    re2998 (\998\:GNDA \999\:GNDA) analogLib_presistor_schematic c=0 \
        r=2.12143
    re2999 (\998\:GNDA \1000\:GNDA) analogLib_presistor_schematic c=0 \
        r=5.94
    re3000 (\954\:GNDA \953\:GNDA) analogLib_presistor_schematic c=0 r=3.3
    re3001 (\1006\:GNDA \1005\:GNDA) analogLib_presistor_schematic c=0 \
        r=3.3
    re3002 (\961\:GNDA \960\:GNDA) analogLib_presistor_schematic c=0 r=3.3
    re3003 (\1009\:GNDA \1010\:GNDA) analogLib_presistor_schematic c=0 \
        r=2.12143
    re3004 (\1009\:GNDA \1011\:GNDA) analogLib_presistor_schematic c=0 \
        r=5.94
    re3005 (\1013\:GNDA \1014\:GNDA) analogLib_presistor_schematic c=0 \
        r=0.54
    re3006 (\983\:GNDA \1015\:GNDA) analogLib_presistor_schematic c=0 \
        r=8.48571
    re3007 (\983\:GNDA \982\:GNDA) analogLib_presistor_schematic c=0 r=3.3
    re3008 (\1018\:GNDA \1017\:GNDA) analogLib_presistor_schematic c=0 \
        r=3.3
    re3009 (\1018\:GNDA \1020\:GNDA) analogLib_presistor_schematic c=0 \
        r=9.9
    re3010 (\1024\:GNDA \1023\:GNDA) analogLib_presistor_schematic c=0 \
        r=3.3
    re3011 (\1024\:GNDA \1026\:GNDA) analogLib_presistor_schematic c=0 \
        r=9.9
    re3012 (\1029\:GNDA \1030\:GNDA) analogLib_presistor_schematic c=0 \
        r=2.12143
    re3013 (\1029\:GNDA \1031\:GNDA) analogLib_presistor_schematic c=0 \
        r=5.94
    re3014 (\1034\:GNDA \1033\:GNDA) analogLib_presistor_schematic c=0 \
        r=3.3
    re3015 (\996\:GNDA \995\:GNDA) analogLib_presistor_schematic c=0 \
        r=3.7125
    re3016 (\1009\:GNDA \995\:GNDA) analogLib_presistor_schematic c=0 \
        r=2.475
    re3017 (\1009\:GNDA \1038\:GNDA) analogLib_presistor_schematic c=0 \
        r=2.12143
    re3018 (\1040\:GNDA \1041\:GNDA) analogLib_presistor_schematic c=0 \
        r=2.12143
    re3019 (\1040\:GNDA \1042\:GNDA) analogLib_presistor_schematic c=0 \
        r=5.94
    re3020 (\1024\:GNDA \1046\:GNDA) analogLib_presistor_schematic c=0 \
        r=8.48571
    re3021 (\1024\:GNDA \1023\:GNDA) analogLib_presistor_schematic c=0 \
        r=3.3
    re3022 (\1049\:GNDA \1048\:GNDA) analogLib_presistor_schematic c=0 \
        r=3.3
    re3023 (\1006\:GNDA \1005\:GNDA) analogLib_presistor_schematic c=0 \
        r=3.7125
    re3024 (\1029\:GNDA \1005\:GNDA) analogLib_presistor_schematic c=0 \
        r=2.475
    re3025 (\1029\:GNDA \1053\:GNDA) analogLib_presistor_schematic c=0 \
        r=2.12143
    re3026 (\1054\:GNDA \1055\:GNDA) analogLib_presistor_schematic c=0 \
        r=2.12143
    re3027 (\1054\:GNDA \1056\:GNDA) analogLib_presistor_schematic c=0 \
        r=5.94
    re3028 (\996\:GNDA \995\:GNDA) analogLib_presistor_schematic c=0 r=3.3
    re3029 (\998\:GNDA \1059\:GNDA) analogLib_presistor_schematic c=0 \
        r=5.94
    re3030 (\998\:GNDA \1060\:GNDA) analogLib_presistor_schematic c=0 \
        r=2.12143
    re3031 (\948\:GNDA \947\:GNDA) analogLib_presistor_schematic c=0 \
        r=3.7125
    re3032 (\998\:GNDA \947\:GNDA) analogLib_presistor_schematic c=0 \
        r=2.475
    re3033 (\1063\:GNDA \1064\:GNDA) analogLib_presistor_schematic c=0 \
        r=0.54
    re3034 (\1018\:GNDA \1065\:GNDA) analogLib_presistor_schematic c=0 \
        r=8.48571
    re3035 (\1018\:GNDA \1017\:GNDA) analogLib_presistor_schematic c=0 \
        r=3.3
    re3036 (\1068\:GNDA \1067\:GNDA) analogLib_presistor_schematic c=0 \
        r=3.3
    re3037 (\1068\:GNDA \1070\:GNDA) analogLib_presistor_schematic c=0 \
        r=9.9
    re3038 (\1074\:GNDA \1075\:GNDA) analogLib_presistor_schematic c=0 \
        r=2.12143
    re3039 (\1074\:GNDA \1076\:GNDA) analogLib_presistor_schematic c=0 \
        r=5.94
    re3040 (\1079\:GNDA \1080\:GNDA) analogLib_presistor_schematic c=0 \
        r=2.12143
    re3041 (\1079\:GNDA \1081\:GNDA) analogLib_presistor_schematic c=0 \
        r=5.94
    re3042 (\1006\:GNDA \1005\:GNDA) analogLib_presistor_schematic c=0 \
        r=3.3
    re3043 (\1034\:GNDA \1033\:GNDA) analogLib_presistor_schematic c=0 \
        r=3.7125
    re3044 (\1054\:GNDA \1033\:GNDA) analogLib_presistor_schematic c=0 \
        r=2.475
    re3045 (\1054\:GNDA \1086\:GNDA) analogLib_presistor_schematic c=0 \
        r=2.12143
    re3046 (\1088\:GNDA \1087\:GNDA) analogLib_presistor_schematic c=0 \
        r=3.3
    re3047 (\1088\:GNDA \1090\:GNDA) analogLib_presistor_schematic c=0 \
        r=9.9
    re3048 (\1088\:GNDA \1093\:GNDA) analogLib_presistor_schematic c=0 \
        r=8.48571
    re3049 (\1088\:GNDA \1087\:GNDA) analogLib_presistor_schematic c=0 \
        r=3.3
    re3050 (\1096\:GNDA \1095\:GNDA) analogLib_presistor_schematic c=0 \
        r=3.3
    re3051 (\1099\:GNDA \1100\:GNDA) analogLib_presistor_schematic c=0 \
        r=2.12143
    re3052 (\1099\:GNDA \1101\:GNDA) analogLib_presistor_schematic c=0 \
        r=5.94
    re3053 (\1074\:GNDA \1106\:GNDA) analogLib_presistor_schematic c=0 \
        r=5.94
    re3054 (\1074\:GNDA \1107\:GNDA) analogLib_presistor_schematic c=0 \
        r=2.12143
    re3055 (\1024\:GNDA \1023\:GNDA) analogLib_presistor_schematic c=0 \
        r=3.7125
    re3056 (\1074\:GNDA \1023\:GNDA) analogLib_presistor_schematic c=0 \
        r=2.475
    re3057 (\1049\:GNDA \1048\:GNDA) analogLib_presistor_schematic c=0 \
        r=3.7125
    re3058 (\1079\:GNDA \1048\:GNDA) analogLib_presistor_schematic c=0 \
        r=2.475
    re3059 (\1079\:GNDA \1112\:GNDA) analogLib_presistor_schematic c=0 \
        r=2.12143
    re3060 (\1114\:GNDA \1113\:GNDA) analogLib_presistor_schematic c=0 \
        r=3.3
    re3061 (\1034\:GNDA \1033\:GNDA) analogLib_presistor_schematic c=0 \
        r=3.3
    re3062 (\1117\:GNDA \1118\:GNDA) analogLib_presistor_schematic c=0 \
        r=2.12143
    re3063 (\1117\:GNDA \1119\:GNDA) analogLib_presistor_schematic c=0 \
        r=5.94
    re3064 (\1122\:GNDA \1123\:GNDA) analogLib_presistor_schematic c=0 \
        r=2.12143
    re3065 (\1122\:GNDA \1124\:GNDA) analogLib_presistor_schematic c=0 \
        r=5.94
    re3066 (\1040\:GNDA \1126\:GNDA) analogLib_presistor_schematic c=0 \
        r=5.94
    re3067 (\1040\:GNDA \1127\:GNDA) analogLib_presistor_schematic c=0 \
        r=2.12143
    re3068 (\983\:GNDA \982\:GNDA) analogLib_presistor_schematic c=0 \
        r=3.7125
    re3069 (\1040\:GNDA \982\:GNDA) analogLib_presistor_schematic c=0 \
        r=2.475
    re3070 (\1130\:GNDA \1131\:GNDA) analogLib_presistor_schematic c=0 \
        r=0.54
    re3071 (\1049\:GNDA \1048\:GNDA) analogLib_presistor_schematic c=0 \
        r=3.3
    re3072 (\1133\:GNDA \1134\:GNDA) analogLib_presistor_schematic c=0 \
        r=2.12143
    re3073 (\1133\:GNDA \1135\:GNDA) analogLib_presistor_schematic c=0 \
        r=5.94
    re3074 (\1138\:GNDA \1137\:GNDA) analogLib_presistor_schematic c=0 \
        r=3.3
    re3075 (\1117\:GNDA \1141\:GNDA) analogLib_presistor_schematic c=0 \
        r=5.94
    re3076 (\1117\:GNDA \1142\:GNDA) analogLib_presistor_schematic c=0 \
        r=2.12143
    re3077 (\1088\:GNDA \1087\:GNDA) analogLib_presistor_schematic c=0 \
        r=3.7125
    re3078 (\1117\:GNDA \1087\:GNDA) analogLib_presistor_schematic c=0 \
        r=2.475
    re3079 (\1096\:GNDA \1095\:GNDA) analogLib_presistor_schematic c=0 \
        r=3.7125
    re3080 (\1122\:GNDA \1095\:GNDA) analogLib_presistor_schematic c=0 \
        r=2.475
    re3081 (\1122\:GNDA \1147\:GNDA) analogLib_presistor_schematic c=0 \
        r=2.12143
    re3082 (\1068\:GNDA \1149\:GNDA) analogLib_presistor_schematic c=0 \
        r=8.48571
    re3083 (\1068\:GNDA \1067\:GNDA) analogLib_presistor_schematic c=0 \
        r=3.3
    re3084 (\1152\:GNDA \1151\:GNDA) analogLib_presistor_schematic c=0 \
        r=3.3
    re3085 (\1152\:GNDA \1154\:GNDA) analogLib_presistor_schematic c=0 \
        r=9.9
    re3086 (\1159\:GNDA \1158\:GNDA) analogLib_presistor_schematic c=0 \
        r=3.3
    re3087 (\1159\:GNDA \1161\:GNDA) analogLib_presistor_schematic c=0 \
        r=9.9
    re3088 (\1159\:GNDA \1164\:GNDA) analogLib_presistor_schematic c=0 \
        r=8.48571
    re3089 (\1159\:GNDA \1158\:GNDA) analogLib_presistor_schematic c=0 \
        r=3.3
    re3090 (\1167\:GNDA \1166\:GNDA) analogLib_presistor_schematic c=0 \
        r=3.3
    re3091 (\1114\:GNDA \1113\:GNDA) analogLib_presistor_schematic c=0 \
        r=3.7125
    re3092 (\1133\:GNDA \1113\:GNDA) analogLib_presistor_schematic c=0 \
        r=2.475
    re3093 (\1133\:GNDA \1171\:GNDA) analogLib_presistor_schematic c=0 \
        r=2.12143
    re3094 (\1172\:GNDA \1173\:GNDA) analogLib_presistor_schematic c=0 \
        r=2.12143
    re3095 (\1172\:GNDA \1174\:GNDA) analogLib_presistor_schematic c=0 \
        r=5.94
    re3096 (\1096\:GNDA \1095\:GNDA) analogLib_presistor_schematic c=0 \
        r=3.3
    re3097 (\1099\:GNDA \1177\:GNDA) analogLib_presistor_schematic c=0 \
        r=5.94
    re3098 (\1099\:GNDA \1178\:GNDA) analogLib_presistor_schematic c=0 \
        r=2.12143
    re3099 (\1018\:GNDA \1017\:GNDA) analogLib_presistor_schematic c=0 \
        r=3.7125
    re3100 (\1099\:GNDA \1017\:GNDA) analogLib_presistor_schematic c=0 \
        r=2.475
    re3101 (\1181\:GNDA \1182\:GNDA) analogLib_presistor_schematic c=0 \
        r=2.12143
    re3102 (\1181\:GNDA \1183\:GNDA) analogLib_presistor_schematic c=0 \
        r=5.94
    re3103 (\1187\:GNDA \1188\:GNDA) analogLib_presistor_schematic c=0 \
        r=2.12143
    re3104 (\1187\:GNDA \1189\:GNDA) analogLib_presistor_schematic c=0 \
        r=5.94
    re3105 (\1192\:GNDA \1193\:GNDA) analogLib_presistor_schematic c=0 \
        r=2.12143
    re3106 (\1192\:GNDA \1194\:GNDA) analogLib_presistor_schematic c=0 \
        r=5.94
    re3107 (\1114\:GNDA \1113\:GNDA) analogLib_presistor_schematic c=0 \
        r=3.3
    re3108 (\1138\:GNDA \1137\:GNDA) analogLib_presistor_schematic c=0 \
        r=3.7125
    re3109 (\1172\:GNDA \1137\:GNDA) analogLib_presistor_schematic c=0 \
        r=2.475
    re3110 (\1172\:GNDA \1199\:GNDA) analogLib_presistor_schematic c=0 \
        r=2.12143
    re3111 (\1201\:GNDA \1200\:GNDA) analogLib_presistor_schematic c=0 \
        r=3.3
    re3112 (\1203\:GNDA \1204\:GNDA) analogLib_presistor_schematic c=0 \
        r=0.54
    re3113 (\1187\:GNDA \1207\:GNDA) analogLib_presistor_schematic c=0 \
        r=5.94
    re3114 (\1187\:GNDA \1208\:GNDA) analogLib_presistor_schematic c=0 \
        r=2.12143
    re3115 (\1159\:GNDA \1158\:GNDA) analogLib_presistor_schematic c=0 \
        r=3.7125
    re3116 (\1187\:GNDA \1158\:GNDA) analogLib_presistor_schematic c=0 \
        r=2.475
    re3117 (\1167\:GNDA \1166\:GNDA) analogLib_presistor_schematic c=0 \
        r=3.7125
    re3118 (\1192\:GNDA \1166\:GNDA) analogLib_presistor_schematic c=0 \
        r=2.475
    re3119 (\1192\:GNDA \1213\:GNDA) analogLib_presistor_schematic c=0 \
        r=2.12143
    re3120 (\1215\:GNDA \1214\:GNDA) analogLib_presistor_schematic c=0 \
        r=3.3
    re3121 (\1138\:GNDA \1137\:GNDA) analogLib_presistor_schematic c=0 \
        r=3.3
    re3122 (\1218\:GNDA \1219\:GNDA) analogLib_presistor_schematic c=0 \
        r=2.12143
    re3123 (\1218\:GNDA \1220\:GNDA) analogLib_presistor_schematic c=0 \
        r=5.94
    re3124 (\1152\:GNDA \1223\:GNDA) analogLib_presistor_schematic c=0 \
        r=8.48571
    re3125 (\1152\:GNDA \1151\:GNDA) analogLib_presistor_schematic c=0 \
        r=3.3
    re3126 (\1226\:GNDA \1225\:GNDA) analogLib_presistor_schematic c=0 \
        r=3.3
    re3127 (\1226\:GNDA \1228\:GNDA) analogLib_presistor_schematic c=0 \
        r=9.9
    re3128 (\1167\:GNDA \1166\:GNDA) analogLib_presistor_schematic c=0 \
        r=3.3
    re3129 (\1233\:GNDA \1234\:GNDA) analogLib_presistor_schematic c=0 \
        r=2.12143
    re3130 (\1233\:GNDA \1235\:GNDA) analogLib_presistor_schematic c=0 \
        r=5.94
    re3131 (\1238\:GNDA \1237\:GNDA) analogLib_presistor_schematic c=0 \
        r=3.3
    re3132 (\1201\:GNDA \1200\:GNDA) analogLib_presistor_schematic c=0 \
        r=3.7125
    re3133 (\1218\:GNDA \1200\:GNDA) analogLib_presistor_schematic c=0 \
        r=2.475
    re3134 (\1218\:GNDA \1242\:GNDA) analogLib_presistor_schematic c=0 \
        r=2.12143
    re3135 (\1244\:GNDA \1245\:GNDA) analogLib_presistor_schematic c=0 \
        r=2.12143
    re3136 (\1244\:GNDA \1246\:GNDA) analogLib_presistor_schematic c=0 \
        r=5.94
    re3137 (\1251\:GNDA \1250\:GNDA) analogLib_presistor_schematic c=0 \
        r=3.3
    re3138 (\1215\:GNDA \1214\:GNDA) analogLib_presistor_schematic c=0 \
        r=3.7125
    re3139 (\1233\:GNDA \1214\:GNDA) analogLib_presistor_schematic c=0 \
        r=2.475
    re3140 (\1233\:GNDA \1255\:GNDA) analogLib_presistor_schematic c=0 \
        r=2.12143
    re3141 (\1256\:GNDA \1257\:GNDA) analogLib_presistor_schematic c=0 \
        r=2.12143
    re3142 (\1256\:GNDA \1258\:GNDA) analogLib_presistor_schematic c=0 \
        r=5.94
    re3143 (\1201\:GNDA \1200\:GNDA) analogLib_presistor_schematic c=0 \
        r=3.3
    re3144 (\1262\:GNDA \1263\:GNDA) analogLib_presistor_schematic c=0 \
        r=0.54
    re3145 (\1265\:GNDA \1266\:GNDA) analogLib_presistor_schematic c=0 \
        r=2.12143
    re3146 (\1265\:GNDA \1267\:GNDA) analogLib_presistor_schematic c=0 \
        r=5.94
    re3147 (\1215\:GNDA \1214\:GNDA) analogLib_presistor_schematic c=0 \
        r=3.3
    re3148 (\1238\:GNDA \1237\:GNDA) analogLib_presistor_schematic c=0 \
        r=3.7125
    re3149 (\1256\:GNDA \1237\:GNDA) analogLib_presistor_schematic c=0 \
        r=2.475
    re3150 (\1256\:GNDA \1272\:GNDA) analogLib_presistor_schematic c=0 \
        r=2.12143
    re3151 (\1274\:GNDA \1273\:GNDA) analogLib_presistor_schematic c=0 \
        r=3.3
    re3152 (\1181\:GNDA \1276\:GNDA) analogLib_presistor_schematic c=0 \
        r=5.94
    re3153 (\1181\:GNDA \1277\:GNDA) analogLib_presistor_schematic c=0 \
        r=2.12143
    re3154 (\1068\:GNDA \1067\:GNDA) analogLib_presistor_schematic c=0 \
        r=3.7125
    re3155 (\1181\:GNDA \1067\:GNDA) analogLib_presistor_schematic c=0 \
        r=2.475
    re3156 (\1226\:GNDA \1281\:GNDA) analogLib_presistor_schematic c=0 \
        r=8.48571
    re3157 (\1226\:GNDA \1225\:GNDA) analogLib_presistor_schematic c=0 \
        r=3.3
    re3158 (\1284\:GNDA \1283\:GNDA) analogLib_presistor_schematic c=0 \
        r=3.3
    re3159 (\1284\:GNDA \1286\:GNDA) analogLib_presistor_schematic c=0 \
        r=9.9
    re3160 (\1251\:GNDA \1250\:GNDA) analogLib_presistor_schematic c=0 \
        r=3.7125
    re3161 (\1265\:GNDA \1250\:GNDA) analogLib_presistor_schematic c=0 \
        r=2.475
    re3162 (\1265\:GNDA \1292\:GNDA) analogLib_presistor_schematic c=0 \
        r=2.12143
    re3163 (\1294\:GNDA \1293\:GNDA) analogLib_presistor_schematic c=0 \
        r=3.3
    re3164 (\1238\:GNDA \1237\:GNDA) analogLib_presistor_schematic c=0 \
        r=3.3
    re3165 (\1297\:GNDA \1298\:GNDA) analogLib_presistor_schematic c=0 \
        r=2.12143
    re3166 (\1297\:GNDA \1299\:GNDA) analogLib_presistor_schematic c=0 \
        r=5.94
    re3167 (\1302\:GNDA \1303\:GNDA) analogLib_presistor_schematic c=0 \
        r=2.12143
    re3168 (\1302\:GNDA \1304\:GNDA) analogLib_presistor_schematic c=0 \
        r=5.94
    re3169 (\1251\:GNDA \1250\:GNDA) analogLib_presistor_schematic c=0 \
        r=3.3
    re3170 (\1309\:GNDA \1310\:GNDA) analogLib_presistor_schematic c=0 \
        r=2.12143
    re3171 (\1309\:GNDA \1311\:GNDA) analogLib_presistor_schematic c=0 \
        r=5.94
    re3172 (\1314\:GNDA \1313\:GNDA) analogLib_presistor_schematic c=0 \
        r=3.3
    re3173 (\1274\:GNDA \1273\:GNDA) analogLib_presistor_schematic c=0 \
        r=3.7125
    re3174 (\1297\:GNDA \1273\:GNDA) analogLib_presistor_schematic c=0 \
        r=2.475
    re3175 (\1297\:GNDA \1318\:GNDA) analogLib_presistor_schematic c=0 \
        r=2.12143
    re3176 (\1320\:GNDA \1321\:GNDA) analogLib_presistor_schematic c=0 \
        r=0.54
    re3177 (\1324\:GNDA \1323\:GNDA) analogLib_presistor_schematic c=0 \
        r=3.3
    re3178 (\1324\:GNDA \1326\:GNDA) analogLib_presistor_schematic c=0 \
        r=9.9
    re3179 (\1294\:GNDA \1293\:GNDA) analogLib_presistor_schematic c=0 \
        r=3.7125
    re3180 (\1309\:GNDA \1293\:GNDA) analogLib_presistor_schematic c=0 \
        r=2.475
    re3181 (\1309\:GNDA \1331\:GNDA) analogLib_presistor_schematic c=0 \
        r=2.12143
    re3182 (\1332\:GNDA \1333\:GNDA) analogLib_presistor_schematic c=0 \
        r=2.12143
    re3183 (\1332\:GNDA \1334\:GNDA) analogLib_presistor_schematic c=0 \
        r=5.94
    re3184 (\1274\:GNDA \1273\:GNDA) analogLib_presistor_schematic c=0 \
        r=3.3
    re3185 (\1244\:GNDA \1337\:GNDA) analogLib_presistor_schematic c=0 \
        r=5.94
    re3186 (\1244\:GNDA \1338\:GNDA) analogLib_presistor_schematic c=0 \
        r=2.12143
    re3187 (\1152\:GNDA \1151\:GNDA) analogLib_presistor_schematic c=0 \
        r=3.7125
    re3188 (\1244\:GNDA \1151\:GNDA) analogLib_presistor_schematic c=0 \
        r=2.475
    re3189 (\1284\:GNDA \1342\:GNDA) analogLib_presistor_schematic c=0 \
        r=8.48571
    re3190 (\1284\:GNDA \1283\:GNDA) analogLib_presistor_schematic c=0 \
        r=3.3
    re3191 (\1345\:GNDA \1344\:GNDA) analogLib_presistor_schematic c=0 \
        r=3.3
    re3192 (\1345\:GNDA \1347\:GNDA) analogLib_presistor_schematic c=0 \
        r=9.9
    re3193 (\1294\:GNDA \1293\:GNDA) analogLib_presistor_schematic c=0 \
        r=3.3
    re3194 (\1314\:GNDA \1313\:GNDA) analogLib_presistor_schematic c=0 \
        r=3.7125
    re3195 (\1332\:GNDA \1313\:GNDA) analogLib_presistor_schematic c=0 \
        r=2.475
    re3196 (\1332\:GNDA \1353\:GNDA) analogLib_presistor_schematic c=0 \
        r=2.12143
    re3197 (\1355\:GNDA \1354\:GNDA) analogLib_presistor_schematic c=0 \
        r=3.3
    re3198 (\1355\:GNDA \1357\:GNDA) analogLib_presistor_schematic c=0 \
        r=9.9
    re3199 (\1355\:GNDA \1360\:GNDA) analogLib_presistor_schematic c=0 \
        r=8.48571
    re3200 (\1355\:GNDA \1354\:GNDA) analogLib_presistor_schematic c=0 \
        r=3.3
    re3201 (\1364\:GNDA \1365\:GNDA) analogLib_presistor_schematic c=0 \
        r=2.12143
    re3202 (\1364\:GNDA \1366\:GNDA) analogLib_presistor_schematic c=0 \
        r=5.94
    re3203 (\1324\:GNDA \1370\:GNDA) analogLib_presistor_schematic c=0 \
        r=8.48571
    re3204 (\1324\:GNDA \1323\:GNDA) analogLib_presistor_schematic c=0 \
        r=3.3
    re3205 (\1374\:GNDA \1373\:GNDA) analogLib_presistor_schematic c=0 \
        r=3.3
    re3206 (\1314\:GNDA \1313\:GNDA) analogLib_presistor_schematic c=0 \
        r=3.3
    re3207 (\1377\:GNDA \1378\:GNDA) analogLib_presistor_schematic c=0 \
        r=2.12143
    re3208 (\1377\:GNDA \1379\:GNDA) analogLib_presistor_schematic c=0 \
        r=5.94
    re3209 (\1383\:GNDA \1384\:GNDA) analogLib_presistor_schematic c=0 \
        r=0.54
    re3210 (\1345\:GNDA \1386\:GNDA) analogLib_presistor_schematic c=0 \
        r=8.48571
    re3211 (\1345\:GNDA \1344\:GNDA) analogLib_presistor_schematic c=0 \
        r=3.3
    re3212 (\1389\:GNDA \1388\:GNDA) analogLib_presistor_schematic c=0 \
        r=3.3
    re3213 (\1389\:GNDA \1391\:GNDA) analogLib_presistor_schematic c=0 \
        r=9.9
    re3214 (\1394\:GNDA \1395\:GNDA) analogLib_presistor_schematic c=0 \
        r=2.12143
    re3215 (\1394\:GNDA \1396\:GNDA) analogLib_presistor_schematic c=0 \
        r=5.94
    re3216 (\1398\:GNDA \1399\:GNDA) analogLib_presistor_schematic c=0 \
        r=2.12143
    re3217 (\1398\:GNDA \1400\:GNDA) analogLib_presistor_schematic c=0 \
        r=5.94
    re3218 (\1403\:GNDA \1402\:GNDA) analogLib_presistor_schematic c=0 \
        r=3.3
    re3219 (\1377\:GNDA \1406\:GNDA) analogLib_presistor_schematic c=0 \
        r=5.94
    re3220 (\1377\:GNDA \1407\:GNDA) analogLib_presistor_schematic c=0 \
        r=2.12143
    re3221 (\1355\:GNDA \1354\:GNDA) analogLib_presistor_schematic c=0 \
        r=3.7125
    re3222 (\1377\:GNDA \1354\:GNDA) analogLib_presistor_schematic c=0 \
        r=2.475
    re3223 (\1302\:GNDA \1410\:GNDA) analogLib_presistor_schematic c=0 \
        r=5.94
    re3224 (\1302\:GNDA \1411\:GNDA) analogLib_presistor_schematic c=0 \
        r=2.12143
    re3225 (\1226\:GNDA \1225\:GNDA) analogLib_presistor_schematic c=0 \
        r=3.7125
    re3226 (\1302\:GNDA \1225\:GNDA) analogLib_presistor_schematic c=0 \
        r=2.475
    re3227 (\1415\:GNDA \1416\:GNDA) analogLib_presistor_schematic c=0 \
        r=2.12143
    re3228 (\1415\:GNDA \1417\:GNDA) analogLib_presistor_schematic c=0 \
        r=5.94
    re3229 (\1421\:GNDA \1422\:GNDA) analogLib_presistor_schematic c=0 \
        r=0.54
    re3230 (\1374\:GNDA \1373\:GNDA) analogLib_presistor_schematic c=0 \
        r=3.7125
    re3231 (\1398\:GNDA \1373\:GNDA) analogLib_presistor_schematic c=0 \
        r=2.475
    re3232 (\1398\:GNDA \1426\:GNDA) analogLib_presistor_schematic c=0 \
        r=2.12143
    re3233 (\1427\:GNDA \1428\:GNDA) analogLib_presistor_schematic c=0 \
        r=2.12143
    re3234 (\1427\:GNDA \1429\:GNDA) analogLib_presistor_schematic c=0 \
        r=5.94
    re3235 (\1432\:GNDA \1433\:GNDA) analogLib_presistor_schematic c=0 \
        r=0.54
    re3236 (\1389\:GNDA \1434\:GNDA) analogLib_presistor_schematic c=0 \
        r=8.48571
    re3237 (\1389\:GNDA \1388\:GNDA) analogLib_presistor_schematic c=0 \
        r=3.3
    re3238 (\1394\:GNDA \1437\:GNDA) analogLib_presistor_schematic c=0 \
        r=5.94
    re3239 (\1394\:GNDA \1438\:GNDA) analogLib_presistor_schematic c=0 \
        r=2.12143
    re3240 (\1324\:GNDA \1323\:GNDA) analogLib_presistor_schematic c=0 \
        r=3.7125
    re3241 (\1394\:GNDA \1323\:GNDA) analogLib_presistor_schematic c=0 \
        r=2.475
    re3242 (\1374\:GNDA \1373\:GNDA) analogLib_presistor_schematic c=0 \
        r=3.3
    re3243 (\1403\:GNDA \1402\:GNDA) analogLib_presistor_schematic c=0 \
        r=3.7125
    re3244 (\1427\:GNDA \1402\:GNDA) analogLib_presistor_schematic c=0 \
        r=2.475
    re3245 (\1427\:GNDA \1444\:GNDA) analogLib_presistor_schematic c=0 \
        r=2.12143
    re3246 (\1447\:GNDA \1448\:GNDA) analogLib_presistor_schematic c=0 \
        r=2.12143
    re3247 (\1447\:GNDA \1449\:GNDA) analogLib_presistor_schematic c=0 \
        r=5.94
    re3248 (\1452\:GNDA \1451\:GNDA) analogLib_presistor_schematic c=0 \
        r=3.3
    re3249 (\1452\:GNDA \1454\:GNDA) analogLib_presistor_schematic c=0 \
        r=9.9
    re3250 (\1403\:GNDA \1402\:GNDA) analogLib_presistor_schematic c=0 \
        r=3.3
    re3251 (\1364\:GNDA \1458\:GNDA) analogLib_presistor_schematic c=0 \
        r=5.94
    re3252 (\1364\:GNDA \1459\:GNDA) analogLib_presistor_schematic c=0 \
        r=2.12143
    re3253 (\1284\:GNDA \1283\:GNDA) analogLib_presistor_schematic c=0 \
        r=3.7125
    re3254 (\1364\:GNDA \1283\:GNDA) analogLib_presistor_schematic c=0 \
        r=2.475
    re3255 (\1415\:GNDA \1462\:GNDA) analogLib_presistor_schematic c=0 \
        r=5.94
    re3256 (\1415\:GNDA \1463\:GNDA) analogLib_presistor_schematic c=0 \
        r=2.12143
    re3257 (\1345\:GNDA \1344\:GNDA) analogLib_presistor_schematic c=0 \
        r=3.7125
    re3258 (\1415\:GNDA \1344\:GNDA) analogLib_presistor_schematic c=0 \
        r=2.475
    re3259 (\1466\:GNDA \1467\:GNDA) analogLib_presistor_schematic c=0 \
        r=0.54
    re3260 (\1452\:GNDA \1468\:GNDA) analogLib_presistor_schematic c=0 \
        r=8.48571
    re3261 (\1452\:GNDA \1451\:GNDA) analogLib_presistor_schematic c=0 \
        r=3.3
    re3262 (\1472\:GNDA \1471\:GNDA) analogLib_presistor_schematic c=0 \
        r=3.3
    re3263 (\1472\:GNDA \1474\:GNDA) analogLib_presistor_schematic c=0 \
        r=9.9
    re3264 (\1472\:GNDA \1477\:GNDA) analogLib_presistor_schematic c=0 \
        r=8.48571
    re3265 (\1472\:GNDA \1471\:GNDA) analogLib_presistor_schematic c=0 \
        r=3.3
    re3266 (\1481\:GNDA \1482\:GNDA) analogLib_presistor_schematic c=0 \
        r=2.12143
    re3267 (\1481\:GNDA \1483\:GNDA) analogLib_presistor_schematic c=0 \
        r=5.94
    re3268 (\1486\:GNDA \1487\:GNDA) analogLib_presistor_schematic c=0 \
        r=2.12143
    re3269 (\1486\:GNDA \1488\:GNDA) analogLib_presistor_schematic c=0 \
        r=5.94
    re3270 (\1447\:GNDA \1491\:GNDA) analogLib_presistor_schematic c=0 \
        r=5.94
    re3271 (\1447\:GNDA \1492\:GNDA) analogLib_presistor_schematic c=0 \
        r=2.12143
    re3272 (\1389\:GNDA \1388\:GNDA) analogLib_presistor_schematic c=0 \
        r=3.7125
    re3273 (\1447\:GNDA \1388\:GNDA) analogLib_presistor_schematic c=0 \
        r=2.475
    re3274 (\1481\:GNDA \1496\:GNDA) analogLib_presistor_schematic c=0 \
        r=5.94
    re3275 (\1481\:GNDA \1497\:GNDA) analogLib_presistor_schematic c=0 \
        r=2.12143
    re3276 (\1452\:GNDA \1451\:GNDA) analogLib_presistor_schematic c=0 \
        r=3.7125
    re3277 (\1481\:GNDA \1451\:GNDA) analogLib_presistor_schematic c=0 \
        r=2.475
    re3278 (\1486\:GNDA \1501\:GNDA) analogLib_presistor_schematic c=0 \
        r=5.94
    re3279 (\1486\:GNDA \1502\:GNDA) analogLib_presistor_schematic c=0 \
        r=2.12143
    re3280 (\1472\:GNDA \1471\:GNDA) analogLib_presistor_schematic c=0 \
        r=3.7125
    re3281 (\1486\:GNDA \1471\:GNDA) analogLib_presistor_schematic c=0 \
        r=2.475
    re3297 (\69\:GNDA \592\:GNDA) analogLib_presistor_schematic c=0 r=19.8
    re3416 (\2\:D2 \13\:D2) analogLib_presistor_schematic c=0 r=0.33
    re3417 (\5\:D2 \14\:D2) analogLib_presistor_schematic c=0 r=0.33
    re3283 (\6\:Vo1 \11\:Vo1) analogLib_presistor_schematic c=0 r=0.99
    re3284 (\8\:Vo1 \14\:Vo1) analogLib_presistor_schematic c=0 r=0.99
    rf1 (\5\:Vo1 \6\:Vo1) analogLib_presistor_schematic c=0 r=10.8347
    rf2 (\6\:Vo1 \7\:Vo1) analogLib_presistor_schematic c=0 r=9.48033
    rf3 (\7\:Vo1 \8\:Vo1) analogLib_presistor_schematic c=0 r=4.063
    rf4 (\8\:Vo1 \9\:Vo1) analogLib_presistor_schematic c=0 r=13.5433
    rf5 (\5\:GNDA \6\:GNDA) analogLib_presistor_schematic c=0 r=239.954
    rf6 (\6\:GNDA \7\:GNDA) analogLib_presistor_schematic c=0 r=490.155
    rf7 (\7\:GNDA \8\:GNDA) analogLib_presistor_schematic c=0 r=911.214
    rf8 (\8\:GNDA \9\:GNDA) analogLib_presistor_schematic c=0 r=484.216
    rf9 (\9\:GNDA \10\:GNDA) analogLib_presistor_schematic c=0 r=468.68
    rf10 (\10\:GNDA \11\:GNDA) analogLib_presistor_schematic c=0 r=469.606
    rf11 (\11\:GNDA \12\:GNDA) analogLib_presistor_schematic c=0 r=498.875
    rf12 (\12\:GNDA \13\:GNDA) analogLib_presistor_schematic c=0 r=289.836
    rf13 (\13\:GNDA \14\:GNDA) analogLib_presistor_schematic c=0 r=54.2217
    rf14 (\14\:GNDA \15\:GNDA) analogLib_presistor_schematic c=0 r=54.2217
    rf15 (\15\:GNDA \16\:GNDA) analogLib_presistor_schematic c=0 r=54.2217
    rf16 (\16\:GNDA \17\:GNDA) analogLib_presistor_schematic c=0 r=47.444
    rf17 (\17\:GNDA \18\:GNDA) analogLib_presistor_schematic c=0 r=47.444
    rf18 (\18\:GNDA \19\:GNDA) analogLib_presistor_schematic c=0 r=54.2217
    rf19 (\19\:GNDA \20\:GNDA) analogLib_presistor_schematic c=0 r=54.2217
    rf20 (\20\:GNDA \21\:GNDA) analogLib_presistor_schematic c=0 r=54.2217
    rf21 (\21\:GNDA \22\:GNDA) analogLib_presistor_schematic c=0 r=259.14
    rf22 (\22\:GNDA \23\:GNDA) analogLib_presistor_schematic c=0 r=465.097
    rf23 (\23\:GNDA \24\:GNDA) analogLib_presistor_schematic c=0 r=852.363
    rf24 (\24\:GNDA \25\:GNDA) analogLib_presistor_schematic c=0 r=469.535
    rf25 (\25\:GNDA \26\:GNDA) analogLib_presistor_schematic c=0 r=284.753
    rf26 (\26\:GNDA \27\:GNDA) analogLib_presistor_schematic c=0 r=253.451
    rf27 (\27\:GNDA \28\:GNDA) analogLib_presistor_schematic c=0 r=503.869
    rf28 (\28\:GNDA \29\:GNDA) analogLib_presistor_schematic c=0 r=906.563
    rf29 (\29\:GNDA \30\:GNDA) analogLib_presistor_schematic c=0 r=188.122
    rf30 (\30\:GNDA \31\:GNDA) analogLib_presistor_schematic c=0 r=233.805
    rf31 (\31\:GNDA \32\:GNDA) analogLib_presistor_schematic c=0 r=209.647
    rf32 (\32\:GNDA \33\:GNDA) analogLib_presistor_schematic c=0 r=223.536
    rf33 (\33\:GNDA \34\:GNDA) analogLib_presistor_schematic c=0 r=120.18
    rf34 (\30\:GNDA \35\:GNDA) analogLib_presistor_schematic c=0 r=106.522
    rf35 (\31\:GNDA \36\:GNDA) analogLib_presistor_schematic c=0 r=199.755
    rf36 (\32\:GNDA \37\:GNDA) analogLib_presistor_schematic c=0 r=197.153
    rf37 (\33\:GNDA \38\:GNDA) analogLib_presistor_schematic c=0 r=106.522
    rf38 (\33\:GNDA \39\:GNDA) analogLib_presistor_schematic c=0 r=242.832
    rf39 (\39\:GNDA \40\:GNDA) analogLib_presistor_schematic c=0 r=158.309
    rf40 (\34\:GNDA \23\:GNDA) analogLib_presistor_schematic c=0 r=59.3475
    rf41 (\35\:GNDA \28\:GNDA) analogLib_presistor_schematic c=0 r=84.2821
    rf42 (\36\:GNDA \27\:GNDA) analogLib_presistor_schematic c=0 r=1.44836
    rf43 (\37\:GNDA \25\:GNDA) analogLib_presistor_schematic c=0 r=2.03848
    rf44 (\38\:GNDA \24\:GNDA) analogLib_presistor_schematic c=0 r=84.2821
    rf45 (\39\:GNDA \41\:GNDA) analogLib_presistor_schematic c=0 r=292.545
    rf46 (\41\:GNDA \42\:GNDA) analogLib_presistor_schematic c=0 r=111.236
    rf47 (\40\:GNDA \22\:GNDA) analogLib_presistor_schematic c=0 r=59.3475
    rf48 (\41\:GNDA \43\:GNDA) analogLib_presistor_schematic c=0 r=241.07
    rf49 (\43\:GNDA \44\:GNDA) analogLib_presistor_schematic c=0 r=99.4365
    rf50 (\42\:GNDA \32\:GNDA) analogLib_presistor_schematic c=0 r=106.692
    rf51 (\43\:GNDA \45\:GNDA) analogLib_presistor_schematic c=0 r=235.813
    rf52 (\45\:GNDA \46\:GNDA) analogLib_presistor_schematic c=0 r=104.233
    rf53 (\44\:GNDA \31\:GNDA) analogLib_presistor_schematic c=0 r=102.27
    rf54 (\45\:GNDA \47\:GNDA) analogLib_presistor_schematic c=0 r=186.118
    rf55 (\47\:GNDA \48\:GNDA) analogLib_presistor_schematic c=0 r=220.006
    rf56 (\46\:GNDA \30\:GNDA) analogLib_presistor_schematic c=0 r=115.387
    rf57 (\47\:GNDA \49\:GNDA) analogLib_presistor_schematic c=0 r=488.17
    rf58 (\49\:GNDA \50\:GNDA) analogLib_presistor_schematic c=0 r=186.118
    rf59 (\50\:GNDA \51\:GNDA) analogLib_presistor_schematic c=0 r=235.813
    rf60 (\51\:GNDA \52\:GNDA) analogLib_presistor_schematic c=0 r=227.846
    rf61 (\52\:GNDA \53\:GNDA) analogLib_presistor_schematic c=0 r=236.655
    rf62 (\53\:GNDA \54\:GNDA) analogLib_presistor_schematic c=0 r=165.564
    rf63 (\48\:GNDA \29\:GNDA) analogLib_presistor_schematic c=0 r=213.841
    rf64 (\50\:GNDA \55\:GNDA) analogLib_presistor_schematic c=0 r=104.233
    rf65 (\51\:GNDA \56\:GNDA) analogLib_presistor_schematic c=0 r=98.2706
    rf66 (\52\:GNDA \57\:GNDA) analogLib_presistor_schematic c=0 r=199.523
    rf67 (\53\:GNDA \58\:GNDA) analogLib_presistor_schematic c=0 r=227.049
    rf68 (\53\:GNDA \59\:GNDA) analogLib_presistor_schematic c=0 r=255.92
    rf69 (\59\:GNDA \60\:GNDA) analogLib_presistor_schematic c=0 r=190.44
    rf70 (\54\:GNDA \16\:GNDA) analogLib_presistor_schematic c=0 r=85.524
    rf71 (\55\:GNDA \45\:GNDA) analogLib_presistor_schematic c=0 r=113.097
    rf72 (\56\:GNDA \43\:GNDA) analogLib_presistor_schematic c=0 r=105.038
    rf73 (\57\:GNDA \41\:GNDA) analogLib_presistor_schematic c=0 r=32.4289
    rf74 (\58\:GNDA \39\:GNDA) analogLib_presistor_schematic c=0 r=32.4289
    rf75 (\59\:GNDA \61\:GNDA) analogLib_presistor_schematic c=0 r=223.66
    rf76 (\61\:GNDA \62\:GNDA) analogLib_presistor_schematic c=0 r=108.579
    rf77 (\60\:GNDA \12\:GNDA) analogLib_presistor_schematic c=0 r=13.4696
    rf78 (\61\:GNDA \63\:GNDA) analogLib_presistor_schematic c=0 r=222.21
    rf79 (\63\:GNDA \64\:GNDA) analogLib_presistor_schematic c=0 r=202.361
    rf80 (\62\:GNDA \52\:GNDA) analogLib_presistor_schematic c=0 r=108.579
    rf81 (\63\:GNDA \65\:GNDA) analogLib_presistor_schematic c=0 r=222.974
    rf82 (\65\:GNDA \66\:GNDA) analogLib_presistor_schematic c=0 r=108.579
    rf83 (\64\:GNDA \51\:GNDA) analogLib_presistor_schematic c=0 r=17.0075
    rf84 (\65\:GNDA \67\:GNDA) analogLib_presistor_schematic c=0 r=203.9
    rf85 (\67\:GNDA \68\:GNDA) analogLib_presistor_schematic c=0 r=220.006
    rf86 (\66\:GNDA \50\:GNDA) analogLib_presistor_schematic c=0 r=113.097
    rf87 (\67\:GNDA \69\:GNDA) analogLib_presistor_schematic c=0 r=266.202
    rf88 (\69\:GNDA \70\:GNDA) analogLib_presistor_schematic c=0 r=202.888
    rf89 (\70\:GNDA \71\:GNDA) analogLib_presistor_schematic c=0 r=176.316
    rf90 (\71\:GNDA \72\:GNDA) analogLib_presistor_schematic c=0 r=209.081
    rf91 (\72\:GNDA \73\:GNDA) analogLib_presistor_schematic c=0 r=248.373
    rf92 (\73\:GNDA \74\:GNDA) analogLib_presistor_schematic c=0 r=268.361
    rf93 (\74\:GNDA \75\:GNDA) analogLib_presistor_schematic c=0 r=120.712
    rf94 (\68\:GNDA \49\:GNDA) analogLib_presistor_schematic c=0 r=220.006
    rf95 (\71\:GNDA \76\:GNDA) analogLib_presistor_schematic c=0 r=108.579
    rf96 (\72\:GNDA \77\:GNDA) analogLib_presistor_schematic c=0 r=103.089
    rf97 (\73\:GNDA \78\:GNDA) analogLib_presistor_schematic c=0 r=127.24
    rf98 (\74\:GNDA \79\:GNDA) analogLib_presistor_schematic c=0 r=107.983
    rf99 (\74\:GNDA \80\:GNDA) analogLib_presistor_schematic c=0 r=234.946
    rf100 (\80\:GNDA \81\:GNDA) analogLib_presistor_schematic c=0 \
        r=158.309
    rf101 (\75\:GNDA \11\:GNDA) analogLib_presistor_schematic c=0 \
        r=73.3575
    rf102 (\76\:GNDA \65\:GNDA) analogLib_presistor_schematic c=0 \
        r=108.579
    rf103 (\77\:GNDA \63\:GNDA) analogLib_presistor_schematic c=0 \
        r=107.983
    rf104 (\78\:GNDA \61\:GNDA) analogLib_presistor_schematic c=0 \
        r=108.579
    rf105 (\79\:GNDA \59\:GNDA) analogLib_presistor_schematic c=0 \
        r=105.146
    rf106 (\80\:GNDA \82\:GNDA) analogLib_presistor_schematic c=0 r=300.64
    rf107 (\82\:GNDA \83\:GNDA) analogLib_presistor_schematic c=0 \
        r=102.666
    rf108 (\81\:GNDA \10\:GNDA) analogLib_presistor_schematic c=0 \
        r=59.3475
    rf109 (\82\:GNDA \84\:GNDA) analogLib_presistor_schematic c=0 \
        r=285.646
    rf110 (\84\:GNDA \85\:GNDA) analogLib_presistor_schematic c=0 r=102.27
    rf111 (\83\:GNDA \73\:GNDA) analogLib_presistor_schematic c=0 \
        r=132.671
    rf112 (\84\:GNDA \86\:GNDA) analogLib_presistor_schematic c=0 r=266.69
    rf113 (\86\:GNDA \87\:GNDA) analogLib_presistor_schematic c=0 \
        r=123.807
    rf114 (\85\:GNDA \72\:GNDA) analogLib_presistor_schematic c=0 \
        r=115.387
    rf115 (\86\:GNDA \88\:GNDA) analogLib_presistor_schematic c=0 \
        r=188.556
    rf116 (\88\:GNDA \89\:GNDA) analogLib_presistor_schematic c=0 \
        r=200.926
    rf117 (\87\:GNDA \71\:GNDA) analogLib_presistor_schematic c=0 \
        r=105.146
    rf118 (\88\:GNDA \90\:GNDA) analogLib_presistor_schematic c=0 \
        r=461.036
    rf119 (\90\:GNDA \91\:GNDA) analogLib_presistor_schematic c=0 \
        r=157.779
    rf120 (\91\:GNDA \92\:GNDA) analogLib_presistor_schematic c=0 \
        r=218.905
    rf121 (\92\:GNDA \93\:GNDA) analogLib_presistor_schematic c=0 \
        r=237.442
    rf122 (\93\:GNDA \94\:GNDA) analogLib_presistor_schematic c=0 \
        r=211.418
    rf123 (\94\:GNDA \95\:GNDA) analogLib_presistor_schematic c=0 \
        r=107.572
    rf124 (\89\:GNDA \70\:GNDA) analogLib_presistor_schematic c=0 \
        r=211.953
    rf125 (\91\:GNDA \96\:GNDA) analogLib_presistor_schematic c=0 \
        r=104.233
    rf126 (\92\:GNDA \97\:GNDA) analogLib_presistor_schematic c=0 \
        r=104.233
    rf127 (\93\:GNDA \98\:GNDA) analogLib_presistor_schematic c=0 \
        r=206.064
    rf128 (\94\:GNDA \99\:GNDA) analogLib_presistor_schematic c=0 \
        r=102.776
    rf129 (\94\:GNDA \100\:GNDA) analogLib_presistor_schematic c=0 \
        r=250.142
    rf130 (\100\:GNDA \101\:GNDA) analogLib_presistor_schematic c=0 \
        r=165.564
    rf131 (\95\:GNDA \9\:GNDA) analogLib_presistor_schematic c=0 r=75.6722
    rf132 (\96\:GNDA \86\:GNDA) analogLib_presistor_schematic c=0 \
        r=136.104
    rf133 (\97\:GNDA \84\:GNDA) analogLib_presistor_schematic c=0 r=102.27
    rf134 (\98\:GNDA \82\:GNDA) analogLib_presistor_schematic c=0 \
        r=23.2701
    rf135 (\99\:GNDA \80\:GNDA) analogLib_presistor_schematic c=0 r=120.1
    rf136 (\100\:GNDA \102\:GNDA) analogLib_presistor_schematic c=0 \
        r=235.205
    rf137 (\102\:GNDA \103\:GNDA) analogLib_presistor_schematic c=0 \
        r=107.983
    rf138 (\100\:GNDA \104\:GNDA) analogLib_presistor_schematic c=0 \
        r=127.24
    rf139 (\101\:GNDA \8\:GNDA) analogLib_presistor_schematic c=0 \
        r=73.3575
    rf140 (\102\:GNDA \105\:GNDA) analogLib_presistor_schematic c=0 \
        r=236.755
    rf141 (\105\:GNDA \106\:GNDA) analogLib_presistor_schematic c=0 \
        r=104.233
    rf142 (\102\:GNDA \107\:GNDA) analogLib_presistor_schematic c=0 \
        r=107.983
    rf143 (\103\:GNDA \93\:GNDA) analogLib_presistor_schematic c=0 \
        r=105.146
    rf144 (\104\:GNDA \7\:GNDA) analogLib_presistor_schematic c=0 \
        r=84.2821
    rf145 (\105\:GNDA \108\:GNDA) analogLib_presistor_schematic c=0 \
        r=218.905
    rf146 (\108\:GNDA \109\:GNDA) analogLib_presistor_schematic c=0 \
        r=104.233
    rf147 (\106\:GNDA \92\:GNDA) analogLib_presistor_schematic c=0 \
        r=113.097
    rf148 (\107\:GNDA \6\:GNDA) analogLib_presistor_schematic c=0 \
        r=80.8486
    rf149 (\108\:GNDA \110\:GNDA) analogLib_presistor_schematic c=0 \
        r=157.779
    rf150 (\110\:GNDA \111\:GNDA) analogLib_presistor_schematic c=0 \
        r=200.926
    rf151 (\109\:GNDA \91\:GNDA) analogLib_presistor_schematic c=0 \
        r=113.097
    rf152 (\110\:GNDA \112\:GNDA) analogLib_presistor_schematic c=0 \
        r=904.69
    rf153 (\112\:GNDA \113\:GNDA) analogLib_presistor_schematic c=0 \
        r=487.118
    rf154 (\113\:GNDA \114\:GNDA) analogLib_presistor_schematic c=0 \
        r=159.353
    rf155 (\111\:GNDA \90\:GNDA) analogLib_presistor_schematic c=0 \
        r=211.953
    rf156 (\112\:GNDA \115\:GNDA) analogLib_presistor_schematic c=0 \
        r=84.2817
    rf157 (\113\:GNDA \116\:GNDA) analogLib_presistor_schematic c=0 \
        r=84.2817
    rf158 (\114\:GNDA \5\:GNDA) analogLib_presistor_schematic c=0 \
        r=66.6266
    rf159 (\115\:GNDA \108\:GNDA) analogLib_presistor_schematic c=0 \
        r=113.097
    rf160 (\116\:GNDA \105\:GNDA) analogLib_presistor_schematic c=0 \
        r=113.097
    rg1 (\1\:VDDA \2\:VDDA) analogLib_presistor_schematic c=0 r=4.95343
    rg2 (\3\:VDDA \4\:VDDA) analogLib_presistor_schematic c=0 r=6.61949
    rg3 (\5\:VDDA \6\:VDDA) analogLib_presistor_schematic c=0 r=6.61949
    rg4 (\7\:VDDA \8\:VDDA) analogLib_presistor_schematic c=0 r=6.61949
    rg5 (\9\:VDDA \10\:VDDA) analogLib_presistor_schematic c=0 r=6.61949
    rg6 (\11\:VDDA \12\:VDDA) analogLib_presistor_schematic c=0 r=6.61949
    rg7 (\13\:VDDA \14\:VDDA) analogLib_presistor_schematic c=0 r=6.61949
    rg8 (\15\:VDDA \16\:VDDA) analogLib_presistor_schematic c=0 r=4.55128
    rg9 (\17\:VDDA \18\:VDDA) analogLib_presistor_schematic c=0 r=4.95343
    rg10 (Vm1 \2\:Vm1) analogLib_presistor_schematic c=0 r=4.55128
    rg11 (\3\:Vm1 \4\:Vm1) analogLib_presistor_schematic c=0 r=4.55128
    rg12 (\5\:Vm1 \6\:Vm1) analogLib_presistor_schematic c=0 r=4.55128
    rg13 (\7\:Vm1 \8\:Vm1) analogLib_presistor_schematic c=0 r=4.55128
    rg14 (\9\:Vm1 \10\:Vm1) analogLib_presistor_schematic c=0 r=4.55128
    rg15 (\11\:Vm1 \12\:Vm1) analogLib_presistor_schematic c=0 r=4.55128
    rg16 (\19\:VDDA \20\:VDDA) analogLib_presistor_schematic c=0 r=4.55128
    rg17 (\21\:VDDA \22\:VDDA) analogLib_presistor_schematic c=0 r=4.95343
    rg18 (\13\:Vm1 \14\:Vm1) analogLib_presistor_schematic c=0 r=4.55128
    rg19 (\15\:Vm1 \16\:Vm1) analogLib_presistor_schematic c=0 r=4.55128
    rg20 (\17\:Vm1 \18\:Vm1) analogLib_presistor_schematic c=0 r=4.55128
    rg21 (\19\:Vm1 \20\:Vm1) analogLib_presistor_schematic c=0 r=4.55128
    rg22 (\21\:Vm1 \22\:Vm1) analogLib_presistor_schematic c=0 r=4.55128
    rg23 (\23\:Vm1 \24\:Vm1) analogLib_presistor_schematic c=0 r=4.55128
    rg24 (\23\:VDDA \24\:VDDA) analogLib_presistor_schematic c=0 r=4.55128
    rg25 (\1\:BG_REF \2\:BG_REF) analogLib_presistor_schematic c=0 \
        r=2.04924
    rg26 (\3\:BG_REF \4\:BG_REF) analogLib_presistor_schematic c=0 \
        r=2.14824
    rg27 (\2\:BG_REF \4\:BG_REF) analogLib_presistor_schematic c=0 \
        r=2.0608
    rg28 (\5\:BG_REF \6\:BG_REF) analogLib_presistor_schematic c=0 \
        r=2.04924
    rg29 (\4\:BG_REF \5\:BG_REF) analogLib_presistor_schematic c=0 \
        r=0.7728
    rg30 (\7\:BG_REF \6\:BG_REF) analogLib_presistor_schematic c=0 \
        r=2.14824
    rg31 (\5\:BG_REF \6\:BG_REF) analogLib_presistor_schematic c=0 r=1.288
    rg32 (\9\:BG_REF \6\:BG_REF) analogLib_presistor_schematic c=0 \
        r=2.04924
    rg34 (\25\:VDDA \26\:VDDA) analogLib_presistor_schematic c=0 r=4.95343
    rg35 (\25\:Vm1 \26\:Vm1) analogLib_presistor_schematic c=0 r=4.55128
    rg36 (\27\:Vm1 \28\:Vm1) analogLib_presistor_schematic c=0 r=4.55128
    rg37 (\29\:Vm1 \30\:Vm1) analogLib_presistor_schematic c=0 r=4.55128
    rg38 (\31\:Vm1 \32\:Vm1) analogLib_presistor_schematic c=0 r=4.55128
    rg39 (\33\:Vm1 \34\:Vm1) analogLib_presistor_schematic c=0 r=4.55128
    rg40 (\35\:Vm1 \36\:Vm1) analogLib_presistor_schematic c=0 r=4.55128
    rg41 (\27\:VDDA \28\:VDDA) analogLib_presistor_schematic c=0 r=4.55128
    rg42 (\29\:VDDA \30\:VDDA) analogLib_presistor_schematic c=0 r=4.95343
    rg43 (\37\:Vm1 \38\:Vm1) analogLib_presistor_schematic c=0 r=4.55128
    rg44 (\39\:Vm1 \40\:Vm1) analogLib_presistor_schematic c=0 r=4.55128
    rg45 (\41\:Vm1 \42\:Vm1) analogLib_presistor_schematic c=0 r=4.55128
    rg46 (\43\:Vm1 \44\:Vm1) analogLib_presistor_schematic c=0 r=4.55128
    rg47 (\45\:Vm1 \46\:Vm1) analogLib_presistor_schematic c=0 r=4.55128
    rg48 (\47\:Vm1 \48\:Vm1) analogLib_presistor_schematic c=0 r=4.55128
    rg49 (\31\:VDDA \32\:VDDA) analogLib_presistor_schematic c=0 r=4.55128
    rg50 (D1 \2\:D1) analogLib_presistor_schematic c=0 r=7.43922
    rg51 (\2\:D1 \3\:D1) analogLib_presistor_schematic c=0 r=7.43922
    rg52 (\33\:VDDA \34\:VDDA) analogLib_presistor_schematic c=0 r=4.95343
    rg53 (\49\:Vm1 \50\:Vm1) analogLib_presistor_schematic c=0 r=4.55128
    rg54 (\51\:Vm1 \52\:Vm1) analogLib_presistor_schematic c=0 r=4.55128
    rg55 (\53\:Vm1 \54\:Vm1) analogLib_presistor_schematic c=0 r=4.55128
    rg56 (\55\:Vm1 \56\:Vm1) analogLib_presistor_schematic c=0 r=4.55128
    rg57 (\57\:Vm1 \58\:Vm1) analogLib_presistor_schematic c=0 r=4.55128
    rg58 (\59\:Vm1 \60\:Vm1) analogLib_presistor_schematic c=0 r=4.55128
    rg59 (\35\:VDDA \36\:VDDA) analogLib_presistor_schematic c=0 r=4.55128
    rg60 (\4\:D1 \5\:D1) analogLib_presistor_schematic c=0 r=7.43922
    rg61 (\5\:D1 \6\:D1) analogLib_presistor_schematic c=0 r=7.43922
    rg62 (\37\:VDDA \38\:VDDA) analogLib_presistor_schematic c=0 r=4.95343
    rg63 (\61\:Vm1 \62\:Vm1) analogLib_presistor_schematic c=0 r=4.55128
    rg64 (\63\:Vm1 \64\:Vm1) analogLib_presistor_schematic c=0 r=4.55128
    rg65 (\65\:Vm1 \66\:Vm1) analogLib_presistor_schematic c=0 r=4.55128
    rg66 (\67\:Vm1 \68\:Vm1) analogLib_presistor_schematic c=0 r=4.55128
    rg67 (\69\:Vm1 \70\:Vm1) analogLib_presistor_schematic c=0 r=4.55128
    rg68 (\71\:Vm1 \72\:Vm1) analogLib_presistor_schematic c=0 r=4.55128
    rg69 (\39\:VDDA \40\:VDDA) analogLib_presistor_schematic c=0 r=4.55128
    rg70 (\41\:VDDA \42\:VDDA) analogLib_presistor_schematic c=0 r=4.95343
    rg71 (\73\:Vm1 \74\:Vm1) analogLib_presistor_schematic c=0 r=4.55128
    rg72 (\75\:Vm1 \76\:Vm1) analogLib_presistor_schematic c=0 r=4.55128
    rg73 (\77\:Vm1 \78\:Vm1) analogLib_presistor_schematic c=0 r=4.55128
    rg74 (\79\:Vm1 \80\:Vm1) analogLib_presistor_schematic c=0 r=4.55128
    rg75 (\81\:Vm1 \82\:Vm1) analogLib_presistor_schematic c=0 r=4.55128
    rg76 (\83\:Vm1 \84\:Vm1) analogLib_presistor_schematic c=0 r=4.55128
    rg77 (\43\:VDDA \44\:VDDA) analogLib_presistor_schematic c=0 r=4.55128
    rg78 (\45\:VDDA \46\:VDDA) analogLib_presistor_schematic c=0 r=4.95343
    rg79 (\85\:Vm1 \86\:Vm1) analogLib_presistor_schematic c=0 r=4.55128
    rg80 (\87\:Vm1 \88\:Vm1) analogLib_presistor_schematic c=0 r=4.55128
    rg81 (\89\:Vm1 \90\:Vm1) analogLib_presistor_schematic c=0 r=4.55128
    rg82 (\91\:Vm1 \92\:Vm1) analogLib_presistor_schematic c=0 r=4.55128
    rg83 (\93\:Vm1 \94\:Vm1) analogLib_presistor_schematic c=0 r=4.55128
    rg84 (\95\:Vm1 \96\:Vm1) analogLib_presistor_schematic c=0 r=4.55128
    rg85 (\47\:VDDA \48\:VDDA) analogLib_presistor_schematic c=0 r=4.55128
    rg86 (S \2\:S) analogLib_presistor_schematic c=0 r=30.6283
    rg87 (\3\:S \4\:S) analogLib_presistor_schematic c=0 r=30.6283
    rg88 (X \2\:X) analogLib_presistor_schematic c=0 r=55.9982
    rg89 (Y \2\:Y) analogLib_presistor_schematic c=0 r=55.9982
    rg90 (\49\:VDDA \50\:VDDA) analogLib_presistor_schematic c=0 r=4.95343
    rg91 (\97\:Vm1 \98\:Vm1) analogLib_presistor_schematic c=0 r=4.55128
    rg92 (\99\:Vm1 \100\:Vm1) analogLib_presistor_schematic c=0 r=4.55128
    rg93 (\101\:Vm1 \102\:Vm1) analogLib_presistor_schematic c=0 r=4.55128
    rg94 (\103\:Vm1 \104\:Vm1) analogLib_presistor_schematic c=0 r=4.55128
    rg95 (\105\:Vm1 \106\:Vm1) analogLib_presistor_schematic c=0 r=4.55128
    rg96 (\107\:Vm1 \108\:Vm1) analogLib_presistor_schematic c=0 r=4.55128
    rg97 (\51\:VDDA \52\:VDDA) analogLib_presistor_schematic c=0 r=4.55128
    rg98 (\3\:Y \4\:Y) analogLib_presistor_schematic c=0 r=36.7368
    rg99 (\3\:X \4\:X) analogLib_presistor_schematic c=0 r=36.7368
    rg100 (\5\:X \6\:X) analogLib_presistor_schematic c=0 r=56.6582
    rg101 (\5\:Y \6\:Y) analogLib_presistor_schematic c=0 r=56.6582
    rg102 (\53\:VDDA \54\:VDDA) analogLib_presistor_schematic c=0 \
        r=4.95343
    rg103 (\55\:VDDA \56\:VDDA) analogLib_presistor_schematic c=0 \
        r=6.61949
    rg104 (\57\:VDDA \58\:VDDA) analogLib_presistor_schematic c=0 \
        r=6.61949
    rg105 (\59\:VDDA \60\:VDDA) analogLib_presistor_schematic c=0 \
        r=6.61949
    rg106 (\61\:VDDA \62\:VDDA) analogLib_presistor_schematic c=0 \
        r=6.61949
    rg107 (\63\:VDDA \64\:VDDA) analogLib_presistor_schematic c=0 \
        r=6.61949
    rg108 (\65\:VDDA \66\:VDDA) analogLib_presistor_schematic c=0 \
        r=6.61949
    rg109 (\67\:VDDA \68\:VDDA) analogLib_presistor_schematic c=0 \
        r=4.55128
    rg110 (\7\:Y \8\:Y) analogLib_presistor_schematic c=0 r=36.7368
    rg111 (\7\:X \8\:X) analogLib_presistor_schematic c=0 r=36.7368
    rg112 (\9\:X \10\:X) analogLib_presistor_schematic c=0 r=56.6582
    rg113 (\9\:Y \10\:Y) analogLib_presistor_schematic c=0 r=56.6582
    rg114 (\11\:Y \12\:Y) analogLib_presistor_schematic c=0 r=36.7368
    rg115 (\11\:X \12\:X) analogLib_presistor_schematic c=0 r=36.7368
    rg116 (\13\:X \14\:X) analogLib_presistor_schematic c=0 r=56.6582
    rg117 (\13\:Y \14\:Y) analogLib_presistor_schematic c=0 r=56.6582
    rg118 (\15\:Y \16\:Y) analogLib_presistor_schematic c=0 r=36.7368
    rg119 (\15\:X \16\:X) analogLib_presistor_schematic c=0 r=36.7368
    rg120 (\5\:S \6\:S) analogLib_presistor_schematic c=0 r=30.6283
    rg121 (\7\:S \8\:S) analogLib_presistor_schematic c=0 r=30.6283
    rg122 (S2 \2\:S2) analogLib_presistor_schematic c=0 r=193.331
    rg123 (\3\:S2 \4\:S2) analogLib_presistor_schematic c=0 r=193.331
    rg124 (vv \2\:vv) analogLib_presistor_schematic c=0 r=181.695
    rg125 (\11\:BG_REF \12\:BG_REF) analogLib_presistor_schematic c=0 \
        r=181.695
    rg126 (\1\:BIAS \2\:BIAS) analogLib_presistor_schematic c=0 r=9.17501
    rg127 (\2\:BIAS \3\:BIAS) analogLib_presistor_schematic c=0 r=9.17501
    rg128 (\3\:BIAS \4\:BIAS) analogLib_presistor_schematic c=0 r=9.17501
    rg129 (\4\:BIAS \5\:BIAS) analogLib_presistor_schematic c=0 r=9.17501
    rg130 (\5\:BIAS \6\:BIAS) analogLib_presistor_schematic c=0 r=9.17501
    rg131 (\6\:BIAS \7\:BIAS) analogLib_presistor_schematic c=0 r=7.50124
    rg132 (\1\:BIAS \8\:BIAS) analogLib_presistor_schematic c=0 r=8.64204
    rg133 (\13\:BG_REF \14\:BG_REF) analogLib_presistor_schematic c=0 \
        r=230.981
    rg134 (\3\:vv \4\:vv) analogLib_presistor_schematic c=0 r=278.895
    rg135 (\5\:S2 \6\:S2) analogLib_presistor_schematic c=0 r=193.331
    rg136 (\7\:S2 \8\:S2) analogLib_presistor_schematic c=0 r=193.331
    rg137 (Vo1 \2\:Vo1) analogLib_presistor_schematic c=0 r=45.2685
    rg138 (\2\:Vo1 \3\:Vo1) analogLib_presistor_schematic c=0 r=44.0061
    rg139 (\2\:Vo1 \4\:Vo1) analogLib_presistor_schematic c=0 r=9.91582
    rg140 (Vs \2\:Vs) analogLib_presistor_schematic c=0 r=4.51791
    rg141 (D2 \2\:D2) analogLib_presistor_schematic c=0 r=7.51988
    rg142 (\2\:D2 \3\:D2) analogLib_presistor_schematic c=0 r=7.51988
    rg143 (\4\:D2 \5\:D2) analogLib_presistor_schematic c=0 r=7.51988
    rg144 (\5\:D2 \6\:D2) analogLib_presistor_schematic c=0 r=7.51988
    rg145 (\5\:vv \6\:vv) analogLib_presistor_schematic c=0 r=2.24783
    Q3\(30\) (\1251\:GNDA \998\:GNDA \1013\:GNDA \1251\:GNDA) vert10 m=1.0
    Q3\(29\) (\1251\:GNDA \1040\:GNDA \1063\:GNDA \1251\:GNDA) vert10 \
        m=1.0
    Q3\(28\) (\1251\:GNDA \1099\:GNDA \1130\:GNDA \1251\:GNDA) vert10 \
        m=1.0
    Q3\(27\) (\1251\:GNDA \1181\:GNDA \1203\:GNDA \1251\:GNDA) vert10 \
        m=1.0
    Q3\(26\) (\1251\:GNDA \1244\:GNDA \1262\:GNDA \1251\:GNDA) vert10 \
        m=1.0
    Q3\(25\) (\1251\:GNDA \1302\:GNDA \1320\:GNDA \1251\:GNDA) vert10 \
        m=1.0
    Q3\(24\) (\1251\:GNDA \1364\:GNDA \1383\:GNDA \1251\:GNDA) vert10 \
        m=1.0
    Q3\(23\) (\1251\:GNDA \1415\:GNDA \1432\:GNDA \1251\:GNDA) vert10 \
        m=1.0
    Q3\(22\) (\1251\:GNDA \1447\:GNDA \1466\:GNDA \1251\:GNDA) vert10 \
        m=1.0
    Q3\(21\) (\1251\:GNDA \870\:GNDA \149\:GNDA \1251\:GNDA) vert10 m=1.0
    Q1\(30\) (\1251\:GNDA \160\:GNDA \35\:U \1251\:GNDA) vert10 m=1.0
    Q1\(29\) (\1251\:GNDA \165\:GNDA \37\:U \1251\:GNDA) vert10 m=1.0
    Q1\(28\) (\1251\:GNDA \170\:GNDA \39\:U \1251\:GNDA) vert10 m=1.0
    Q1\(27\) (\1251\:GNDA \175\:GNDA \41\:U \1251\:GNDA) vert10 m=1.0
    Q1\(26\) (\1251\:GNDA \180\:GNDA \43\:U \1251\:GNDA) vert10 m=1.0
    Q1\(25\) (\1251\:GNDA \185\:GNDA \47\:U \1251\:GNDA) vert10 m=1.0
    Q1\(24\) (\1251\:GNDA \190\:GNDA \49\:U \1251\:GNDA) vert10 m=1.0
    Q3\(20\) (\1251\:GNDA \515\:GNDA \664\:GNDA \1251\:GNDA) vert10 m=1.0
    Q3\(19\) (\1251\:GNDA \818\:GNDA \874\:GNDA \1251\:GNDA) vert10 m=1.0
    Q1\(23\) (\1251\:GNDA \823\:GNDA \56\:U \1251\:GNDA) vert10 m=1.0
    Q1\(22\) (\1251\:GNDA \968\:GNDA \58\:U \1251\:GNDA) vert10 m=1.0
    Q3\(18\) (\1251\:GNDA \1074\:GNDA \1105\:GNDA \1251\:GNDA) vert10 \
        m=1.0
    Q1\(21\) (\1251\:GNDA \1079\:GNDA \60\:U \1251\:GNDA) vert10 m=1.0
    Q3\(17\) (\1251\:GNDA \1187\:GNDA \1206\:GNDA \1251\:GNDA) vert10 \
        m=1.0
    Q1\(20\) (\1251\:GNDA \1192\:GNDA \64\:U \1251\:GNDA) vert10 m=1.0
    Q1\(19\) (\1251\:GNDA \1265\:GNDA \66\:U \1251\:GNDA) vert10 m=1.0
    Q3\(16\) (\1251\:GNDA \1394\:GNDA \1421\:GNDA \1251\:GNDA) vert10 \
        m=1.0
    Q3\(15\) (\1251\:GNDA \786\:GNDA \827\:GNDA \1251\:GNDA) vert10 m=1.0
    Q1\(18\) (\1251\:GNDA \791\:GNDA \22\:U \1251\:GNDA) vert10 m=1.0
    Q1\(17\) (\1251\:GNDA \956\:GNDA \24\:U \1251\:GNDA) vert10 m=1.0
    Q1\(16\) (\1251\:GNDA \1029\:GNDA \26\:U \1251\:GNDA) vert10 m=1.0
    Q0 (\1251\:GNDA \1133\:GNDA \31\:X \1251\:GNDA) vert10 m=1.0
    Q1\(15\) (\1251\:GNDA \1233\:GNDA \6\:U \1251\:GNDA) vert10 m=1.0
    Q1\(14\) (\1251\:GNDA \1309\:GNDA \10\:U \1251\:GNDA) vert10 m=1.0
    Q1\(13\) (\1251\:GNDA \1398\:GNDA \12\:U \1251\:GNDA) vert10 m=1.0
    Q3\(14\) (\1251\:GNDA \1481\:GNDA \1495\:GNDA \1251\:GNDA) vert10 \
        m=1.0
    Q3\(13\) (\1251\:GNDA \835\:GNDA \883\:GNDA \1251\:GNDA) vert10 m=1.0
    Q1\(12\) (\1251\:GNDA \839\:GNDA \75\:U \1251\:GNDA) vert10 m=1.0
    Q1\(11\) (\1251\:GNDA \975\:GNDA \77\:U \1251\:GNDA) vert10 m=1.0
    Q1\(10\) (\1251\:GNDA \1054\:GNDA \79\:U \1251\:GNDA) vert10 m=1.0
    Q1\(9\) (\1251\:GNDA \1172\:GNDA \81\:U \1251\:GNDA) vert10 m=1.0
    Q1\(8\) (\1251\:GNDA \1256\:GNDA \83\:U \1251\:GNDA) vert10 m=1.0
    Q1\(7\) (\1251\:GNDA \1332\:GNDA \87\:U \1251\:GNDA) vert10 m=1.0
    Q1\(6\) (\1251\:GNDA \1427\:GNDA \89\:U \1251\:GNDA) vert10 m=1.0
    Q3\(12\) (\1251\:GNDA \1486\:GNDA \1500\:GNDA \1251\:GNDA) vert10 \
        m=1.0
    Q3\(11\) (\1251\:GNDA \748\:GNDA \800\:GNDA \1251\:GNDA) vert10 m=1.0
    Q1\(5\) (\1251\:GNDA \753\:GNDA \97\:U \1251\:GNDA) vert10 m=1.0
    Q1\(4\) (\1251\:GNDA \935\:GNDA \99\:U \1251\:GNDA) vert10 m=1.0
    Q1\(3\) (\1251\:GNDA \1009\:GNDA \101\:U \1251\:GNDA) vert10 m=1.0
    Q3\(10\) (\1251\:GNDA \1117\:GNDA \1140\:GNDA \1251\:GNDA) vert10 \
        m=1.0
    Q1\(2\) (\1251\:GNDA \1122\:GNDA \103\:U \1251\:GNDA) vert10 m=1.0
    Q1\(1\) (\1251\:GNDA \1218\:GNDA \107\:U \1251\:GNDA) vert10 m=1.0
    Q1\(0\) (\1251\:GNDA \1297\:GNDA \109\:U \1251\:GNDA) vert10 m=1.0
    Q3\(9\) (\1251\:GNDA \1377\:GNDA \1405\:GNDA \1251\:GNDA) vert10 m=1.0
    Q3\(8\) (\1251\:GNDA \467\:GNDA \648\:GNDA \1251\:GNDA) vert10 m=1.0
    Q3\(7\) (\1251\:GNDA \455\:GNDA \641\:GNDA \1251\:GNDA) vert10 m=1.0
    Q3\(6\) (\1251\:GNDA \443\:GNDA \634\:GNDA \1251\:GNDA) vert10 m=1.0
    Q3\(5\) (\1251\:GNDA \431\:GNDA \627\:GNDA \1251\:GNDA) vert10 m=1.0
    Q3\(4\) (\1251\:GNDA \419\:GNDA \620\:GNDA \1251\:GNDA) vert10 m=1.0
    Q3\(3\) (\1251\:GNDA \401\:GNDA \732\:GNDA \1251\:GNDA) vert10 m=1.0
    Q3\(2\) (\1251\:GNDA \391\:GNDA \610\:GNDA \1251\:GNDA) vert10 m=1.0
    Q3\(1\) (\1251\:GNDA \379\:GNDA \603\:GNDA \1251\:GNDA) vert10 m=1.0
    Q3\(0\) (\1251\:GNDA \366\:GNDA \597\:GNDA \1251\:GNDA) vert10 m=1.0
    C0\|C0 (\7\:Vo1 \6\:BG_REF) cpoly area=3.46612e-09 perimeter=0.0002355 \
        m=1 mmw=0
    avD43_1 (\1251\:GNDA \550\:GNDA) nwd area=4.0922e-09 \
        perimeter=0.0002559 m=1
    MP9\(3\) (\31\:S2 \5\:S2 \34\:S2 \44\:S2) modp w=1e-05 l=3.5e-07 \
        as=8.5e-12 ad=8.5e-12 ps=1.17e-05 pd=1.17e-05 nrd=0.06 nrs=0.06 \
        ng=1
    MP5\(1\) (\11\:D2 \13\:BG_REF \27\:S2 \44\:S2) modp w=1e-05 l=3.5e-07 \
        as=8.5e-12 ad=8.5e-12 ps=1.17e-05 pd=1.17e-05 nrd=0.06 nrs=0.06 \
        ng=1
    MP6\(1\) (\3\:Vs vv \23\:S2 \44\:S2) modp w=1e-05 l=3.5e-07 as=8.5e-12 \
        ad=8.5e-12 ps=1.17e-05 pd=1.17e-05 nrd=0.06 nrs=0.06 ng=1
    MP9\(2\) (\15\:S2 S2 \18\:S2 \44\:S2) modp w=1e-05 l=3.5e-07 \
        as=8.5e-12 ad=8.5e-12 ps=1.17e-05 pd=1.17e-05 nrd=0.06 nrs=0.06 \
        ng=1
    MP9\(1\) (\35\:S2 \7\:S2 \38\:S2 \44\:S2) modp w=1e-05 l=3.5e-07 \
        as=8.5e-12 ad=8.5e-12 ps=1.17e-05 pd=1.17e-05 nrd=0.06 nrs=0.06 \
        ng=1
    MP6\(0\) (\7\:Vs \3\:vv \29\:S2 \44\:S2) modp w=1e-05 l=3.5e-07 \
        as=8.5e-12 ad=8.5e-12 ps=1.17e-05 pd=1.17e-05 nrd=0.06 nrs=0.06 \
        ng=1
    MP5\(0\) (\7\:D2 \11\:BG_REF \25\:S2 \44\:S2) modp w=1e-05 l=3.5e-07 \
        as=8.5e-12 ad=8.5e-12 ps=1.17e-05 pd=1.17e-05 nrd=0.06 nrs=0.06 \
        ng=1
    MP9\(0\) (\19\:S2 \3\:S2 \22\:S2 \44\:S2) modp w=1e-05 l=3.5e-07 \
        as=8.5e-12 ad=8.5e-12 ps=1.17e-05 pd=1.17e-05 nrd=0.06 nrs=0.06 \
        ng=1
    MN2_1__rcx (\728\:GNDA Vo1 Vo2 \1251\:GNDA) modn w=5e-06 l=1e-06 \
        as=2.5e-12 ad=4.25e-12 ps=1e-06 pd=6.7e-06 nrd=0.06 nrs=0.06 ng=1
    MN2 (Vo2 \3\:Vo1 \768\:GNDA \1251\:GNDA) modn w=5e-06 l=1e-06 \
        as=4.25e-12 ad=2.5e-12 ps=6.7e-06 pd=1e-06 nrd=0.06 nrs=0.06 ng=1
    MN8 (\13\:vv \5\:vv \760\:GNDA \1251\:GNDA) modn w=5e-07 l=1e-05 \
        as=5.9e-13 ad=5.9e-13 ps=2.7e-06 pd=2.7e-06 nrd=0.06 nrs=0.06 ng=1
    MN7 (\84\:BG_REF \2\:Vs \3\:Vo2 \1251\:GNDA) modn w=5e-06 l=1e-05 \
        as=4.25e-12 ad=4.25e-12 ps=6.7e-06 pd=6.7e-06 nrd=0.06 nrs=0.06 \
        ng=1
    MN10\(1\) (\18\:BIAS \1\:BIAS \20\:BIAS \1251\:GNDA) modn w=5e-06 \
        l=1e-05 as=4.25e-12 ad=4.25e-12 ps=6.7e-06 pd=6.7e-06 nrd=0.06 \
        nrs=0.06 ng=1
    MN4\(1\) (\221\:Vm1 \2\:BIAS \670\:GNDA \1251\:GNDA) modn w=5e-06 \
        l=1e-05 as=4.25e-12 ad=4.25e-12 ps=6.7e-06 pd=6.7e-06 nrd=0.06 \
        nrs=0.06 ng=1
    MN3\(1\) (\9\:BIAS \3\:BIAS \671\:GNDA \1251\:GNDA) modn w=5e-06 \
        l=1e-05 as=4.25e-12 ad=4.25e-12 ps=6.7e-06 pd=6.7e-06 nrd=0.06 \
        nrs=0.06 ng=1
    MN4\(0\) (\223\:Vm1 \4\:BIAS \672\:GNDA \1251\:GNDA) modn w=5e-06 \
        l=1e-05 as=4.25e-12 ad=4.25e-12 ps=6.7e-06 pd=6.7e-06 nrd=0.06 \
        nrs=0.06 ng=1
    MN3\(0\) (\11\:BIAS \5\:BIAS \669\:GNDA \1251\:GNDA) modn w=5e-06 \
        l=1e-05 as=4.25e-12 ad=4.25e-12 ps=6.7e-06 pd=6.7e-06 nrd=0.06 \
        nrs=0.06 ng=1
    MN10\(0\) (\25\:BIAS \6\:BIAS \27\:BIAS \1251\:GNDA) modn w=5e-06 \
        l=1e-05 as=4.25e-12 ad=4.25e-12 ps=6.7e-06 pd=6.7e-06 nrd=0.06 \
        nrs=0.06 ng=1
    MN11\(1\) (\11\:Vs D2 \146\:GNDA \1251\:GNDA) modn w=1e-05 l=1e-05 \
        as=8.5e-12 ad=8.5e-12 ps=1.17e-05 pd=1.17e-05 nrd=0.06 nrs=0.06 \
        ng=1
    MN12\(1\) (\9\:D2 \3\:D2 \137\:GNDA \1251\:GNDA) modn w=1e-05 l=1e-05 \
        as=8.5e-12 ad=8.5e-12 ps=1.17e-05 pd=1.17e-05 nrd=0.06 nrs=0.06 \
        ng=1
    MN12\(0\) (\17\:D2 \4\:D2 \147\:GNDA \1251\:GNDA) modn w=1e-05 l=1e-05 \
        as=8.5e-12 ad=8.5e-12 ps=1.17e-05 pd=1.17e-05 nrd=0.06 nrs=0.06 \
        ng=1
    MN11\(0\) (\5\:Vs \6\:D2 \139\:GNDA \1251\:GNDA) modn w=1e-05 l=1e-05 \
        as=8.5e-12 ad=8.5e-12 ps=1.17e-05 pd=1.17e-05 nrd=0.06 nrs=0.06 \
        ng=1
    MN1\(1\) (\13\:D1 \4\:D1 \125\:GNDA \1251\:GNDA) modn w=1e-05 l=1e-05 \
        as=8.5e-12 ad=8.5e-12 ps=1.17e-05 pd=1.17e-05 nrd=0.06 nrs=0.06 \
        ng=1
    MN0\(1\) (\16\:Vo1 D1 \117\:GNDA \1251\:GNDA) modn w=1e-05 l=1e-05 \
        as=8.5e-12 ad=8.5e-12 ps=1.17e-05 pd=1.17e-05 nrd=0.06 nrs=0.06 \
        ng=1
    MN0\(0\) (\18\:Vo1 \6\:D1 \127\:GNDA \1251\:GNDA) modn w=1e-05 l=1e-05 \
        as=8.5e-12 ad=8.5e-12 ps=1.17e-05 pd=1.17e-05 nrd=0.06 nrs=0.06 \
        ng=1
    MN1\(0\) (\9\:D1 \3\:D1 \119\:GNDA \1251\:GNDA) modn w=1e-05 l=1e-05 \
        as=8.5e-12 ad=8.5e-12 ps=1.17e-05 pd=1.17e-05 nrd=0.06 nrs=0.06 \
        ng=1
    MP10\(3\) (\131\:S \6\:S \134\:S \102\:S) modp w=2.5e-05 l=4e-06 \
        as=2.125e-11 ad=2.125e-11 ps=2.67e-05 pd=2.67e-05 nrd=0.06 \
        nrs=0.06 ng=1
    MP0\(7\) (\36\:D1 \15\:Y \123\:S \102\:S) modp w=2.5e-05 l=4e-06 \
        as=2.125e-11 ad=2.125e-11 ps=2.67e-05 pd=2.67e-05 nrd=0.06 \
        nrs=0.06 ng=1
    MP1\(7\) (\38\:Vo1 \13\:X \115\:S \102\:S) modp w=2.5e-05 l=4e-06 \
        as=2.125e-11 ad=2.125e-11 ps=2.67e-05 pd=2.67e-05 nrd=0.06 \
        nrs=0.06 ng=1
    MP0\(6\) (\30\:D1 \11\:Y \107\:S \102\:S) modp w=2.5e-05 l=4e-06 \
        as=2.125e-11 ad=2.125e-11 ps=2.67e-05 pd=2.67e-05 nrd=0.06 \
        nrs=0.06 ng=1
    MP1\(6\) (\32\:Vo1 \9\:X \99\:S \102\:S) modp w=2.5e-05 l=4e-06 \
        as=2.125e-11 ad=2.125e-11 ps=2.67e-05 pd=2.67e-05 nrd=0.06 \
        nrs=0.06 ng=1
    MP0\(5\) (\24\:D1 \7\:Y \91\:S \102\:S) modp w=2.5e-05 l=4e-06 \
        as=2.125e-11 ad=2.125e-11 ps=2.67e-05 pd=2.67e-05 nrd=0.06 \
        nrs=0.06 ng=1
    MP1\(5\) (\26\:Vo1 \5\:X \83\:S \102\:S) modp w=2.5e-05 l=4e-06 \
        as=2.125e-11 ad=2.125e-11 ps=2.67e-05 pd=2.67e-05 nrd=0.06 \
        nrs=0.06 ng=1
    MP0\(4\) (\18\:D1 \3\:Y \75\:S \102\:S) modp w=2.5e-05 l=4e-06 \
        as=2.125e-11 ad=2.125e-11 ps=2.67e-05 pd=2.67e-05 nrd=0.06 \
        nrs=0.06 ng=1
    MP1\(4\) (\20\:Vo1 X \67\:S \102\:S) modp w=2.5e-05 l=4e-06 \
        as=2.125e-11 ad=2.125e-11 ps=2.67e-05 pd=2.67e-05 nrd=0.06 \
        nrs=0.06 ng=1
    MP10\(2\) (\53\:S \2\:S \56\:S \102\:S) modp w=2.5e-05 l=4e-06 \
        as=2.125e-11 ad=2.125e-11 ps=2.67e-05 pd=2.67e-05 nrd=0.06 \
        nrs=0.06 ng=1
    MP10\(1\) (\138\:S \8\:S \141\:S \102\:S) modp w=2.5e-05 l=4e-06 \
        as=2.125e-11 ad=2.125e-11 ps=2.67e-05 pd=2.67e-05 nrd=0.06 \
        nrs=0.06 ng=1
    MP1\(3\) (\41\:Vo1 \15\:X \127\:S \102\:S) modp w=2.5e-05 l=4e-06 \
        as=2.125e-11 ad=2.125e-11 ps=2.67e-05 pd=2.67e-05 nrd=0.06 \
        nrs=0.06 ng=1
    MP0\(3\) (\33\:D1 \13\:Y \119\:S \102\:S) modp w=2.5e-05 l=4e-06 \
        as=2.125e-11 ad=2.125e-11 ps=2.67e-05 pd=2.67e-05 nrd=0.06 \
        nrs=0.06 ng=1
    MP1\(2\) (\35\:Vo1 \11\:X \111\:S \102\:S) modp w=2.5e-05 l=4e-06 \
        as=2.125e-11 ad=2.125e-11 ps=2.67e-05 pd=2.67e-05 nrd=0.06 \
        nrs=0.06 ng=1
    MP0\(2\) (\27\:D1 \9\:Y \103\:S \102\:S) modp w=2.5e-05 l=4e-06 \
        as=2.125e-11 ad=2.125e-11 ps=2.67e-05 pd=2.67e-05 nrd=0.06 \
        nrs=0.06 ng=1
    MP1\(1\) (\29\:Vo1 \7\:X \95\:S \102\:S) modp w=2.5e-05 l=4e-06 \
        as=2.125e-11 ad=2.125e-11 ps=2.67e-05 pd=2.67e-05 nrd=0.06 \
        nrs=0.06 ng=1
    MP0\(1\) (\21\:D1 \5\:Y \87\:S \102\:S) modp w=2.5e-05 l=4e-06 \
        as=2.125e-11 ad=2.125e-11 ps=2.67e-05 pd=2.67e-05 nrd=0.06 \
        nrs=0.06 ng=1
    MP1\(0\) (\23\:Vo1 \3\:X \79\:S \102\:S) modp w=2.5e-05 l=4e-06 \
        as=2.125e-11 ad=2.125e-11 ps=2.67e-05 pd=2.67e-05 nrd=0.06 \
        nrs=0.06 ng=1
    MP0\(0\) (\15\:D1 Y \71\:S \102\:S) modp w=2.5e-05 l=4e-06 \
        as=2.125e-11 ad=2.125e-11 ps=2.67e-05 pd=2.67e-05 nrd=0.06 \
        nrs=0.06 ng=1
    MP10\(0\) (\60\:S \4\:S \63\:S \102\:S) modp w=2.5e-05 l=4e-06 \
        as=2.125e-11 ad=2.125e-11 ps=2.67e-05 pd=2.67e-05 nrd=0.06 \
        nrs=0.06 ng=1
    MP12\(33\) (\500\:VDDA \54\:VDDA \467\:VDDA \279\:VDDA) modp w=5e-06 \
        l=1e-05 as=4.25e-12 ad=4.25e-12 ps=6.7e-06 pd=6.7e-06 nrd=0.06 \
        nrs=0.06 ng=1
    MP12\(32\) (\469\:VDDA \50\:VDDA \412\:VDDA \279\:VDDA) modp w=5e-06 \
        l=1e-05 as=4.25e-12 ad=4.25e-12 ps=6.7e-06 pd=6.7e-06 nrd=0.06 \
        nrs=0.06 ng=1
    MP12\(31\) (\414\:VDDA \46\:VDDA \377\:VDDA \279\:VDDA) modp w=5e-06 \
        l=1e-05 as=4.25e-12 ad=4.25e-12 ps=6.7e-06 pd=6.7e-06 nrd=0.06 \
        nrs=0.06 ng=1
    MP12\(30\) (\379\:VDDA \42\:VDDA \342\:VDDA \279\:VDDA) modp w=5e-06 \
        l=1e-05 as=4.25e-12 ad=4.25e-12 ps=6.7e-06 pd=6.7e-06 nrd=0.06 \
        nrs=0.06 ng=1
    MP12\(29\) (\344\:VDDA \38\:VDDA \307\:VDDA \279\:VDDA) modp w=5e-06 \
        l=1e-05 as=4.25e-12 ad=4.25e-12 ps=6.7e-06 pd=6.7e-06 nrd=0.06 \
        nrs=0.06 ng=1
    MP12\(28\) (\309\:VDDA \34\:VDDA \272\:VDDA \279\:VDDA) modp w=5e-06 \
        l=1e-05 as=4.25e-12 ad=4.25e-12 ps=6.7e-06 pd=6.7e-06 nrd=0.06 \
        nrs=0.06 ng=1
    MP12\(27\) (\274\:VDDA \30\:VDDA \237\:VDDA \279\:VDDA) modp w=5e-06 \
        l=1e-05 as=4.25e-12 ad=4.25e-12 ps=6.7e-06 pd=6.7e-06 nrd=0.06 \
        nrs=0.06 ng=1
    MP12\(26\) (\239\:VDDA \26\:VDDA \202\:VDDA \279\:VDDA) modp w=5e-06 \
        l=1e-05 as=4.25e-12 ad=4.25e-12 ps=6.7e-06 pd=6.7e-06 nrd=0.06 \
        nrs=0.06 ng=1
    MP12\(25\) (\204\:VDDA \22\:VDDA \167\:VDDA \279\:VDDA) modp w=5e-06 \
        l=1e-05 as=4.25e-12 ad=4.25e-12 ps=6.7e-06 pd=6.7e-06 nrd=0.06 \
        nrs=0.06 ng=1
    MP12\(24\) (\169\:VDDA \18\:VDDA \131\:VDDA \279\:VDDA) modp w=5e-06 \
        l=1e-05 as=4.25e-12 ad=4.25e-12 ps=6.7e-06 pd=6.7e-06 nrd=0.06 \
        nrs=0.06 ng=1
    MP12\(23\) (\134\:VDDA \2\:VDDA \85\:VDDA \279\:VDDA) modp w=5e-06 \
        l=1e-05 as=4.25e-12 ad=4.25e-12 ps=6.7e-06 pd=6.7e-06 nrd=0.06 \
        nrs=0.06 ng=1
    MP12\(22\) (\502\:VDDA \56\:VDDA \473\:VDDA \279\:VDDA) modp w=5e-06 \
        l=1e-05 as=4.25e-12 ad=4.25e-12 ps=6.7e-06 pd=6.7e-06 nrd=0.06 \
        nrs=0.06 ng=1
    MP4\(29\) (\72\:BG_REF \98\:Vm1 \453\:VDDA \279\:VDDA) modp w=5e-06 \
        l=1e-05 as=4.25e-12 ad=4.25e-12 ps=6.7e-06 pd=6.7e-06 nrd=0.06 \
        nrs=0.06 ng=1
    MP4\(28\) (\64\:BG_REF \86\:Vm1 \398\:VDDA \279\:VDDA) modp w=5e-06 \
        l=1e-05 as=4.25e-12 ad=4.25e-12 ps=6.7e-06 pd=6.7e-06 nrd=0.06 \
        nrs=0.06 ng=1
    MP4\(27\) (\60\:BG_REF \74\:Vm1 \363\:VDDA \279\:VDDA) modp w=5e-06 \
        l=1e-05 as=4.25e-12 ad=4.25e-12 ps=6.7e-06 pd=6.7e-06 nrd=0.06 \
        nrs=0.06 ng=1
    MP4\(26\) (\56\:BG_REF \62\:Vm1 \328\:VDDA \279\:VDDA) modp w=5e-06 \
        l=1e-05 as=4.25e-12 ad=4.25e-12 ps=6.7e-06 pd=6.7e-06 nrd=0.06 \
        nrs=0.06 ng=1
    MP4\(25\) (\52\:BG_REF \50\:Vm1 \293\:VDDA \279\:VDDA) modp w=5e-06 \
        l=1e-05 as=4.25e-12 ad=4.25e-12 ps=6.7e-06 pd=6.7e-06 nrd=0.06 \
        nrs=0.06 ng=1
    MP4\(24\) (\48\:BG_REF \38\:Vm1 \258\:VDDA \279\:VDDA) modp w=5e-06 \
        l=1e-05 as=4.25e-12 ad=4.25e-12 ps=6.7e-06 pd=6.7e-06 nrd=0.06 \
        nrs=0.06 ng=1
    MP4\(23\) (\44\:BG_REF \26\:Vm1 \223\:VDDA \279\:VDDA) modp w=5e-06 \
        l=1e-05 as=4.25e-12 ad=4.25e-12 ps=6.7e-06 pd=6.7e-06 nrd=0.06 \
        nrs=0.06 ng=1
    MP4\(22\) (\36\:BG_REF \14\:Vm1 \188\:VDDA \279\:VDDA) modp w=5e-06 \
        l=1e-05 as=4.25e-12 ad=4.25e-12 ps=6.7e-06 pd=6.7e-06 nrd=0.06 \
        nrs=0.06 ng=1
    MP4\(21\) (\24\:BG_REF \2\:Vm1 \153\:VDDA \279\:VDDA) modp w=5e-06 \
        l=1e-05 as=4.25e-12 ad=4.25e-12 ps=6.7e-06 pd=6.7e-06 nrd=0.06 \
        nrs=0.06 ng=1
    MP12\(21\) (\117\:VDDA \4\:VDDA \87\:VDDA \279\:VDDA) modp w=5e-06 \
        l=1e-05 as=4.25e-12 ad=4.25e-12 ps=6.7e-06 pd=6.7e-06 nrd=0.06 \
        nrs=0.06 ng=1
    MP12\(20\) (\504\:VDDA \58\:VDDA \475\:VDDA \279\:VDDA) modp w=5e-06 \
        l=1e-05 as=4.25e-12 ad=4.25e-12 ps=6.7e-06 pd=6.7e-06 nrd=0.06 \
        nrs=0.06 ng=1
    MP4\(20\) (\74\:BG_REF \100\:Vm1 \455\:VDDA \279\:VDDA) modp w=5e-06 \
        l=1e-05 as=4.25e-12 ad=4.25e-12 ps=6.7e-06 pd=6.7e-06 nrd=0.06 \
        nrs=0.06 ng=1
    MP3\(19\) (\46\:S \88\:Vm1 \400\:VDDA \279\:VDDA) modp w=5e-06 l=1e-05 \
        as=4.25e-12 ad=4.25e-12 ps=6.7e-06 pd=6.7e-06 nrd=0.06 nrs=0.06 \
        ng=1
    MP3\(18\) (\38\:S \76\:Vm1 \365\:VDDA \279\:VDDA) modp w=5e-06 l=1e-05 \
        as=4.25e-12 ad=4.25e-12 ps=6.7e-06 pd=6.7e-06 nrd=0.06 nrs=0.06 \
        ng=1
    MP3\(17\) (\32\:S \64\:Vm1 \330\:VDDA \279\:VDDA) modp w=5e-06 l=1e-05 \
        as=4.25e-12 ad=4.25e-12 ps=6.7e-06 pd=6.7e-06 nrd=0.06 nrs=0.06 \
        ng=1
    MP3\(16\) (\28\:S \52\:Vm1 \295\:VDDA \279\:VDDA) modp w=5e-06 l=1e-05 \
        as=4.25e-12 ad=4.25e-12 ps=6.7e-06 pd=6.7e-06 nrd=0.06 nrs=0.06 \
        ng=1
    MP3\(15\) (\22\:S \40\:Vm1 \260\:VDDA \279\:VDDA) modp w=5e-06 l=1e-05 \
        as=4.25e-12 ad=4.25e-12 ps=6.7e-06 pd=6.7e-06 nrd=0.06 nrs=0.06 \
        ng=1
    MP3\(14\) (\14\:S \28\:Vm1 \225\:VDDA \279\:VDDA) modp w=5e-06 l=1e-05 \
        as=4.25e-12 ad=4.25e-12 ps=6.7e-06 pd=6.7e-06 nrd=0.06 nrs=0.06 \
        ng=1
    MP3\(13\) (\10\:S \16\:Vm1 \190\:VDDA \279\:VDDA) modp w=5e-06 l=1e-05 \
        as=4.25e-12 ad=4.25e-12 ps=6.7e-06 pd=6.7e-06 nrd=0.06 nrs=0.06 \
        ng=1
    MP4\(19\) (\26\:BG_REF \4\:Vm1 \155\:VDDA \279\:VDDA) modp w=5e-06 \
        l=1e-05 as=4.25e-12 ad=4.25e-12 ps=6.7e-06 pd=6.7e-06 nrd=0.06 \
        nrs=0.06 ng=1
    MP12\(19\) (\119\:VDDA \6\:VDDA \89\:VDDA \279\:VDDA) modp w=5e-06 \
        l=1e-05 as=4.25e-12 ad=4.25e-12 ps=6.7e-06 pd=6.7e-06 nrd=0.06 \
        nrs=0.06 ng=1
    MP12\(18\) (\506\:VDDA \60\:VDDA \477\:VDDA \279\:VDDA) modp w=5e-06 \
        l=1e-05 as=4.25e-12 ad=4.25e-12 ps=6.7e-06 pd=6.7e-06 nrd=0.06 \
        nrs=0.06 ng=1
    MP4\(18\) (\76\:BG_REF \102\:Vm1 \457\:VDDA \279\:VDDA) modp w=5e-06 \
        l=1e-05 as=4.25e-12 ad=4.25e-12 ps=6.7e-06 pd=6.7e-06 nrd=0.06 \
        nrs=0.06 ng=1
    MP4\(17\) (\66\:BG_REF \90\:Vm1 \402\:VDDA \279\:VDDA) modp w=5e-06 \
        l=1e-05 as=4.25e-12 ad=4.25e-12 ps=6.7e-06 pd=6.7e-06 nrd=0.06 \
        nrs=0.06 ng=1
    MP3\(12\) (\40\:S \78\:Vm1 \367\:VDDA \279\:VDDA) modp w=5e-06 l=1e-05 \
        as=4.25e-12 ad=4.25e-12 ps=6.7e-06 pd=6.7e-06 nrd=0.06 nrs=0.06 \
        ng=1
    MP2\(1\) (\171\:Vm1 \66\:Vm1 \332\:VDDA \279\:VDDA) modp w=5e-06 \
        l=1e-05 as=4.25e-12 ad=4.25e-12 ps=6.7e-06 pd=6.7e-06 nrd=0.06 \
        nrs=0.06 ng=1
    MP7 (\10\:S2 \54\:Vm1 \297\:VDDA \279\:VDDA) modp w=5e-06 l=1e-05 \
        as=4.25e-12 ad=4.25e-12 ps=6.7e-06 pd=6.7e-06 nrd=0.06 nrs=0.06 \
        ng=1
    MP3\(11\) (\24\:S \42\:Vm1 \262\:VDDA \279\:VDDA) modp w=5e-06 l=1e-05 \
        as=4.25e-12 ad=4.25e-12 ps=6.7e-06 pd=6.7e-06 nrd=0.06 nrs=0.06 \
        ng=1
    MP3\(10\) (\16\:S \30\:Vm1 \227\:VDDA \279\:VDDA) modp w=5e-06 l=1e-05 \
        as=4.25e-12 ad=4.25e-12 ps=6.7e-06 pd=6.7e-06 nrd=0.06 nrs=0.06 \
        ng=1
    MP4\(16\) (\38\:BG_REF \18\:Vm1 \192\:VDDA \279\:VDDA) modp w=5e-06 \
        l=1e-05 as=4.25e-12 ad=4.25e-12 ps=6.7e-06 pd=6.7e-06 nrd=0.06 \
        nrs=0.06 ng=1
    MP4\(15\) (\28\:BG_REF \6\:Vm1 \157\:VDDA \279\:VDDA) modp w=5e-06 \
        l=1e-05 as=4.25e-12 ad=4.25e-12 ps=6.7e-06 pd=6.7e-06 nrd=0.06 \
        nrs=0.06 ng=1
    MP12\(17\) (\121\:VDDA \8\:VDDA \91\:VDDA \279\:VDDA) modp w=5e-06 \
        l=1e-05 as=4.25e-12 ad=4.25e-12 ps=6.7e-06 pd=6.7e-06 nrd=0.06 \
        nrs=0.06 ng=1
    MP12\(16\) (\508\:VDDA \62\:VDDA \479\:VDDA \279\:VDDA) modp w=5e-06 \
        l=1e-05 as=4.25e-12 ad=4.25e-12 ps=6.7e-06 pd=6.7e-06 nrd=0.06 \
        nrs=0.06 ng=1
    MP4\(14\) (\78\:BG_REF \104\:Vm1 \459\:VDDA \279\:VDDA) modp w=5e-06 \
        l=1e-05 as=4.25e-12 ad=4.25e-12 ps=6.7e-06 pd=6.7e-06 nrd=0.06 \
        nrs=0.06 ng=1
    MP4\(13\) (\68\:BG_REF \92\:Vm1 \404\:VDDA \279\:VDDA) modp w=5e-06 \
        l=1e-05 as=4.25e-12 ad=4.25e-12 ps=6.7e-06 pd=6.7e-06 nrd=0.06 \
        nrs=0.06 ng=1
    MP3\(9\) (\42\:S \80\:Vm1 \369\:VDDA \279\:VDDA) modp w=5e-06 l=1e-05 \
        as=4.25e-12 ad=4.25e-12 ps=6.7e-06 pd=6.7e-06 nrd=0.06 nrs=0.06 \
        ng=1
    MP3\(8\) (\34\:S \68\:Vm1 \334\:VDDA \279\:VDDA) modp w=5e-06 l=1e-05 \
        as=4.25e-12 ad=4.25e-12 ps=6.7e-06 pd=6.7e-06 nrd=0.06 nrs=0.06 \
        ng=1
    MP8 (\8\:vv \56\:Vm1 \299\:VDDA \279\:VDDA) modp w=5e-06 l=1e-05 \
        as=4.25e-12 ad=4.25e-12 ps=6.7e-06 pd=6.7e-06 nrd=0.06 nrs=0.06 \
        ng=1
    MP2\(0\) (\145\:Vm1 \44\:Vm1 \264\:VDDA \279\:VDDA) modp w=5e-06 \
        l=1e-05 as=4.25e-12 ad=4.25e-12 ps=6.7e-06 pd=6.7e-06 nrd=0.06 \
        nrs=0.06 ng=1
    MP3\(7\) (\18\:S \32\:Vm1 \229\:VDDA \279\:VDDA) modp w=5e-06 l=1e-05 \
        as=4.25e-12 ad=4.25e-12 ps=6.7e-06 pd=6.7e-06 nrd=0.06 nrs=0.06 \
        ng=1
    MP4\(12\) (\40\:BG_REF \20\:Vm1 \194\:VDDA \279\:VDDA) modp w=5e-06 \
        l=1e-05 as=4.25e-12 ad=4.25e-12 ps=6.7e-06 pd=6.7e-06 nrd=0.06 \
        nrs=0.06 ng=1
    MP4\(11\) (\30\:BG_REF \8\:Vm1 \159\:VDDA \279\:VDDA) modp w=5e-06 \
        l=1e-05 as=4.25e-12 ad=4.25e-12 ps=6.7e-06 pd=6.7e-06 nrd=0.06 \
        nrs=0.06 ng=1
    MP12\(15\) (\123\:VDDA \10\:VDDA \93\:VDDA \279\:VDDA) modp w=5e-06 \
        l=1e-05 as=4.25e-12 ad=4.25e-12 ps=6.7e-06 pd=6.7e-06 nrd=0.06 \
        nrs=0.06 ng=1
    MP12\(14\) (\510\:VDDA \64\:VDDA \481\:VDDA \279\:VDDA) modp w=5e-06 \
        l=1e-05 as=4.25e-12 ad=4.25e-12 ps=6.7e-06 pd=6.7e-06 nrd=0.06 \
        nrs=0.06 ng=1
    MP4\(10\) (\80\:BG_REF \106\:Vm1 \461\:VDDA \279\:VDDA) modp w=5e-06 \
        l=1e-05 as=4.25e-12 ad=4.25e-12 ps=6.7e-06 pd=6.7e-06 nrd=0.06 \
        nrs=0.06 ng=1
    MP3\(6\) (\48\:S \94\:Vm1 \406\:VDDA \279\:VDDA) modp w=5e-06 l=1e-05 \
        as=4.25e-12 ad=4.25e-12 ps=6.7e-06 pd=6.7e-06 nrd=0.06 nrs=0.06 \
        ng=1
    MP3\(5\) (\44\:S \82\:Vm1 \371\:VDDA \279\:VDDA) modp w=5e-06 l=1e-05 \
        as=4.25e-12 ad=4.25e-12 ps=6.7e-06 pd=6.7e-06 nrd=0.06 nrs=0.06 \
        ng=1
    MP3\(4\) (\36\:S \70\:Vm1 \336\:VDDA \279\:VDDA) modp w=5e-06 l=1e-05 \
        as=4.25e-12 ad=4.25e-12 ps=6.7e-06 pd=6.7e-06 nrd=0.06 nrs=0.06 \
        ng=1
    MP3\(3\) (\30\:S \58\:Vm1 \301\:VDDA \279\:VDDA) modp w=5e-06 l=1e-05 \
        as=4.25e-12 ad=4.25e-12 ps=6.7e-06 pd=6.7e-06 nrd=0.06 nrs=0.06 \
        ng=1
    MP3\(2\) (\26\:S \46\:Vm1 \266\:VDDA \279\:VDDA) modp w=5e-06 l=1e-05 \
        as=4.25e-12 ad=4.25e-12 ps=6.7e-06 pd=6.7e-06 nrd=0.06 nrs=0.06 \
        ng=1
    MP3\(1\) (\20\:S \34\:Vm1 \231\:VDDA \279\:VDDA) modp w=5e-06 l=1e-05 \
        as=4.25e-12 ad=4.25e-12 ps=6.7e-06 pd=6.7e-06 nrd=0.06 nrs=0.06 \
        ng=1
    MP3\(0\) (\12\:S \22\:Vm1 \196\:VDDA \279\:VDDA) modp w=5e-06 l=1e-05 \
        as=4.25e-12 ad=4.25e-12 ps=6.7e-06 pd=6.7e-06 nrd=0.06 nrs=0.06 \
        ng=1
    MP4\(9\) (\32\:BG_REF \10\:Vm1 \161\:VDDA \279\:VDDA) modp w=5e-06 \
        l=1e-05 as=4.25e-12 ad=4.25e-12 ps=6.7e-06 pd=6.7e-06 nrd=0.06 \
        nrs=0.06 ng=1
    MP12\(13\) (\125\:VDDA \12\:VDDA \95\:VDDA \279\:VDDA) modp w=5e-06 \
        l=1e-05 as=4.25e-12 ad=4.25e-12 ps=6.7e-06 pd=6.7e-06 nrd=0.06 \
        nrs=0.06 ng=1
    MP12\(12\) (\512\:VDDA \66\:VDDA \483\:VDDA \279\:VDDA) modp w=5e-06 \
        l=1e-05 as=4.25e-12 ad=4.25e-12 ps=6.7e-06 pd=6.7e-06 nrd=0.06 \
        nrs=0.06 ng=1
    MP4\(8\) (\82\:BG_REF \108\:Vm1 \463\:VDDA \279\:VDDA) modp w=5e-06 \
        l=1e-05 as=4.25e-12 ad=4.25e-12 ps=6.7e-06 pd=6.7e-06 nrd=0.06 \
        nrs=0.06 ng=1
    MP4\(7\) (\70\:BG_REF \96\:Vm1 \408\:VDDA \279\:VDDA) modp w=5e-06 \
        l=1e-05 as=4.25e-12 ad=4.25e-12 ps=6.7e-06 pd=6.7e-06 nrd=0.06 \
        nrs=0.06 ng=1
    MP4\(6\) (\62\:BG_REF \84\:Vm1 \373\:VDDA \279\:VDDA) modp w=5e-06 \
        l=1e-05 as=4.25e-12 ad=4.25e-12 ps=6.7e-06 pd=6.7e-06 nrd=0.06 \
        nrs=0.06 ng=1
    MP4\(5\) (\58\:BG_REF \72\:Vm1 \338\:VDDA \279\:VDDA) modp w=5e-06 \
        l=1e-05 as=4.25e-12 ad=4.25e-12 ps=6.7e-06 pd=6.7e-06 nrd=0.06 \
        nrs=0.06 ng=1
    MP4\(4\) (\54\:BG_REF \60\:Vm1 \303\:VDDA \279\:VDDA) modp w=5e-06 \
        l=1e-05 as=4.25e-12 ad=4.25e-12 ps=6.7e-06 pd=6.7e-06 nrd=0.06 \
        nrs=0.06 ng=1
    MP4\(3\) (\50\:BG_REF \48\:Vm1 \268\:VDDA \279\:VDDA) modp w=5e-06 \
        l=1e-05 as=4.25e-12 ad=4.25e-12 ps=6.7e-06 pd=6.7e-06 nrd=0.06 \
        nrs=0.06 ng=1
    MP4\(2\) (\46\:BG_REF \36\:Vm1 \233\:VDDA \279\:VDDA) modp w=5e-06 \
        l=1e-05 as=4.25e-12 ad=4.25e-12 ps=6.7e-06 pd=6.7e-06 nrd=0.06 \
        nrs=0.06 ng=1
    MP4\(1\) (\42\:BG_REF \24\:Vm1 \198\:VDDA \279\:VDDA) modp w=5e-06 \
        l=1e-05 as=4.25e-12 ad=4.25e-12 ps=6.7e-06 pd=6.7e-06 nrd=0.06 \
        nrs=0.06 ng=1
    MP4\(0\) (\34\:BG_REF \12\:Vm1 \163\:VDDA \279\:VDDA) modp w=5e-06 \
        l=1e-05 as=4.25e-12 ad=4.25e-12 ps=6.7e-06 pd=6.7e-06 nrd=0.06 \
        nrs=0.06 ng=1
    MP12\(11\) (\127\:VDDA \14\:VDDA \97\:VDDA \279\:VDDA) modp w=5e-06 \
        l=1e-05 as=4.25e-12 ad=4.25e-12 ps=6.7e-06 pd=6.7e-06 nrd=0.06 \
        nrs=0.06 ng=1
    MP12\(10\) (\514\:VDDA \68\:VDDA \470\:VDDA \279\:VDDA) modp w=5e-06 \
        l=1e-05 as=4.25e-12 ad=4.25e-12 ps=6.7e-06 pd=6.7e-06 nrd=0.06 \
        nrs=0.06 ng=1
    MP12\(9\) (\465\:VDDA \52\:VDDA \415\:VDDA \279\:VDDA) modp w=5e-06 \
        l=1e-05 as=4.25e-12 ad=4.25e-12 ps=6.7e-06 pd=6.7e-06 nrd=0.06 \
        nrs=0.06 ng=1
    MP12\(8\) (\410\:VDDA \48\:VDDA \380\:VDDA \279\:VDDA) modp w=5e-06 \
        l=1e-05 as=4.25e-12 ad=4.25e-12 ps=6.7e-06 pd=6.7e-06 nrd=0.06 \
        nrs=0.06 ng=1
    MP12\(7\) (\375\:VDDA \44\:VDDA \345\:VDDA \279\:VDDA) modp w=5e-06 \
        l=1e-05 as=4.25e-12 ad=4.25e-12 ps=6.7e-06 pd=6.7e-06 nrd=0.06 \
        nrs=0.06 ng=1
    MP12\(6\) (\340\:VDDA \40\:VDDA \310\:VDDA \279\:VDDA) modp w=5e-06 \
        l=1e-05 as=4.25e-12 ad=4.25e-12 ps=6.7e-06 pd=6.7e-06 nrd=0.06 \
        nrs=0.06 ng=1
    MP12\(5\) (\305\:VDDA \36\:VDDA \275\:VDDA \279\:VDDA) modp w=5e-06 \
        l=1e-05 as=4.25e-12 ad=4.25e-12 ps=6.7e-06 pd=6.7e-06 nrd=0.06 \
        nrs=0.06 ng=1
    MP12\(4\) (\270\:VDDA \32\:VDDA \240\:VDDA \279\:VDDA) modp w=5e-06 \
        l=1e-05 as=4.25e-12 ad=4.25e-12 ps=6.7e-06 pd=6.7e-06 nrd=0.06 \
        nrs=0.06 ng=1
    MP12\(3\) (\235\:VDDA \28\:VDDA \205\:VDDA \279\:VDDA) modp w=5e-06 \
        l=1e-05 as=4.25e-12 ad=4.25e-12 ps=6.7e-06 pd=6.7e-06 nrd=0.06 \
        nrs=0.06 ng=1
    MP12\(2\) (\200\:VDDA \24\:VDDA \170\:VDDA \279\:VDDA) modp w=5e-06 \
        l=1e-05 as=4.25e-12 ad=4.25e-12 ps=6.7e-06 pd=6.7e-06 nrd=0.06 \
        nrs=0.06 ng=1
    MP12\(1\) (\165\:VDDA \20\:VDDA \135\:VDDA \279\:VDDA) modp w=5e-06 \
        l=1e-05 as=4.25e-12 ad=4.25e-12 ps=6.7e-06 pd=6.7e-06 nrd=0.06 \
        nrs=0.06 ng=1
    MP12\(0\) (\129\:VDDA \16\:VDDA \99\:VDDA \279\:VDDA) modp w=5e-06 \
        l=1e-05 as=4.25e-12 ad=4.25e-12 ps=6.7e-06 pd=6.7e-06 nrd=0.06 \
        nrs=0.06 ng=1
    avD43_2 (\1251\:GNDA \279\:VDDA) nwd area=3.09071e-08 \
        perimeter=0.0007042 m=1
    avD43_3 (\1251\:GNDA \102\:S) nwd area=7.33863e-09 perimeter=0.0003433 \
        m=1
    avD43_4 (\1251\:GNDA \44\:S2) nwd area=1.88805e-09 perimeter=0.000175 \
        m=1
    avD43_5 (\1251\:GNDA \218\:GNDA) nwd area=1.74158e-08 \
        perimeter=0.0005461 m=1
    R37 (net37 \2\:net32 \218\:GNDA) PRIMLIB_rpolyhc_schematic w=2e-06 \
        l=5.255e-05 mult=1 mmw=0 cap=2.08292e-14
    R6 (net4 \2\:net2 \218\:GNDA) PRIMLIB_rpolyhc_schematic w=2e-06 \
        l=5.255e-05 mult=1 mmw=0 cap=2.08292e-14
    R38 (\2\:net41 \2\:net33 \218\:GNDA) PRIMLIB_rpolyhc_schematic w=2e-06 \
        l=5.255e-05 mult=1 mmw=0 cap=2.08292e-14
    R42 (net38 \2\:net37 \218\:GNDA) PRIMLIB_rpolyhc_schematic w=2e-06 \
        l=5.255e-05 mult=1 mmw=0 cap=2.08292e-14
    R21 (net23 net19 \218\:GNDA) PRIMLIB_rpolyhc_schematic w=2e-06 \
        l=5.255e-05 mult=1 mmw=0 cap=2.08292e-14
    R47 (net40 \17\:X \218\:GNDA) PRIMLIB_rpolyhc_schematic w=2e-06 \
        l=5.255e-05 mult=1 mmw=0 cap=2.08292e-14
    R25 (net21 \2\:net23 \218\:GNDA) PRIMLIB_rpolyhc_schematic w=2e-06 \
        l=5.255e-05 mult=1 mmw=0 cap=2.08292e-14
    R46 (net39 net41 \218\:GNDA) PRIMLIB_rpolyhc_schematic w=2e-06 \
        l=5.255e-05 mult=1 mmw=0 cap=2.08292e-14
    R16 (\2\:net7 \2\:net14 \218\:GNDA) PRIMLIB_rpolyhc_schematic w=2e-06 \
        l=5.255e-05 mult=1 mmw=0 cap=2.08292e-14
    R5 (U \2\:net4 \218\:GNDA) PRIMLIB_rpolyhc_schematic w=2e-06 \
        l=5.255e-05 mult=1 mmw=0 cap=2.08292e-14
    R7 (net2 \18\:Y \218\:GNDA) PRIMLIB_rpolyhc_schematic w=2e-06 \
        l=5.255e-05 mult=1 mmw=0 cap=2.08292e-14
    R39 (\2\:net27 \2\:net34 \218\:GNDA) PRIMLIB_rpolyhc_schematic w=2e-06 \
        l=5.255e-05 mult=1 mmw=0 cap=2.08292e-14
    R19 (net14 net17 \218\:GNDA) PRIMLIB_rpolyhc_schematic w=2e-06 \
        l=5.255e-05 mult=1 mmw=0 cap=2.08292e-14
    R40 (net32 net35 \218\:GNDA) PRIMLIB_rpolyhc_schematic w=2e-06 \
        l=5.255e-05 mult=1 mmw=0 cap=2.08292e-14
    R20 (net15 \2\:net18 \218\:GNDA) PRIMLIB_rpolyhc_schematic w=2e-06 \
        l=5.255e-05 mult=1 mmw=0 cap=2.08292e-14
    R41 (net33 \2\:net36 \218\:GNDA) PRIMLIB_rpolyhc_schematic w=2e-06 \
        l=5.255e-05 mult=1 mmw=0 cap=2.08292e-14
    R43 (net34 \2\:net38 \218\:GNDA) PRIMLIB_rpolyhc_schematic w=2e-06 \
        l=5.255e-05 mult=1 mmw=0 cap=2.08292e-14
    R24 (net18 \2\:net22 \218\:GNDA) PRIMLIB_rpolyhc_schematic w=2e-06 \
        l=5.255e-05 mult=1 mmw=0 cap=2.08292e-14
    R45 (net36 \2\:net40 \218\:GNDA) PRIMLIB_rpolyhc_schematic w=2e-06 \
        l=5.255e-05 mult=1 mmw=0 cap=2.08292e-14
    R8 (\15\:BG_REF net6 \218\:GNDA) PRIMLIB_rpolyhc_schematic w=2e-06 \
        l=5.255e-05 mult=1 mmw=0 cap=2.08292e-14
    R32 (\2\:net1 net27 \218\:GNDA) PRIMLIB_rpolyhc_schematic w=2e-06 \
        l=5.255e-05 mult=1 mmw=0 cap=2.08292e-14
    R12 (\2\:net8 net10 \218\:GNDA) PRIMLIB_rpolyhc_schematic w=2e-06 \
        l=5.255e-05 mult=1 mmw=0 cap=2.08292e-14
    R33 (\2\:net25 net28 \218\:GNDA) PRIMLIB_rpolyhc_schematic w=2e-06 \
        l=5.255e-05 mult=1 mmw=0 cap=2.08292e-14
    R34 (\2\:net3 net29 \218\:GNDA) PRIMLIB_rpolyhc_schematic w=2e-06 \
        l=5.255e-05 mult=1 mmw=0 cap=2.08292e-14
    R13 (\2\:net9 net11 \218\:GNDA) PRIMLIB_rpolyhc_schematic w=2e-06 \
        l=5.255e-05 mult=1 mmw=0 cap=2.08292e-14
    R35 (\2\:net26 net30 \218\:GNDA) PRIMLIB_rpolyhc_schematic w=2e-06 \
        l=5.255e-05 mult=1 mmw=0 cap=2.08292e-14
    R14 (\2\:net6 net12 \218\:GNDA) PRIMLIB_rpolyhc_schematic w=2e-06 \
        l=5.255e-05 mult=1 mmw=0 cap=2.08292e-14
    R27 (net16 \17\:Y \218\:GNDA) PRIMLIB_rpolyhc_schematic w=2e-06 \
        l=5.255e-05 mult=1 mmw=0 cap=2.08292e-14
    R23 (\2\:net17 \2\:net21 \218\:GNDA) PRIMLIB_rpolyhc_schematic w=2e-06 \
        l=5.255e-05 mult=1 mmw=0 cap=2.08292e-14
    R44 (\2\:net35 \2\:net39 \218\:GNDA) PRIMLIB_rpolyhc_schematic w=2e-06 \
        l=5.255e-05 mult=1 mmw=0 cap=2.08292e-14
ends fecg_bandgap3_layout_av_extracted
// End of subcircuit definition.

// Library name: FBIAS
// Cell name: fecg_bandgap_tb
// View name: schematic
// Inherited view list: verilogams veriloga behavioral functional module
// schematic spectre symbol
I0 (BG_REF net4 0 VDD) fecg_bandgap3_layout_av_extracted
V0 (net1 0) vsource dc=VDD mag=1 xfmag=1 type=dc
C0 (BG_REF 0) capacitor c=150f
V1 (VDD net1) vsource type=pulse val0=0 val1=VDD_PULSE period=1 delay=2u \
        rise=VDD_RISE fall=1n width=500.0m
I2 (0 net4) isource dc=200n type=dc
simulatorOptions options psfversion="1.4.0" temp=27 tnom=27 homotopy=all \
    limit=delta scalem=1.0 scale=1.0 compatible=spice2 gmin=1e-12 rforce=1 \
    maxnotes=5 maxwarns=5 digits=5 cols=80 pivrel=1e-3 \
    sensfile="../psf/sens.output" checklimitdest=psf enable_pre_ver=yes \
    ignorezerovar=yes
dcOp dc write="spectre.dc" maxiters=150 maxsteps=10000 annotate=status
dcOpInfo info what=oppoint where=rawfile
dc dc param=VDD start=0 stop=3.3 step=20m oppoint=rawfile maxiters=150 \
    maxsteps=10000 annotate=status
noise ( BG_REF ) noise start=0.01 stop=100M dec=30 annotate=status
xf ( BG_REF ) xf start=0.01 stop=100M dec=20 annotate=status
modelParameter info what=models where=rawfile
element info what=inst where=rawfile
outputParameter info what=output where=rawfile
designParamVals info what=parameters where=rawfile
primitives info what=primitives where=rawfile
subckts info what=subckts where=rawfile
save BG_REF
saveOptions options save=allpub
