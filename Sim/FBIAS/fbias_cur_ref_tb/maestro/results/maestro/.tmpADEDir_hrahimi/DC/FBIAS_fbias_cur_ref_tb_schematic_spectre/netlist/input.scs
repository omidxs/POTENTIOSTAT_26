// Design: FBIAS/fbias_cur_ref_tb
simulator lang=spectre
global 0
include "/opt/pdk/ams/410/spectre/c35/soac/soac.scs"
parameters temperature=27 VDD_STEP=20m VGB_STEP=0 VBG=1.2 VDD=3.3
include "/opt/pdk/ams/410/spectre/c35/processOption.scs"
include "/opt/pdk/ams/410/spectre/c35/cmos53.scs" section=cmostm
include "/opt/pdk/ams/410/spectre/c35/res.scs" section=restm
include "/opt/pdk/ams/410/spectre/c35/cap.scs" section=captm
include "/opt/pdk/ams/410/spectre/c35/bip.scs" section=biptm
include "/opt/pdk/ams/410/spectre/c35/ind.scs" section=indtm
include "/opt/pdk/ams/410/spectre/c35/esddiode.scs" section=esddiodetm

// PRIMLIB/rpolyhc/schematic
subckt rpolyhc PLUS MINUS REF
parameters w=10u l=10u mult=1 mmw=0 cap=14.34f
    R1 (PLUS net9) rpolyh w=w l=(0.5 * l) m=mult mmw=mmw
    R2 (net9 MINUS) rpolyh w=w l=(0.5*l) m=mult mmw=mmw
    CS0 (PLUS REF) capacitor c=(1-0.5*(1+tanh(l/200/w)))*cap/2 m=mult
    CS1 (MINUS REF) capacitor c=(1-0.5*(1+tanh(l/200/w)))*cap/2 m=mult
    CM (net9 REF) capacitor c=(0.5*(1+tanh(l/200/w))*cap) m=mult
ends rpolyhc

// FBIAS/fbias_cur_ref2_layout/schematic
subckt fbias_cur_ref2_layout BIAS GNDA OUT1 OUT10 OUT2 OUT3 OUT4 OUT5 OUT6 OUT7 OUT8 OUT9 VBG VDDA VRES OUT11
    MN1\<0\> (D1 VRES S GNDA) modn w=28.5u l=1u ng=1
    MN1\<1\> (D1 VRES S GNDA) modn w=28.5u l=1u ng=1
    MN1\<2\> (D1 VRES S GNDA) modn w=28.5u l=1u ng=1
    MN1\<3\> (D1 VRES S GNDA) modn w=28.5u l=1u ng=1
    MN1\<4\> (D1 VRES S GNDA) modn w=28.5u l=1u ng=1
    MN1\<5\> (D1 VRES S GNDA) modn w=28.5u l=1u ng=1
    MN1\<6\> (D1 VRES S GNDA) modn w=28.5u l=1u ng=1
    MN1\<7\> (D1 VRES S GNDA) modn w=28.5u l=1u ng=1
    MN1\<8\> (D1 VRES S GNDA) modn w=28.5u l=1u ng=1
    MN1\<9\> (D1 VRES S GNDA) modn w=28.5u l=1u ng=1
    MN1\<10\> (D1 VRES S GNDA) modn w=28.5u l=1u ng=1
    MN1\<11\> (D1 VRES S GNDA) modn w=28.5u l=1u ng=1
    MN1\<12\> (D1 VRES S GNDA) modn w=28.5u l=1u ng=1
    MN1\<13\> (D1 VRES S GNDA) modn w=28.5u l=1u ng=1
    MN0\<0\> (D2 VBG S GNDA) modn w=28.5u l=1u ng=1
    MN0\<1\> (D2 VBG S GNDA) modn w=28.5u l=1u ng=1
    MN0\<2\> (D2 VBG S GNDA) modn w=28.5u l=1u ng=1
    MN0\<3\> (D2 VBG S GNDA) modn w=28.5u l=1u ng=1
    MN0\<4\> (D2 VBG S GNDA) modn w=28.5u l=1u ng=1
    MN0\<5\> (D2 VBG S GNDA) modn w=28.5u l=1u ng=1
    MN0\<6\> (D2 VBG S GNDA) modn w=28.5u l=1u ng=1
    MN0\<7\> (D2 VBG S GNDA) modn w=28.5u l=1u ng=1
    MN0\<8\> (D2 VBG S GNDA) modn w=28.5u l=1u ng=1
    MN0\<9\> (D2 VBG S GNDA) modn w=28.5u l=1u ng=1
    MN0\<10\> (D2 VBG S GNDA) modn w=28.5u l=1u ng=1
    MN0\<11\> (D2 VBG S GNDA) modn w=28.5u l=1u ng=1
    MN0\<12\> (D2 VBG S GNDA) modn w=28.5u l=1u ng=1
    MN0\<13\> (D2 VBG S GNDA) modn w=28.5u l=1u ng=1
    MN5\<0\> (GNDA GNDA GNDA GNDA) modn w=28.5u l=1u ng=1
    MN5\<1\> (GNDA GNDA GNDA GNDA) modn w=28.5u l=1u ng=1
    MN5\<2\> (GNDA GNDA GNDA GNDA) modn w=28.5u l=1u ng=1
    MN5\<3\> (GNDA GNDA GNDA GNDA) modn w=28.5u l=1u ng=1
    MN3\<0\> (BIAS BIAS GNDA GNDA) modn w=5u l=10u ng=1
    MN3\<1\> (BIAS BIAS GNDA GNDA) modn w=5u l=10u ng=1
    MN2 (GC BIAS GNDA GNDA) modn w=5u l=10u ng=1
    MN6\<0\> (BIAS BIAS BIAS GNDA) modn w=5u l=10u ng=1
    MN6\<1\> (BIAS BIAS BIAS GNDA) modn w=5u l=10u ng=1
    MN4\<0\> (S BIAS GNDA GNDA) modn w=5u l=10u ng=1
    MN4\<1\> (S BIAS GNDA GNDA) modn w=5u l=10u ng=1
    MP30\<0\> (GC GC GC VDDA) modp w=5u l=2u ng=1
    MP30\<1\> (GC GC GC VDDA) modp w=5u l=2u ng=1
    MP29\<0\> (D2 D2 D2 VDDA) modp w=10u l=30u ng=1
    MP29\<1\> (D2 D2 D2 VDDA) modp w=10u l=30u ng=1
    MP28\<0\> (D1 D1 D1 VDDA) modp w=8.35u l=5u ng=1
    MP28\<1\> (D1 D1 D1 VDDA) modp w=8.35u l=5u ng=1
    MP28\<2\> (D1 D1 D1 VDDA) modp w=8.35u l=5u ng=1
    MP28\<3\> (D1 D1 D1 VDDA) modp w=8.35u l=5u ng=1
    MP1\<0\> (C D2 VDDA VDDA) modp w=10u l=30u ng=1
    MP1\<1\> (C D2 VDDA VDDA) modp w=10u l=30u ng=1
    MP1\<2\> (C D2 VDDA VDDA) modp w=10u l=30u ng=1
    MP1\<3\> (C D2 VDDA VDDA) modp w=10u l=30u ng=1
    MP1\<4\> (C D2 VDDA VDDA) modp w=10u l=30u ng=1
    MP1\<5\> (C D2 VDDA VDDA) modp w=10u l=30u ng=1
    MP27 (net14 D2 VDDA VDDA) modp w=10u l=30u ng=1
    MP26 (OUT11 GC net14 VDDA) modp w=5u l=2u ng=1
    MP25 (net13 D2 VDDA VDDA) modp w=10u l=30u ng=1
    MP24 (net12 D2 VDDA VDDA) modp w=10u l=30u ng=1
    MP23 (net10 D2 VDDA VDDA) modp w=10u l=30u ng=1
    MP22 (OUT8 GC net13 VDDA) modp w=5u l=2u ng=1
    MP17 (net9 D2 VDDA VDDA) modp w=10u l=30u ng=1
    MP16 (OUT5 GC net9 VDDA) modp w=5u l=2u ng=1
    MP15 (net8 D2 VDDA VDDA) modp w=10u l=30u ng=1
    MP14 (OUT6 GC net8 VDDA) modp w=5u l=2u ng=1
    MP13 (net7 D2 VDDA VDDA) modp w=10u l=30u ng=1
    MP12 (OUT3 GC net7 VDDA) modp w=5u l=2u ng=1
    MP11 (net5 D2 VDDA VDDA) modp w=10u l=30u ng=1
    MP19 (net6 D2 VDDA VDDA) modp w=10u l=30u ng=1
    MP18 (OUT7 GC net6 VDDA) modp w=5u l=2u ng=1
    MP21 (OUT9 GC net12 VDDA) modp w=5u l=2u ng=1
    MP20 (OUT10 GC net10 VDDA) modp w=5u l=2u ng=1
    MP8 (OUT2 GC net4 VDDA) modp w=5u l=2u ng=1
    MP9 (net4 D2 VDDA VDDA) modp w=10u l=30u ng=1
    MP10 (OUT4 GC net5 VDDA) modp w=5u l=2u ng=1
    MP7 (OUT1 GC net1 VDDA) modp w=5u l=2u ng=1
    MP6 (net1 D2 VDDA VDDA) modp w=10u l=30u ng=1
    MP5 (VRES GC C VDDA) modp w=5u l=1u ng=1
    MP3 (GC GC net19 VDDA) modp w=5u l=2u ng=1
    MP2 (net19 net19 VDDA VDDA) modp w=5u l=1u ng=1
    MP4\<0\> (D1 D1 VDDA VDDA) modp w=8.35u l=5u ng=1
    MP4\<1\> (D1 D1 VDDA VDDA) modp w=8.35u l=5u ng=1
    MP4\<2\> (D1 D1 VDDA VDDA) modp w=8.35u l=5u ng=1
    MP4\<3\> (D1 D1 VDDA VDDA) modp w=8.35u l=5u ng=1
    MP4\<4\> (D1 D1 VDDA VDDA) modp w=8.35u l=5u ng=1
    MP4\<5\> (D1 D1 VDDA VDDA) modp w=8.35u l=5u ng=1
    MP0\<0\> (D2 D1 VDDA VDDA) modp w=8.35u l=5u ng=1
    MP0\<1\> (D2 D1 VDDA VDDA) modp w=8.35u l=5u ng=1
    MP0\<2\> (D2 D1 VDDA VDDA) modp w=8.35u l=5u ng=1
    MP0\<3\> (D2 D1 VDDA VDDA) modp w=8.35u l=5u ng=1
    MP0\<4\> (D2 D1 VDDA VDDA) modp w=8.35u l=5u ng=1
    MP0\<5\> (D2 D1 VDDA VDDA) modp w=8.35u l=5u ng=1
    R0 (D2 net3 GNDA) rpolyhc w=0.8u l=30u mult=1 mmw=0 cap=5.928f
    C1\<0\> (net3 VRES GNDA) cvar w=990u l=0.65u row=15 col=10 m=1
    C1\<1\> (net3 VRES GNDA) cvar w=990u l=0.65u row=15 col=10 m=1
    C1\<2\> (net3 VRES GNDA) cvar w=990u l=0.65u row=15 col=10 m=1
    C1\<3\> (net3 VRES GNDA) cvar w=990u l=0.65u row=15 col=10 m=1
    C1\<4\> (net3 VRES GNDA) cvar w=990u l=0.65u row=15 col=10 m=1
    C1\<5\> (net3 VRES GNDA) cvar w=990u l=0.65u row=15 col=10 m=1
ends fbias_cur_ref2_layout

// FBIAS/fbias_cur_ref_tb/schematic
I0 (net2 0 net5 net13 net10 net9 net8 net7 net6 net12 net15 net14 VBGP VDD VRES net11) fbias_cur_ref2_layout
V1 (net4 0) vsource dc=VBG xfmag=1 type=dc
V0 (net3 0) vsource dc=VDD type=dc
R10 (net13 0) resistor r=2M isnoisy=no
R9 (net14 0) resistor r=2M isnoisy=no
R8 (net15 0) resistor r=2M isnoisy=no
R7 (net12 0) resistor r=2M isnoisy=no
R6 (net7 0) resistor r=2M isnoisy=no
R5 (net8 0) resistor r=2M isnoisy=no
R4 (net9 0) resistor r=2M isnoisy=no
R3 (net10 0) resistor r=2M isnoisy=no
R2 (net5 0) resistor r=2M isnoisy=no
R1 (net1 0) resistor r=2M isnoisy=no
R0 (VRES 0) resistor r=1M
C0 (VRES 0) capacitor c=5p
I2 (0 net2) isource dc=200n type=dc
V3 (VDD net3) vsource type=pulse val0=0 val1=VDD_STEP period=1 delay=10u rise=1n fall=1n width=500.0m
V2 (VBGP net4) vsource type=pulse val0=0 val1=VGB_STEP period=1 delay=10u rise=1n fall=1n width=500.0m
IPRB0 (net6 net1) iprobe
simulatorOptions options temp=27 homotopy=all limit=delta compatible=spice2 enable_pre_ver=yes ignorezerovar=yes
dcOp dc
tran tran stop=100u
noise noise start=0.01 stop=100M dec=20 oprobe=IPRB0
save R1:1
