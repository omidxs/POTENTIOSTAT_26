(envSetVal "asimenv.startup" "projectDir" 'string "./Sim")
(envSetVal "maestro.lscs" "startEvaluatorAfterSimFinish" 'boolean nil)
(envSetVal "maestro.lscs" "evaluateMultipleMonteCarlo" 'boolean t)
(envSetVal "adexl.results" "evalOutputsOnSimFailure" 'cyclic "SkipFailedAnalyses")
