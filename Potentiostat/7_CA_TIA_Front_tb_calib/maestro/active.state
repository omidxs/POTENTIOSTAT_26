ADE simulation setup
Test TIA_Gain_Linearity: Potentiostat/7_CA_TIA_Front_tb_calib/schematic6, simulator spectre
  Models: /opt/pdk/ams/410/spectre/c35/soac/processOption.scs, /opt/pdk/ams/410/spectre/c35/soac/cmos53.scs[cmostm], /opt/pdk/ams/410/spectre/c35/soac/res.scs[restm], /opt/pdk/ams/410/spectre/c35/soac/cap.scs[captm], /opt/pdk/ams/410/spectre/c35/soac/bip.scs[biptm], /opt/pdk/ams/410/spectre/c35/soac/ind.scs[indtm], /opt/pdk/ams/410/spectre/c35/soac/esddiode.scs[esddiodetm]
  Variables: Vb = 1.615; Idc = 0; Iin_TIA_AC = 1; Ipulse = 0; Vin_CA_AC = 0; vpuls = 0
  Temperature: 27
  Simulator options: reltol=100e-6 homotopy=all limit=delta additionalArgs=enable_pre_ver=yes ignorezerovar=yes
  Files: definitions /opt/pdk/ams/410/spectre/c35/soac/soac.scs
  Analysis tran: stop=800m errpreset=conservative
  Analysis dc: sweep Idc start=-5.5u stop=5.5u step=20n (saves the operating point)
  Analysis ac: start=1m stop=1G dec=20
  Analysis noise: start=1u stop=1G dec=20 p=/Vout
  Output deriv(VS("/Vout"))
  Output rmsNoise(0.001 100000)
  Output VDC("/I25/net8")
  Output VDC("/net1")
  Signals: /Vout, /I25/net8, /net1
Test MC: Potentiostat/7_CA_TIA_Front_tb_calib/config, simulator spectre
  Models: /opt/pdk/ams/410/spectre/c35/soac/processOption.scs, /opt/pdk/ams/410/spectre/c35/soac/cmos53.scs[cmosmc], /opt/pdk/ams/410/spectre/c35/soac/res.scs[resmc], /opt/pdk/ams/410/spectre/c35/soac/cap.scs[capmc], /opt/pdk/ams/410/spectre/c35/soac/bip.scs[bipmc], /opt/pdk/ams/410/spectre/c35/soac/ind.scs[indmc], /opt/pdk/ams/410/spectre/c35/soac/esddiode.scs[esddiodemc]
  Variables: Vb = 1.7; Idc = 0; Iin_TIA_AC = 0; Ipulse = 0; Vin_CA_AC = 1; vpuls = -50m
  Temperature: 27
  Simulator options: reltol=100e-6 homotopy=all limit=delta additionalArgs=enable_pre_ver=yes ignorezerovar=yes
  Files: definitions /opt/pdk/ams/410/spectre/c35/soac/soac.scs
  Analysis pz: p=/Vout iprobe=/V1 freq=1
  Analysis tran: stop=800m errpreset=conservative
  Analysis dc: (saves the operating point)
  Analysis ac: start=10m stop=1G dec=20
  Analysis xf: start=1m stop=1G dec=20 p=/Vout
  Analysis noise: start=1m stop=1G dec=20 p=/Vout
  Analysis stb: start=1m stop=500k dec=20 probe=/I25/IPRB2 stbProbeMode=single-ended
  Output Bias error = mag((value(VT("/RE") 0.3) - value(VT("/WE") 0.3) - (value(VT("/V_EC") 0.3) - VS("/vref"))))
  Output Output noise = getData("out" ?result "noise")
  Output CA Error = mag((value(VT("/RE") 0.3) - value(VT("/V_EC") 0.3)))
  Output (VDC("/vref") - VDC("/net1"))
  Output rmsNoise(0.001 100000)
  Output Vout_noise/Rf = (rmsNoise(0.001 100000) / ((VDC("/net1") - VDC("/Vout")) / IDC("/I25/IPRB0/PLUS")))
  Output PSRR = db(getData("/V0" ?result "xf"))
  Output TIA_Error_Adjusted = mag((VS("/vref") - value(VT("/Vout") 0.3) - ((value(IT("/I25/IPRB0/PLUS") 0.3) * (VDC("/net1") - VDC("/Vout"))) / IDC("/I25/IPRB0/PLUS"))))
  Output Phase Margin = getData("phaseMargin" ?result "stb_margin")
  Output MUX leakage = (IDC("/I25/IPRB7/PLUS") - IDC("/I25/IPRB0/PLUS"))
  Output MUX voltage drop = (VDC("/I25/net3") - VDC("/I25/net1"))
  Signals: /CE, /RE, /Vout, /WE, /V_EC, /vref, /VDDA, /I25/IPRB0/PLUS (terminal), /net1, /I25/IPRB7/PLUS (terminal), /I25/net3, /I25/net1
Test PTAT_MC: Potentiostat/7_CA_TIA_Front_tb_calib/schematic6, simulator spectre
  Models: /opt/pdk/ams/410/spectre/c35/soac/processOption.scs, /opt/pdk/ams/410/spectre/c35/soac/cmos53.scs[cmosmc], /opt/pdk/ams/410/spectre/c35/soac/res.scs[resmc], /opt/pdk/ams/410/spectre/c35/soac/cap.scs[capmc], /opt/pdk/ams/410/spectre/c35/soac/bip.scs[bipmc], /opt/pdk/ams/410/spectre/c35/soac/ind.scs[indmc], /opt/pdk/ams/410/spectre/c35/soac/esddiode.scs[esddiodemc]
  Variables: Vb = 1.7; Idc = 0; Iin_TIA_AC = 0; Ipulse = 0; Vin_CA_AC = 0; vpuls = 0
  Temperature: 27
  Simulator options: reltol=100e-6 homotopy=all limit=delta additionalArgs=enable_pre_ver=yes ignorezerovar=yes
  Files: definitions /opt/pdk/ams/410/spectre/c35/soac/soac.scs
  Analysis dc: (saves the operating point)
  Analysis xf: start=1m stop=1G dec=20 p=/V_ptat_inv
  Output Sensitivity = ((value(VS("/V_ptat_inv") -40) - value(VS("/V_ptat_inv") 85)) / 125)
  Output Slope = deriv(VS("/V_ptat_inv"))
  Output PSRR = db(getData("/V0" ?result "xf"))
  Signals: /V_ptat_inv
Test Potentiostat_7_CA_TIA_Front_tb_calib_1: Potentiostat/7_CA_TIA_Front_tb_calib/config, simulator spectre
  Models: /opt/pdk/ams/410/spectre/c35/soac/processOption.scs, /opt/pdk/ams/410/spectre/c35/soac/cmos53.scs[cmostm], /opt/pdk/ams/410/spectre/c35/soac/res.scs[restm], /opt/pdk/ams/410/spectre/c35/soac/cap.scs[captm], /opt/pdk/ams/410/spectre/c35/soac/bip.scs[biptm], /opt/pdk/ams/410/spectre/c35/soac/ind.scs[indtm], /opt/pdk/ams/410/spectre/c35/soac/esddiode.scs[esddiodetm]
  Variables: Vb = 1.7; Idc = 0; Iin_TIA_AC = 0; Ipulse = 0; Vin_CA_AC = 1; vpuls = -50m
  Temperature: 27
  Simulator options: reltol=100e-6 homotopy=all limit=delta additionalArgs=enable_pre_ver=yes ignorezerovar=yes
  Files: definitions /opt/pdk/ams/410/spectre/c35/soac/soac.scs
  Analysis pz: p=/Vout iprobe=/V1 freq=1
  Analysis tran: stop=800m errpreset=conservative
  Analysis dc: (saves the operating point)
  Analysis ac: start=10m stop=1G dec=20
  Analysis xf: start=1m stop=1G dec=20 p=/Vout
  Analysis noise: start=1m stop=1G dec=20 p=/Vout
  Analysis stb: start=1m stop=100M dec=20 probe=/I25/IPRB2 stbProbeMode=single-ended
  Output Bias error = mag((value(VT("/RE") 0.3) - value(VT("/WE") 0.3) - (value(VT("/V_EC") 0.3) - VS("/vref"))))
  Output Output noise = getData("out" ?result "noise")
  Output CA Error = mag((value(VT("/RE") 0.3) - value(VT("/V_EC") 0.3)))
  Output rmsNoise(0.001 100000)
  Output PSRR = db(getData("/V0" ?result "xf"))
  Output TIA_Error_Adjusted = mag((VS("/vref") - value(VT("/Vout") 0.3) - ((value(IT("/I25/IPRB0/PLUS") 0.3) * (VDC("/net1") - VDC("/Vout"))) / IDC("/I25/IPRB0/PLUS"))))
  Output Phase Margin = getData("phaseMargin" ?result "stb_margin")
  Output MUX leakage = (IDC("/I25/IPRB7/PLUS") - IDC("/I25/IPRB0/PLUS"))
  Output MUX voltage drop = (VDC("/I25/net3") - VDC("/I25/net1"))
  Output (VDC("/vref") - VDC("/net1"))
  Output Vout_noise/Rf = (rmsNoise(0.001 100000) / ((VDC("/net1") - VDC("/Vout")) / IDC("/I25/IPRB0/PLUS")))
  Signals: /CE, /RE, /Vout, /WE, /V_EC, /vref, /VDDA, /I25/IPRB0/PLUS (terminal), /net1, /I25/IPRB7/PLUS (terminal), /I25/net3, /I25/net1
Test PTAT: Potentiostat/7_CA_TIA_Front_tb_calib/schematic6, simulator spectre
  Models: /opt/pdk/ams/410/spectre/c35/soac/processOption.scs, /opt/pdk/ams/410/spectre/c35/soac/cmos53.scs[cmostm], /opt/pdk/ams/410/spectre/c35/soac/res.scs[restm], /opt/pdk/ams/410/spectre/c35/soac/cap.scs[captm], /opt/pdk/ams/410/spectre/c35/soac/bip.scs[biptm], /opt/pdk/ams/410/spectre/c35/soac/ind.scs[indtm], /opt/pdk/ams/410/spectre/c35/soac/esddiode.scs[esddiodetm]
  Variables: Vb = 1.7; Idc = 0; Iin_TIA_AC = 0; Ipulse = 0; Vin_CA_AC = 0; vpuls = 0
  Temperature: 27
  Simulator options: reltol=100e-6 homotopy=all limit=delta additionalArgs=enable_pre_ver=yes ignorezerovar=yes
  Files: definitions /opt/pdk/ams/410/spectre/c35/soac/soac.scs
  Analysis tran: stop=200m errpreset=conservative
  Output Sensitivity = ((value(VS("/V_ptat_inv") -40) - value(VS("/V_ptat_inv") 85)) / 125)
  Output Slope = deriv(VS("/V_ptat_inv"))
  Output PSRR = db(getData("/V0" ?result "xf"))
  Signals: /V_ptat_inv
Run mode: Single Run, Sweeps and Corners
Global variables:
  Cdl = 10n
  vdd = 3.3
  vtran = 0
  vref = 1.615
  Vb = 1.7 (off)
  vddpuls = 0
  R_ct = 500k
  Cdl_CE = 10n
  Rct_CE = 100k
  Rs_CE = 10k
  Rs_WE = 10k
  PTAT_EN = 1
  Calib_EN = 0
  S0 = 0
  S1 = 0
  S2 = 1
  S3 = 0
Corners (all switched off):
  model folders: /opt/pdk/ams/410/spectre/c35/soac
  CMOS_VDD_CAP_RES_BJT (off): vdd=2.97 3.63; processOption.scs, cmos53.scs[cmoswz cmosws cmoswp cmoswo], res.scs[reswp resws], cap.scs[capwp capws], bip.scs[biphb biphs biplb]
  CMOS_VDD_RES_Temp (off): temperature=-40 27 85; vdd=2.97 3.63; processOption.scs, cmos53.scs[cmoswz cmosws cmoswp cmoswo], res.scs[reswp resws], cap.scs[captm], bip.scs[biptm]
  CMOS (off): processOption.scs, cmos53.scs[cmoswo cmoswp cmosws cmoswz], res.scs[restm], cap.scs[captm], bip.scs[biptm]
  Temp (off): temperature=-40 -35 -30 -25 -20 -15 -10 -5 0 5 10 15 20 25 30 35 40 45 50 55 60 65 70 75 80 85; processOption.scs, cmos53.scs[cmostm], res.scs[restm], cap.scs[captm], bip.scs[biptm]
  CMOS_current (off): R_ct=mag((VAR( "Vb" )-VAR( "vref" ))/10n), mag((VAR( "Vb" )-VAR( "vref" ))/500n); processOption.scs, cmos53.scs[cmoswo cmoswp cmosws cmoswz], res.scs[restm], cap.scs[captm], bip.scs[biptm]
  CMOS_current_Temp_Res_Cap (off): temperature=-40 85; R_ct=mag((VAR( "Vb" )-VAR( "vref" ))/10n), mag((VAR( "Vb" )-VAR( "vref" ))/500n); processOption.scs, cmos53.scs[cmoswo cmoswp cmosws cmoswz], res.scs[reswp resws], cap.scs[capwp capws], bip.scs[biptm]
  CMOS_current_Temp_Res_Cap_VDD_BJT (off): temperature=-40 85; vdd=2.97 3.63; R_ct=mag((VAR( "Vb" )-VAR( "vref" ))/100n), mag((VAR( "Vb" )-VAR( "vref" ))/400n); processOption.scs, cmos53.scs[cmoswo cmoswp cmosws cmoswz], res.scs[reswp resws], cap.scs[capwp capws], bip.scs[biphb biphs biplb]
  CMOS_Temp_Res_Cap_BJT (off): processOption.scs, cmos53.scs[cmoswo cmoswp cmosws cmoswz], res.scs[reswp resws], cap.scs[capwp capws], bip.scs[biphb biphs biplb]
  CMOS_VDD_Res_Cap_Temp: temperature=-40 85; vdd=2.97 3.63; processOption.scs, cmos53.scs[cmoswo cmoswp cmosws cmoswz], res.scs[reswp resws], cap.scs[capwp capws], bip.scs[biptm]
  CMOS_VDD_Res_Cap_Temp_BJT (off): temperature=-40 85; vdd=2.97 3.63; processOption.scs, cmos53.scs[cmoswo cmoswp cmosws cmoswz], res.scs[reswp resws], cap.scs[capwp capws], bip.scs[biphb biphs biplb]
  CMOS_Temp_VDD (off): temperature=-40 85; vdd=2.97 3.63; R_ct=mag((VAR( "Vb" )-VAR( "vref" ))/500n); processOption.scs, cmos53.scs[cmoswo cmoswp cmosws cmoswz], res.scs[reswp resws], cap.scs[capwp capws], bip.scs[biptm]
  Load_Current for 1M (off): R_ct=mag((VAR( "Vb" )-VAR( "vref" ))/350n), mag((VAR( "Vb" )-VAR( "vref" ))/1u); Cdl=1u 1n 10n 100n; Rs_CE=1k 20k; Cdl_CE=10p 1n 1u; Rct_CE=10k; Rs_WE=1k 20k; Vb=1.765 1.715; S1=1; S2=0; S3=0; processOption.scs, cmos53.scs[cmostm], res.scs[restm], cap.scs[captm], bip.scs[biptm]
  Load_Current for 3M (off): R_ct=mag((VAR( "Vb" )-VAR( "vref" ))/100n), mag((VAR( "Vb" )-VAR( "vref" ))/350n); Cdl=1u 1n 10n 100n; Rs_CE=1k 20k; Cdl_CE=10p 1n 1u; Rct_CE=10k; Rs_WE=1k 20k; Vb=1.765 1.715; S1=0; S2=1; S3=0; processOption.scs, cmos53.scs[cmostm], res.scs[restm], cap.scs[captm], bip.scs[biptm]
  Load_Current for 10M (off): R_ct=mag((VAR( "Vb" )-VAR( "vref" ))/10n), mag((VAR( "Vb" )-VAR( "vref" ))/100n); Cdl=1u 1n 10n 100n; Rs_CE=1k 20k; Cdl_CE=10p 1n 1u; Rct_CE=10k; Rs_WE=1k 20k; Vb=1.765 1.715; S1=0; S2=0; S3=1; processOption.scs, cmos53.scs[cmostm], res.scs[restm], cap.scs[captm], bip.scs[biptm]
  Cell current (off): R_ct=mag((VAR( "Vb" )-VAR( "vref" ))/10n), mag((VAR( "Vb" )-VAR( "vref" ))/500n)
Disabled tests: MC, PTAT, PTAT_MC, Potentiostat_7_CA_TIA_Front_tb_calib_1_1, TIA_Gain_Linearity
