ADE simulation setup
Run mode: Single Run, Sweeps and Corners
Tests:
  Potentiostat_6_TIA_tb_1: Potentiostat/6_TIA_Front_Layout_tb/schematic, simulator spectre
    Variables: Cdl = 10n; Ib9 = 200n; Iin_TIA_AC = 1; Ipulse = 100n; R_ct = 1M; vref = 1.65; vdd = 3.3; Itran = 0; Vb = 1.75; vddpulse = 0; Iin_dc = 0
    Outputs: /Vout; Zeros; Poles; rmsNoise(0.001 100000)
  MC (off): Potentiostat/6_TIA_Front_Layout_tb/schematic, simulator spectre
    Variables: Cdl = 10n; Ib9 = 200n; Iin_TIA_AC = 1; Ipulse = 100n; R_ct = 1M; vref = 1.65; vdd = 3.3; Itran = 0; Vb = 1.75; vddpulse = 0; Iin_dc = 0
    Outputs: /Vout; Zeros; Poles; rmsNoise(0.001 100000)
  Linearity (off): Potentiostat/6_TIA_Front_Layout_tb/schematic, simulator spectre
    Variables: Cdl = 10n; Ib9 = 200n; Iin_TIA_AC = 1; Ipulse = 0; R_ct = 1M; vref = 1.65; vdd = 3.3; Itran = 100n; Vb = 1.75; vddpulse = 0; Iin_dc = -1u
    Outputs: /Vout; deriv(VS("/Vout")); dB20(dft(leafValue(VT("/Vout") "Design_Point" 1.0) 0 0.8 1024 "Rectangular" 1 "default" 1.0)); dB20(dft(VT("/Vout") 0 0.8 1024 "Rectangular" 1 "default" 1.0)); HD2
  Linearity_MC (off): Potentiostat/6_TIA_Front_Layout_tb/schematic, simulator spectre
    Variables: Cdl = 10n; Ib9 = 200n; Iin_TIA_AC = 1; Ipulse = 0; R_ct = 1M; vref = 1.65; vdd = 3.3; Itran = 50n; Vb = 1.75; vddpulse = 0; Iin_dc = -1u
    Outputs: /Vout; deriv(VS("/Vout")); dB20(dft(leafValue(VT("/Vout") "Design_Point" 1.0) 0 0.8 1024 "Rectangular" 1 "default" 1.0)); dB20(dft(VT("/Vout") 0 0.8 1024 "Rectangular" 1 "default" 1.0)); HD2
Corners:
  model folders: /opt/pdk/ams/410/spectre/c35/soac
  C0 (off): vdd=2.97 3.63; processOption.scs, cmos53.scs[cmoswo cmoswp cmosws cmoswz], res.scs[reswp resws], cap.scs[capwp capws], bip.scs[biptm], ind.scs[indtm], esddiode.scs[esddiodetm]
  C0_copy_0 (off): processOption.scs, cmos53.scs[cmoswo cmoswp cmosws cmoswz], res.scs[reswp resws], cap.scs[capwp capws], bip.scs[biptm], ind.scs[indtm], esddiode.scs[esddiodetm]
