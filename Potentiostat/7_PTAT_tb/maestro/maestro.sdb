ADE simulation setup
Run mode: Single Run, Sweeps and Corners
Tests:
  Potentiostat_7_my_bandgap_1: Potentiostat/7_PTAT_tb/schematic, simulator spectre
    Variables: vdd = 3.3
    Outputs: "/V_ptat"; /Y; /X; rmsNoise(0.001 100000); /; /Vo; Sensor_sensitiv; /V_ptat; /I14/V_ptat
  MC (off): Potentiostat/7_PTAT_tb/schematic, simulator spectre
    Outputs: "/V_ptat"; /Y; /V_ptat; /X; rmsNoise(0.001 100000); /; /Vo; Sensor_sensitiv
Global variables:
  vdd = 0
  vddpulse = 3.3
Corners (all switched off):
  model folders: /opt/pdk/ams/410/spectre/c35/soac
  C1: vdd=2.97 3.63; processOption.scs, cmos53.scs[cmoswo cmoswp cmosws cmoswz], res.scs[restmwn reswp], cap.scs[capwp capws], bip.scs[biphb biphs biplb]
