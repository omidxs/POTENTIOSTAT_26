ADE simulation setup
Test VT26_TOP_top_tb_DC: Potentiostat_Top/topsyh_tb/config, simulator ams
  Models: /opt/pdk/ams/410/spectre/c35/processOption.scs, /opt/pdk/ams/410/spectre/c35/cmos53.scs[cmostm], /opt/pdk/ams/410/spectre/c35/res.scs[restm], /opt/pdk/ams/410/spectre/c35/cap.scs[captm], /opt/pdk/ams/410/spectre/c35/bip.scs[biptm], /opt/pdk/ams/410/spectre/c35/ind.scs[indtm], /opt/pdk/ams/410/spectre/c35/esddiode.scs[esddiodetm]
  Variables: BIO_VB = 1.7; BIO_VB_PULSE = 0; Idc = 0; Iin_TIA_AC = 0; Ipulse = 0; R_ct = 500k; BOR_DEL = 2; VDD_PULSE_BOR = 0; VDD_PULSE = 0; VDD_PW = 0.5; VDD_SR = 1u; VDD = 3.3; FC = 4k; VCM_AC = 0; VCM_AMP = 0; VCM_DC = 1.6; VIN_AC = 1; VIN_AMP = 1m; VIN_DC = 0; VIN_FREQ = 50
  Temperature: 27
  Files: definitions /opt/pdk/ams/410/spectre/c35/soac/soac.scs
  Analysis tran: stop=200u errpreset=conservative infotimes=("200u")
  Signals: /I0/CMFB_ens, /I0/fECG_filter<2:0>, /I0/fECG_gain<2:0>, /I0/CMFB_en, /I0/Bio_GAIN<3:0>, /I0/Bio_PTAT_EN, /I0/Bio_Calin_EN, /I0/ECG_filter<2:0>, /I0/ECG_gain<3:0>
Test VT26_TOP_top_tb_TRAN: Potentiostat_Top/topsyh_tb/config, simulator ams
  Models: /opt/pdk/ams/410/spectre/c35/processOption.scs, /opt/pdk/ams/410/spectre/c35/cmos53.scs[cmostm], /opt/pdk/ams/410/spectre/c35/res.scs[restm], /opt/pdk/ams/410/spectre/c35/cap.scs[captm], /opt/pdk/ams/410/spectre/c35/bip.scs[biptm], /opt/pdk/ams/410/spectre/c35/ind.scs[indtm], /opt/pdk/ams/410/spectre/c35/esddiode.scs[esddiodetm]
  Variables: BOR_DEL = 2; VDD_PULSE_BOR = 0; VDD_PULSE = 0; VDD_PW = 0.5; VDD_SR = 1u; VDD = 3.3; FC = 4k; VCM_AC = 0; VCM_AMP = 0; VCM_DC = 1.6; VIN_AC = 1; VIN_AMP = 0.25m; VIN_DC = 0; VIN_FREQ = 50
  Temperature: 27
  Files: definitions /opt/pdk/ams/410/spectre/c35/soac/soac.scs
  Analysis tran: stop=200m errpreset=conservative infotimes=("160u")
  Signals: /RESET_L, /SPI_CLK, /CPI_CS, /SPI_MOSI, /I0/fECG_filter<2:0>, /I0/fECG_gain<2:0>, /I0/CMFB_en, /I0/porl, /FECG, /I0/vinp, /I0/vinn, /I0/I2/VIA, /I0/I2/VLF1, /I0/I2/VGA, /I0/I2/VLF2, /GNDA, /ECG, /I0/ECG_filter<2:0>, /I0/ECG_gain<3:0>, /I0/CMFB_ens, /I0/I19/VIA, /I0/I19/VLF1, /I0/I19/VGA, /I0/I19/VLF2
Test VT26_TOP_top_tb_TRAN_VDD: Potentiostat_Top/topsyh_tb/config, simulator ams
  Models: /opt/pdk/ams/410/spectre/c35/processOption.scs, /opt/pdk/ams/410/spectre/c35/cmos53.scs[cmostm], /opt/pdk/ams/410/spectre/c35/res.scs[restm], /opt/pdk/ams/410/spectre/c35/cap.scs[captm], /opt/pdk/ams/410/spectre/c35/bip.scs[biptm], /opt/pdk/ams/410/spectre/c35/ind.scs[indtm], /opt/pdk/ams/410/spectre/c35/esddiode.scs[esddiodetm]
  Variables: BOR_DEL = 3; VDD_PULSE_BOR = 0; VDD_PULSE = 3.3; VDD_PW = 9; VDD_SR = 1m; VDD = 0; FC = 4k; VCM_AC = 0; VCM_AMP = 0; VCM_DC = 1.6; VIN_AC = 1; VIN_AMP = 0; VIN_DC = 0; VIN_FREQ = 50
  Temperature: 27
  Files: definitions /opt/pdk/ams/410/spectre/c35/soac/soac.scs
  Analysis tran: stop=2 errpreset=conservative infotimes=("160u")
  Signals: /RESET_L, /SPI_CLK, /CPI_CS, /SPI_MOSI, /I0/fECG_filter<2:0>, /I0/fECG_gain<2:0>, /I0/CMFB_en, /I0/porl, /FECG, /I0/vinp, /I0/vinn, /I0/I2/VIA, /I0/I2/VLF1, /I0/I2/VGA, /I0/I2/VLF2, /ECG, /I0/I19/VIA, /I0/I19/VLF1, /I0/I19/VGA, /I0/I19/VLF2
Test VT26_TOP_top_tb_TRAN_VDD_BOR: Potentiostat_Top/topsyh_tb/config, simulator ams
  Models: /opt/pdk/ams/410/spectre/c35/processOption.scs, /opt/pdk/ams/410/spectre/c35/cmos53.scs[cmostm], /opt/pdk/ams/410/spectre/c35/res.scs[restm], /opt/pdk/ams/410/spectre/c35/cap.scs[captm], /opt/pdk/ams/410/spectre/c35/bip.scs[biptm], /opt/pdk/ams/410/spectre/c35/ind.scs[indtm], /opt/pdk/ams/410/spectre/c35/esddiode.scs[esddiodetm]
  Variables: BOR_DEL = 40m; VDD_PULSE_BOR = -500m; VDD_PULSE = 0; VDD_PW = 9; VDD_SR = 1m; VDD = 3.3; FC = 4k; VCM_AC = 0; VCM_AMP = 0; VCM_DC = 1.6; VIN_AC = 1; VIN_AMP = 1m; VIN_DC = 0; VIN_FREQ = 50
  Temperature: 27
  Files: definitions /opt/pdk/ams/410/spectre/c35/soac/soac.scs
  Analysis tran: stop=100m errpreset=conservative infotimes=("160u")
  Signals: /RESET_L, /SPI_CLK, /CPI_CS, /SPI_MOSI, /I0/fECG_filter<2:0>, /I0/fECG_gain<2:0>, /I0/CMFB_en, /I0/porl, /FECG, /I0/vinp, /I0/vinn, /I0/I2/VIA, /I0/I2/VLF1, /I0/I2/VGA, /I0/I2/VLF2, /ECG, /I0/I19/VIA, /I0/I19/VLF1, /I0/I19/VGA, /I0/I19/VLF2
Test VT26_TOP_top_tb_TRAN_GAIN_ECG: Potentiostat_Top/topsyh_tb/config, simulator ams
  Models: /opt/pdk/ams/410/spectre/c35/processOption.scs, /opt/pdk/ams/410/spectre/c35/cmos53.scs[cmostm], /opt/pdk/ams/410/spectre/c35/res.scs[restm], /opt/pdk/ams/410/spectre/c35/cap.scs[captm], /opt/pdk/ams/410/spectre/c35/bip.scs[biptm], /opt/pdk/ams/410/spectre/c35/ind.scs[indtm], /opt/pdk/ams/410/spectre/c35/esddiode.scs[esddiodetm]
  Variables: BOR_DEL = 2; VDD_PULSE_BOR = 0; VDD_PULSE = 0; VDD_PW = 0.5; VDD_SR = 1u; VDD = 3.3; FC = 4k; VCM_AC = 0; VCM_AMP = 0; VCM_DC = 1.6; VIN_AC = 1; VIN_AMP = 0.25m; VIN_DC = 0; VIN_FREQ = 50
  Temperature: 27
  Files: definitions /opt/pdk/ams/410/spectre/c35/soac/soac.scs
  Analysis tran: stop=200m errpreset=conservative infotimes=("160u")
  Signals: /RESET_L, /SPI_CLK, /CPI_CS, /SPI_MOSI, /I0/fECG_filter<2:0>, /I0/fECG_gain<2:0>, /I0/CMFB_en, /I0/porl, /FECG, /I0/vinp, /I0/vinn, /I0/I2/VIA, /I0/I2/VLF1, /I0/I2/VGA, /I0/I2/VLF2, /GNDA, /ECG, /I0/ECG_filter<2:0>, /I0/ECG_gain<3:0>, /I0/CMFB_ens, /I0/I19/VIA, /I0/I19/VLF1, /I0/I19/VGA, /I0/I19/VLF2
Test VT26_TOP_top_tb_TRAN_FILTER_ECG: Potentiostat_Top/topsyh_tb/config, simulator ams
  Models: /opt/pdk/ams/410/spectre/c35/processOption.scs, /opt/pdk/ams/410/spectre/c35/cmos53.scs[cmostm], /opt/pdk/ams/410/spectre/c35/res.scs[restm], /opt/pdk/ams/410/spectre/c35/cap.scs[captm], /opt/pdk/ams/410/spectre/c35/bip.scs[biptm], /opt/pdk/ams/410/spectre/c35/ind.scs[indtm], /opt/pdk/ams/410/spectre/c35/esddiode.scs[esddiodetm]
  Variables: BOR_DEL = 2; VDD_PULSE_BOR = 0; VDD_PULSE = 0; VDD_PW = 0.5; VDD_SR = 1u; VDD = 3.3; FC = 4k; VCM_AC = 0; VCM_AMP = 0; VCM_DC = 1.6; VIN_AC = 1; VIN_AMP = 1m; VIN_DC = 0; VIN_FREQ = 800
  Temperature: 27
  Files: definitions /opt/pdk/ams/410/spectre/c35/soac/soac.scs
  Analysis tran: stop=160m errpreset=conservative infotimes=("160u")
  Signals: /RESET_L, /SPI_CLK, /CPI_CS, /SPI_MOSI, /I0/fECG_filter<2:0>, /I0/fECG_gain<2:0>, /I0/CMFB_en, /I0/porl, /FECG, /I0/vinp, /I0/vinn, /I0/I2/VIA, /I0/I2/VLF1, /I0/I2/VGA, /I0/I2/VLF2, /GNDA, /ECG, /I0/ECG_filter<2:0>, /I0/ECG_gain<3:0>, /I0/CMFB_ens, /I0/I19/VIA, /I0/I19/VLF1, /I0/I19/VGA, /I0/I19/VLF2
Test VT26_TOP_top_tb_DC_BIO: Potentiostat_Top/topsyh_tb/config, simulator ams
  Models: /opt/pdk/ams/410/spectre/c35/processOption.scs, /opt/pdk/ams/410/spectre/c35/cmos53.scs[cmostm], /opt/pdk/ams/410/spectre/c35/res.scs[restm], /opt/pdk/ams/410/spectre/c35/cap.scs[captm], /opt/pdk/ams/410/spectre/c35/bip.scs[biptm], /opt/pdk/ams/410/spectre/c35/ind.scs[indtm], /opt/pdk/ams/410/spectre/c35/esddiode.scs[esddiodetm]
  Variables: BIO_VB = 1.7; BIO_VB_PULSE = 0; Idc = 0; Iin_TIA_AC = 0; Ipulse = 0; R_ct = 500k; BOR_DEL = 2; VDD_PULSE_BOR = 0; VDD_PULSE = 0; VDD_PW = 0.5; VDD_SR = 1u; VDD = 3.3; FC = 0.1; VCM_AC = 0; VCM_AMP = 0; VCM_DC = 1.6; VIN_AC = 1; VIN_AMP = 1m; VIN_DC = 0; VIN_FREQ = 50
  Temperature: 27
  Files: definitions /opt/pdk/ams/410/spectre/c35/soac/soac.scs
  Analysis tran: stop=10m errpreset=conservative infotimes=("10m")
  Signals: /I0/CMFB_ens, /I0/fECG_filter<2:0>, /I0/fECG_gain<2:0>, /I0/CMFB_en, /I0/Bio_GAIN<3:0>, /I0/Bio_PTAT_EN, /I0/Bio_Calin_EN, /I0/ECG_filter<2:0>, /I0/ECG_gain<3:0>
Test VT26_TOP_top_tb_TRAN_BIO: Potentiostat_Top/topsyh_tb/config, simulator ams
  Models: /opt/pdk/ams/410/spectre/c35/processOption.scs, /opt/pdk/ams/410/spectre/c35/cmos53.scs[cmostm], /opt/pdk/ams/410/spectre/c35/res.scs[restm], /opt/pdk/ams/410/spectre/c35/cap.scs[captm], /opt/pdk/ams/410/spectre/c35/bip.scs[biptm], /opt/pdk/ams/410/spectre/c35/ind.scs[indtm], /opt/pdk/ams/410/spectre/c35/esddiode.scs[esddiodetm]
  Variables: BIO_VB = 1.68; BIO_VB_PULSE = 0; Idc = 0; Iin_TIA_AC = 0; Ipulse = 0; R_ct = 500k; BOR_DEL = 2; VDD_PULSE_BOR = 0; VDD_PULSE = 0; VDD_PW = 0.5; VDD_SR = 1u; VDD = 3.3; FC = 0.1; VCM_AC = 0; VCM_AMP = 0; VCM_DC = 1.6; VIN_AC = 1; VIN_AMP = 0.25m; VIN_DC = 0; VIN_FREQ = 50
  Temperature: 27
  Files: definitions /opt/pdk/ams/410/spectre/c35/soac/soac.scs
  Analysis tran: stop=2 errpreset=conservative infotimes=("1.5")
  Signals: /RESET_L, /SPI_CLK, /CPI_CS, /SPI_MOSI, /I0/porl, /GNDA, /POT_OUT, /V_EC, /WE, /RE, /VPI
Test VT26_TOP_top_tb_TRAN_NOISE_BIO: Potentiostat_Top/topsyh_tb/config, simulator ams
  Models: /opt/pdk/ams/410/spectre/c35/processOption.scs, /opt/pdk/ams/410/spectre/c35/cmos53.scs[cmostm], /opt/pdk/ams/410/spectre/c35/res.scs[restm], /opt/pdk/ams/410/spectre/c35/cap.scs[captm], /opt/pdk/ams/410/spectre/c35/bip.scs[biptm], /opt/pdk/ams/410/spectre/c35/ind.scs[indtm], /opt/pdk/ams/410/spectre/c35/esddiode.scs[esddiodetm]
  Variables: BIO_VB = 1.7; BIO_VB_PULSE = 0; Idc = 0; Iin_TIA_AC = 0; Ipulse = 0; R_ct = 500k; BOR_DEL = 2; VDD_PULSE_BOR = 0; VDD_PULSE = 0; VDD_PW = 0.5; VDD_SR = 1u; VDD = 3.3; FC = 0.1; VCM_AC = 0; VCM_AMP = 0; VCM_DC = 1.6; VIN_AC = 1; VIN_AMP = 0.25m; VIN_DC = 0; VIN_FREQ = 50
  Temperature: 27
  Files: definitions /opt/pdk/ams/410/spectre/c35/soac/soac.scs
  Analysis tran: stop=200m errpreset=conservative noisefmax=100k noisefmin=1m noisescale=1 infotimes=("180m")
  Output rmsNoise(0.001 100000) (unticked)
  Output stddev(clip(VT("/POT_OUT") 0.1 0.2))
  Output stddev(clip(VT("/VPI") 0.1 0.2))
  Signals: /RESET_L, /SPI_CLK, /CPI_CS, /SPI_MOSI, /I0/porl, /GNDA, /POT_OUT, /V_EC, /WE, /RE, /VPI
