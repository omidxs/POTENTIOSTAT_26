ADE simulation setup
Run mode: Single Run, Sweeps and Corners
Tests:
  VT26_TOP_top_tb_DC (off): Potentiostat_Top/topsyh_tb/config, simulator ams
    Variables: FC = 4k; VCM_AC = 0; VCM_AMP = 0; VCM_DC = 1.6; VIN_AC = 1; VIN_AMP = 1m; VIN_DC = 0; VIN_FREQ = 50; VDD = 3.3; VDD_PULSE = 0; VDD_PW = 0.5; VDD_SR = 1u; VDD_PULSE_BOR = 0; BOR_DEL = 2; BIO_VB = 1.7; BIO_VB_PULSE = 0; Idc = 0; Iin_TIA_AC = 0; Ipulse = 0; R_ct = 500k
  VT26_TOP_top_tb_TRAN (off): Potentiostat_Top/topsyh_tb/config, simulator ams
    Variables: FC = 4k; VCM_AC = 0; VCM_AMP = 0; VCM_DC = 1.6; VIN_AC = 1; VIN_AMP = 0.25m; VIN_DC = 0; VIN_FREQ = 50; VDD = 3.3; VDD_PULSE = 0; VDD_PW = 0.5; VDD_SR = 1u; VDD_PULSE_BOR = 0; BOR_DEL = 2
    Outputs: /RESET_L; /SPI_CLK; /CPI_CS; /SPI_MOSI; /FECG
  VT26_TOP_top_tb_TRAN_VDD (off): Potentiostat_Top/topsyh_tb/config, simulator ams
    Variables: FC = 4k; VCM_AC = 0; VCM_AMP = 0; VCM_DC = 1.6; VIN_AC = 1; VIN_AMP = 0; VIN_DC = 0; VIN_FREQ = 50; VDD = 0; VDD_PULSE = 3.3; VDD_PW = 9; VDD_SR = 1m; VDD_PULSE_BOR = 0; BOR_DEL = 3
    Outputs: /RESET_L; /SPI_CLK; /CPI_CS; /SPI_MOSI; /FECG
  VT26_TOP_top_tb_TRAN_VDD_BOR (off): Potentiostat_Top/topsyh_tb/config, simulator ams
    Variables: FC = 4k; VCM_AC = 0; VCM_AMP = 0; VCM_DC = 1.6; VIN_AC = 1; VIN_AMP = 1m; VIN_DC = 0; VIN_FREQ = 50; VDD = 3.3; VDD_PULSE = 0; VDD_PW = 9; VDD_SR = 1m; VDD_PULSE_BOR = -500m; BOR_DEL = 40m
    Outputs: /RESET_L; /SPI_CLK; /CPI_CS; /SPI_MOSI; /FECG
  VT26_TOP_top_tb_TRAN_GAIN_ECG (off): Potentiostat_Top/topsyh_tb/config, simulator ams
    Variables: FC = 4k; VCM_AC = 0; VCM_AMP = 0; VCM_DC = 1.6; VIN_AC = 1; VIN_AMP = 0.25m; VIN_DC = 0; VIN_FREQ = 50; VDD = 3.3; VDD_PULSE = 0; VDD_PW = 0.5; VDD_SR = 1u; VDD_PULSE_BOR = 0; BOR_DEL = 2
    Outputs: /RESET_L; /SPI_CLK; /CPI_CS; /SPI_MOSI; /FECG
  VT26_TOP_top_tb_TRAN_FILTER_ECG (off): Potentiostat_Top/topsyh_tb/config, simulator ams
    Variables: FC = 4k; VCM_AC = 0; VCM_AMP = 0; VCM_DC = 1.6; VIN_AC = 1; VIN_AMP = 1m; VIN_DC = 0; VIN_FREQ = 800; VDD = 3.3; VDD_PULSE = 0; VDD_PW = 0.5; VDD_SR = 1u; VDD_PULSE_BOR = 0; BOR_DEL = 2
    Outputs: /RESET_L; /SPI_CLK; /CPI_CS; /SPI_MOSI; /FECG
  VT26_TOP_top_tb_DC_BIO (off): Potentiostat_Top/topsyh_tb/config, simulator ams
    Variables: FC = 0.1; VCM_AC = 0; VCM_AMP = 0; VCM_DC = 1.6; VIN_AC = 1; VIN_AMP = 1m; VIN_DC = 0; VIN_FREQ = 50; VDD = 3.3; VDD_PULSE = 0; VDD_PW = 0.5; VDD_SR = 1u; VDD_PULSE_BOR = 0; BOR_DEL = 2; BIO_VB = 1.7; BIO_VB_PULSE = 0; Idc = 0; Iin_TIA_AC = 0; Ipulse = 0; R_ct = 500k
  VT26_TOP_top_tb_TRAN_BIO (off): Potentiostat_Top/topsyh_tb/config, simulator ams
    Variables: FC = 0.1; VCM_AC = 0; VCM_AMP = 0; VCM_DC = 1.6; VIN_AC = 1; VIN_AMP = 0.25m; VIN_DC = 0; VIN_FREQ = 50; VDD = 3.3; VDD_PULSE = 0; VDD_PW = 0.5; VDD_SR = 1u; VDD_PULSE_BOR = 0; BOR_DEL = 2; BIO_VB = 1.68; BIO_VB_PULSE = 0; Idc = 0; Iin_TIA_AC = 0; Ipulse = 0; R_ct = 500k
    Outputs: /RESET_L; /SPI_CLK; /CPI_CS; /SPI_MOSI
  VT26_TOP_top_tb_TRAN_NOISE_BIO: Potentiostat_Top/topsyh_tb/config, simulator ams
    Variables: FC = 0.1; VCM_AC = 0; VCM_AMP = 0; VCM_DC = 1.6; VIN_AC = 1; VIN_AMP = 0.25m; VIN_DC = 0; VIN_FREQ = 50; VDD = 3.3; VDD_PULSE = 0; VDD_PW = 0.5; VDD_SR = 1u; VDD_PULSE_BOR = 0; BOR_DEL = 2; BIO_VB = 1.7; BIO_VB_PULSE = 0; Idc = 0; Iin_TIA_AC = 0; Ipulse = 0; R_ct = 500k
    Outputs: /RESET_L; /SPI_CLK; /CPI_CS; /SPI_MOSI; rmsNoise(0.001 100000); value(rmsNoise(0.001 100000)); stddev(clip(VT("/POT_OUT") 0.1 0.2)); stddev(clip(VT("/VPI") 0.1 0.2))
Corners (all switched off):
  model folders: /opt/pdk/ams/410/spectre/c35
  C0: temperature=-40 27 85; VDD=2.97 3.3 3.63; processOption.scs, cmos53.scs[cmoswo cmoswp cmosws cmoswz]
