ADE simulation setup
Test Potentiostat_7_CA_TIA_Front_tb_calib_1: Potentiostat/7_CA_TIA_Front_tb_calib/schematic6, simulator spectre
  Models: /opt/pdk/ams/410/spectre/c35/soac/processOption.scs, /opt/pdk/ams/410/spectre/c35/soac/cmos53.scs[cmostm], /opt/pdk/ams/410/spectre/c35/soac/res.scs[restm], /opt/pdk/ams/410/spectre/c35/soac/cap.scs[captm], /opt/pdk/ams/410/spectre/c35/soac/bip.scs[biptm], /opt/pdk/ams/410/spectre/c35/soac/ind.scs[indtm], /opt/pdk/ams/410/spectre/c35/soac/esddiode.scs[esddiodetm]
  Variables: Vb = 1.7; Idc = 0; Iin_TIA_AC = 0; Ipulse = 0; Vin_CA_AC = 1; vpuls = -50m
  Temperature: 27
  Simulator options: reltol=100e-6 homotopy=all limit=delta additionalArgs=enable_pre_ver=yes ignorezerovar=yes
  Files: definitions /opt/pdk/ams/410/spectre/c35/soac/soac.scs
  Analysis noise: start=1m stop=1G dec=20 p=/Vout
  Analysis ac: start=10m stop=1G dec=20
  Analysis dc: (saves the operating point)
  Analysis xf: start=1m stop=1G dec=20 p=/Vout
  Analysis pz: p=/Vout iprobe=/V1 freq=1
  Analysis stb: start=1m stop=100M dec=20 probe=/I25/IPRB2 stbProbeMode=single-ended
  Analysis tran: stop=800m errpreset=conservative
  Output Bias error = mag((value(VT("/RE") 0.3) - value(VT("/WE") 0.3) - (value(VT("/V_EC") 0.3) - VS("/vref"))))
  Output Output noise = getData("out" ?result "noise")
  Output CA Error = mag((value(VT("/RE") 0.3) - value(VT("/V_EC") 0.3)))
  Output rmsNoise(0.001 100000)
  Output PSRR = db(getData("/V0" ?result "xf"))
  Output TIA_Error_Adjusted = mag((VS("/vref") - value(VT("/Vout") 0.3) - ((value(IT("/I25/IPRB0/PLUS") 0.3) * (VDC("/net1") - VDC("/Vout"))) / IDC("/I25/IPRB0/PLUS"))))
  Output Phase Margin = getData("phaseMargin" ?result "stb_margin")
  Output MUX leakage = (IDC("/I25/IPRB7/PLUS") - IDC("/I25/IPRB0/PLUS"))
  Output MUX voltage drop = (VDC("/I25/net3") - VDC("/I25/net1"))
  Output (VDC("/vref") - VDC("/net1"))
  Output Vout_noise/Rf = (rmsNoise(0.001 100000) / ((VDC("/net1") - VDC("/Vout")) / IDC("/I25/IPRB0/PLUS")))
  Signals: /CE, /RE, /Vout, /WE, /V_EC, /vref, /VDDA, /I25/IPRB0/PLUS (terminal), /net1, /I25/IPRB7/PLUS (terminal), /I25/net3, /I25/net1
Test TIA_Gain_Linearity: Potentiostat/7_CA_TIA_Front_tb_calib/config, simulator spectre
  Models: /opt/pdk/ams/410/spectre/c35/soac/processOption.scs, /opt/pdk/ams/410/spectre/c35/soac/cmos53.scs[cmostm], /opt/pdk/ams/410/spectre/c35/soac/res.scs[restm], /opt/pdk/ams/410/spectre/c35/soac/cap.scs[captm], /opt/pdk/ams/410/spectre/c35/soac/bip.scs[biptm], /opt/pdk/ams/410/spectre/c35/soac/ind.scs[indtm], /opt/pdk/ams/410/spectre/c35/soac/esddiode.scs[esddiodetm]
  Variables: Vb = 1.615; Idc = 0; Iin_TIA_AC = 1; Ipulse = 0; Vin_CA_AC = 0; vpuls = 0
  Temperature: 27
  Simulator options: reltol=100e-6 homotopy=all limit=delta additionalArgs=enable_pre_ver=yes ignorezerovar=yes
  Files: definitions /opt/pdk/ams/410/spectre/c35/soac/soac.scs
  Analysis noise: start=1u stop=1G dec=20 p=/Vout
  Analysis tran: stop=800m errpreset=conservative
  Analysis ac: start=1m stop=1G dec=20
  Analysis dc: sweep Idc start=-5.5u stop=5.5u step=20n (saves the operating point)
  Output deriv(VS("/Vout"))
  Output rmsNoise(0.001 100000)
  Output VDC("/I25/net8")
  Output VDC("/net1")
  Signals: /Vout, /I25/net8, /net1
Test MC: Potentiostat/7_CA_TIA_Front_tb_calib/config, simulator spectre
  Models: /opt/pdk/ams/410/spectre/c35/soac/processOption.scs, /opt/pdk/ams/410/spectre/c35/soac/cmos53.scs[cmosmc], /opt/pdk/ams/410/spectre/c35/soac/res.scs[resmc], /opt/pdk/ams/410/spectre/c35/soac/cap.scs[capmc], /opt/pdk/ams/410/spectre/c35/soac/bip.scs[bipmc], /opt/pdk/ams/410/spectre/c35/soac/ind.scs[indmc], /opt/pdk/ams/410/spectre/c35/soac/esddiode.scs[esddiodemc]
  Variables: Vb = 1.7; Idc = 0; Iin_TIA_AC = 0; Ipulse = 0; Vin_CA_AC = 1; vpuls = -50m
  Temperature: 27
  Simulator options: reltol=100e-6 homotopy=all limit=delta additionalArgs=enable_pre_ver=yes ignorezerovar=yes
  Files: definitions /opt/pdk/ams/410/spectre/c35/soac/soac.scs
  Analysis noise: start=1m stop=1G dec=20 p=/Vout
  Analysis ac: start=10m stop=1G dec=20
  Analysis dc: (saves the operating point)
  Analysis xf: start=1m stop=1G dec=20 p=/Vout
  Analysis pz: p=/Vout iprobe=/V1 freq=1
  Analysis stb: start=1m stop=500k dec=20 probe=/I25/IPRB2 stbProbeMode=single-ended
  Analysis tran: stop=800m errpreset=conservative
  Output Bias error = mag((value(VT("/RE") 0.3) - value(VT("/WE") 0.3) - (value(VT("/V_EC") 0.3) - VS("/vref"))))
  Output Output noise = getData("out" ?result "noise")
  Output CA Error = mag((value(VT("/RE") 0.3) - value(VT("/V_EC") 0.3)))
  Output (VDC("/vref") - VDC("/net1"))
  Output rmsNoise(0.001 100000)
  Output Vout_noise/Rf = (rmsNoise(0.001 100000) / ((VDC("/net1") - VDC("/Vout")) / IDC("/I25/IPRB0/PLUS")))
  Output PSRR = db(getData("/V0" ?result "xf"))
  Output TIA_Error_Adjusted = mag((VS("/vref") - value(VT("/Vout") 0.3) - ((value(IT("/I25/IPRB0/PLUS") 0.3) * (VDC("/net1") - VDC("/Vout"))) / IDC("/I25/IPRB0/PLUS"))))
  Output Phase Margin = getData("phaseMargin" ?result "stb_margin")
  Output MUX leakage = (IDC("/I25/IPRB7/PLUS") - IDC("/I25/IPRB0/PLUS"))
  Output MUX voltage drop = (VDC("/I25/net3") - VDC("/I25/net1"))
  Signals: /CE, /RE, /Vout, /WE, /V_EC, /vref, /VDDA, /I25/IPRB0/PLUS (terminal), /net1, /I25/IPRB7/PLUS (terminal), /I25/net3, /I25/net1
Test PTAT: Potentiostat/7_CA_TIA_Front_tb_calib/schematic6, simulator spectre
  Models: /opt/pdk/ams/410/spectre/c35/soac/processOption.scs, /opt/pdk/ams/410/spectre/c35/soac/cmos53.scs[cmostm], /opt/pdk/ams/410/spectre/c35/soac/res.scs[restm], /opt/pdk/ams/410/spectre/c35/soac/cap.scs[captm], /opt/pdk/ams/410/spectre/c35/soac/bip.scs[biptm], /opt/pdk/ams/410/spectre/c35/soac/ind.scs[indtm], /opt/pdk/ams/410/spectre/c35/soac/esddiode.scs[esddiodetm]
  Variables: Vb = 1.7; Idc = 0; Iin_TIA_AC = 0; Ipulse = 0; Vin_CA_AC = 0; vpuls = 0
  Temperature: 27
  Simulator options: reltol=100e-6 homotopy=all limit=delta additionalArgs=enable_pre_ver=yes ignorezerovar=yes
  Files: definitions /opt/pdk/ams/410/spectre/c35/soac/soac.scs
  Analysis tran: stop=200m errpreset=conservative
  Output Sensitivity = ((value(VS("/V_ptat_inv") -40) - value(VS("/V_ptat_inv") 85)) / 125)
  Output Slope = deriv(VS("/V_ptat_inv"))
  Output PSRR = db(getData("/V0" ?result "xf"))
  Signals: /V_ptat_inv
Test PTAT_MC: Potentiostat/7_CA_TIA_Front_tb_calib/schematic6, simulator spectre
  Models: /opt/pdk/ams/410/spectre/c35/soac/processOption.scs, /opt/pdk/ams/410/spectre/c35/soac/cmos53.scs[cmosmc], /opt/pdk/ams/410/spectre/c35/soac/res.scs[resmc], /opt/pdk/ams/410/spectre/c35/soac/cap.scs[capmc], /opt/pdk/ams/410/spectre/c35/soac/bip.scs[bipmc], /opt/pdk/ams/410/spectre/c35/soac/ind.scs[indmc], /opt/pdk/ams/410/spectre/c35/soac/esddiode.scs[esddiodemc]
  Variables: Vb = 1.7; Idc = 0; Iin_TIA_AC = 0; Ipulse = 0; Vin_CA_AC = 0; vpuls = 0
  Temperature: 27
  Simulator options: reltol=100e-6 homotopy=all limit=delta additionalArgs=enable_pre_ver=yes ignorezerovar=yes
  Files: definitions /opt/pdk/ams/410/spectre/c35/soac/soac.scs
  Analysis dc: (saves the operating point)
  Analysis xf: start=1m stop=1G dec=20 p=/V_ptat_inv
  Output Sensitivity = ((value(VS("/V_ptat_inv") -40) - value(VS("/V_ptat_inv") 85)) / 125)
  Output Slope = deriv(VS("/V_ptat_inv"))
  Output PSRR = db(getData("/V0" ?result "xf"))
  Signals: /V_ptat_inv
