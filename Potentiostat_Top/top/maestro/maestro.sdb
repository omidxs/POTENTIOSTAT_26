ADE simulation setup
Run mode: Monte Carlo Sampling
Tests:
  Poten (off): Potentiostat_Top/top/config, simulator spectre
    Variables: Idc = 0; Iin_TIA_AC = 1; Ipulse = 0; Vin_CA_AC = 0; vpuls = -50m; Vb = 1.7
    Outputs: /CE; /RE; "/POT_OUT"; Bias error; Output noise; CA Loop Error; rmsNoise(0.001 100000); PSRR; /VDDA; VDC("/I25/net8"); (VDC("/I25/net8") - VDC("/net1")); (VDC("/vref") - VDC("/net1")); ((VDC("/net1") - VDC("/Vout")) / IDC("/I25/IPRB0/PLUS")); rmsNoise(0.01 100000); /POT_OUT; (VDC("/I2/vref") - VDC("/I2/net1")); (VDC("/I2/vref") - VDC("/I2/TIA_IN")); /WE; (VDC("/I2/V_EC") - VDC("/I2/net1")); (VDC("/I2/net4") - VDC("/I2/net1")); /Ib8; TIA loop Error
  TIA_Gain_Linearity (off): Potentiostat_Top/top/config, simulator spectre
    Variables: Idc = 0; Iin_TIA_AC = 1; Ipulse = 0; Vin_CA_AC = 0; vpuls = 0; Vb = 1.615
    Outputs: "/POT_OUT"; deriv(VS("/Vout")); rmsNoise(0.001 100000); /POT_OUT; deriv(VS("/POT_OUT")); VDC("/I2/I25/net8"); VDC("/I2/net1")
  PTAT (off): Potentiostat_Top/top/config, simulator spectre
    Variables: Idc = 0; Iin_TIA_AC = 0; Ipulse = 0; Vin_CA_AC = 0; vpuls = 0; Vb = 0
    Outputs: /V_ptat_inv; Sensitivity; Slope; PSRR; /VPI; rmsNoise(0.001 100000)
  Poten_MC: Potentiostat_Top/top/config, simulator spectre
    Variables: Idc = 0; Iin_TIA_AC = 0; Ipulse = 0; Vin_CA_AC = 1; vpuls = -50m; Vb = 1.7
    Outputs: /CE; /RE; "/POT_OUT"; Bias error; Output noise; CA Loop Error; rmsNoise(0.001 100000); PSRR; /VDDA; VDC("/I25/net8"); (VDC("/I25/net8") - VDC("/net1")); (VDC("/vref") - VDC("/net1")); ((VDC("/net1") - VDC("/Vout")) / IDC("/I25/IPRB0/PLUS")); rmsNoise(0.01 100000); /POT_OUT; (VDC("/I2/vref") - VDC("/I2/net1")); (VDC("/I2/vref") - VDC("/I2/TIA_IN")); /WE; (VDC("/I2/V_EC") - VDC("/I2/net1")); (VDC("/I2/net4") - VDC("/I2/net1")); /Ib8; TIA loop Error
  PTAT_MC: Potentiostat_Top/top/config, simulator spectre
    Variables: Idc = 0; Iin_TIA_AC = 0; Ipulse = 0; Vin_CA_AC = 0; vpuls = 0; Vb = 0
    Outputs: /V_ptat_inv; Sensitivity; Slope; PSRR; /VPI
  TIA_Gain_Linearity_MC (off): Potentiostat_Top/top/config, simulator spectre
    Variables: Idc = 0; Iin_TIA_AC = 1; Ipulse = 0; Vin_CA_AC = 0; vpuls = 0; Vb = 1.615
    Outputs: "/POT_OUT"; deriv(VS("/Vout")); rmsNoise(0.001 100000); /POT_OUT; deriv(VS("/POT_OUT")); VDC("/I2/I25/net8"); VDC("/I2/net1")
Global variables:
  Cdl = 10n
  vdd = 0
  vtran = 0
  vref = 1.615
  Vb = 1.7 (off)
  vddpuls = 3.3
  R_ct = 500k
  Cdl_CE = 10n
  Rct_CE = 100k
  Rs_CE = 10k
  Rs_WE = 10k
  PTAT_EN = 0
  Calib_EN = 1
  S0 = 0
  S1 = 0
  S2 = 1
  S3 = 0
Corners (all switched off):
  model folders: /opt/pdk/ams/410/spectre/c35/soac
  CMOS_VDD_CAP_RES_BJT (off): vdd=2.97 3.63; processOption.scs, cmos53.scs[cmoswz cmosws cmoswp cmoswo], res.scs[reswp resws], cap.scs[capwp capws], bip.scs[biphb biphs biplb]
  CMOS_VDD_RES_Temp (off): temperature=-40 27 85; vdd=2.97 3.63; processOption.scs, cmos53.scs[cmoswz cmosws cmoswp cmoswo], res.scs[reswp resws], cap.scs[captm], bip.scs[biptm]
  CMOS (off): processOption.scs, cmos53.scs[cmoswo cmoswp cmosws cmoswz], res.scs[restm], cap.scs[captm], bip.scs[biptm]
  Temp (off): temperature=-40 -35 -30 -25 -20 -15 -10 -5 0 5 10 15 20 25 30 35 40 45 50 55 60 65 70 75 80 85; processOption.scs, cmos53.scs[cmostm], res.scs[restm], cap.scs[captm], bip.scs[biptm]
  CMOS_current (off): R_ct=mag((VAR( "Vb" )-VAR( "vref" ))/10n), mag((VAR( "Vb" )-VAR( "vref" ))/500n); processOption.scs, cmos53.scs[cmoswo cmoswp cmosws cmoswz], res.scs[restm], cap.scs[captm], bip.scs[biptm]
  CMOS_current_Temp_Res_Cap (off): temperature=-40 85; R_ct=mag((VAR( "Vb" )-VAR( "vref" ))/10n), mag((VAR( "Vb" )-VAR( "vref" ))/500n); processOption.scs, cmos53.scs[cmoswo cmoswp cmosws cmoswz], res.scs[reswp resws], cap.scs[capwp capws], bip.scs[biptm]
  CMOS_current_Temp_Res_Cap_VDD_BJT (off): temperature=-40 85; vdd=2.97 3.63; R_ct=mag((VAR( "Vb" )-VAR( "vref" ))/100n), mag((VAR( "Vb" )-VAR( "vref" ))/400n); processOption.scs, cmos53.scs[cmoswo cmoswp cmosws cmoswz], res.scs[reswp resws], cap.scs[capwp capws], bip.scs[biphb biphs biplb]
  CMOS_Res_Cap_BJT: processOption.scs, cmos53.scs[cmoswo cmoswp cmosws cmoswz], res.scs[reswp resws], cap.scs[capwp capws], bip.scs[biphb biphs biplb], ind.scs[indtm], esddiode.scs[esddiodetm]
  CMOS_VDD_Res_Cap_Temp (off): temperature=-40 85; vdd=2.97 3.63; processOption.scs, cmos53.scs[cmoswo cmoswp cmosws cmoswz], res.scs[reswp resws], cap.scs[capwp capws], bip.scs[biptm]
  CMOS_Res_Cap_Temp (off): temperature=-40 85; processOption.scs, cmos53.scs[cmoswo cmoswp cmosws cmoswz], res.scs[reswp resws], cap.scs[capwp capws], bip.scs[biptm]
  CMOS_VDD_Res_Cap_Temp_BJT (off): temperature=-40 85; vdd=2.97 3.63; processOption.scs, cmos53.scs[cmoswo cmoswp cmosws cmoswz], res.scs[reswp resws], cap.scs[capwp capws], bip.scs[biphb biphs biplb]
  CMOS_Temp_VDD (off): temperature=-40 85; vdd=2.97 3.63; R_ct=mag((VAR( "Vb" )-VAR( "vref" ))/500n); processOption.scs, cmos53.scs[cmoswo cmoswp cmosws cmoswz], res.scs[reswp resws], cap.scs[capwp capws], bip.scs[biptm]
  Load_Current for 1M (off): R_ct=mag((VAR( "Vb" )-VAR( "vref" ))/350n), mag((VAR( "Vb" )-VAR( "vref" ))/1u); Cdl=1u 1n 10n 100n; Rs_CE=1k 20k; Cdl_CE=10p 1n 1u; Rct_CE=10k; Rs_WE=1k 20k; Vb=1.765 1.715; S1=1; S2=0; S3=0; processOption.scs, cmos53.scs[cmostm], res.scs[restm], cap.scs[captm], bip.scs[biptm]
  Load_Current for 3M (off): R_ct=mag((VAR( "Vb" )-VAR( "vref" ))/100n), mag((VAR( "Vb" )-VAR( "vref" ))/350n); Cdl=1u 1n 10n 100n; Rs_CE=1k 20k; Cdl_CE=10p 1n 1u; Rct_CE=10k; Rs_WE=1k 20k; Vb=1.765 1.715; S1=0; S2=1; S3=0; processOption.scs, cmos53.scs[cmostm], res.scs[restm], cap.scs[captm], bip.scs[biptm]
  Load_Current for 10M (off): R_ct=mag((VAR( "Vb" )-VAR( "vref" ))/10n), mag((VAR( "Vb" )-VAR( "vref" ))/100n); Cdl=1u 1n 10n 100n; Rs_CE=1k 20k; Cdl_CE=10p 1n 1u; Rct_CE=10k; Rs_WE=1k 20k; Vb=1.765 1.715; S1=0; S2=0; S3=1; processOption.scs, cmos53.scs[cmostm], res.scs[restm], cap.scs[captm], bip.scs[biptm]
  Cell current (off): R_ct=mag((VAR( "Vb" )-VAR( "vref" ))/10n), mag((VAR( "Vb" )-VAR( "vref" ))/500n)
Monte Carlo Sampling options: mismatchvary=Gaussian, sssnumpoints=7000, mismatchscale=1, processscale=1, pointsPerJobPolicy=Group automatically, maxPointsPerJob=10, reliabilitymode=singlestress, wcdinitialpoints=200, mcnumpoints=50, yeyistostart=3.0, mcSigmaTarget=3, yeiterations=10, processvary=Gaussian, yeexpectedyield=3, mcmethod=all, yeusehistorymc=0, yeuseautomcsamples=1, yecreatecorners=0, mcdistandscalingmismatchenable=0, parasiticanalysis=0, mcFilterPluginEnabled=0, haveyeyieldtostart=1, yeusevarreduction=1, mcdistandscalingprocessenable=0
