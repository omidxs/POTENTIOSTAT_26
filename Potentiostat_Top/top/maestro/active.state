ADE simulation setup
Test TIA_Gain_Linearity: Potentiostat_Top/top/schematic, simulator spectre
  Models: /opt/pdk/ams/410/spectre/c35/soac/processOption.scs, /opt/pdk/ams/410/spectre/c35/soac/cmos53.scs[cmostm], /opt/pdk/ams/410/spectre/c35/soac/res.scs[restm], /opt/pdk/ams/410/spectre/c35/soac/cap.scs[captm], /opt/pdk/ams/410/spectre/c35/soac/bip.scs[biptm], /opt/pdk/ams/410/spectre/c35/soac/ind.scs[indtm], /opt/pdk/ams/410/spectre/c35/soac/esddiode.scs[esddiodetm]
  Variables: Vb = 1.615; Idc = 0; Iin_TIA_AC = 1; Ipulse = 0; Vin_CA_AC = 0; vpuls = 0
  Temperature: 27
  Simulator options: reltol=100e-6 homotopy=all limit=delta additionalArgs=enable_pre_ver=yes ignorezerovar=yes
  Files: definitions /opt/pdk/ams/410/spectre/c35/soac/soac.scs
  Analysis noise: start=1u stop=1G dec=20 p=/POT_OUT
  Analysis tran: stop=800m errpreset=conservative
  Analysis dc: sweep Idc start=-5.5u stop=5.5u step=20n (saves the operating point)
  Analysis ac: start=1m stop=1G dec=20
  Output deriv(VS("/POT_OUT"))
  Output rmsNoise(0.001 100000)
  Output VDC("/I2/vref")
  Output VDC("/TIA_IN")
  Signals: /TIA_IN, /I2/vref
Test PTAT: Potentiostat_Top/top/schematic, simulator spectre
  Models: /opt/pdk/ams/410/spectre/c35/soac/processOption.scs, /opt/pdk/ams/410/spectre/c35/soac/cmos53.scs[cmostm], /opt/pdk/ams/410/spectre/c35/soac/res.scs[restm], /opt/pdk/ams/410/spectre/c35/soac/cap.scs[captm], /opt/pdk/ams/410/spectre/c35/soac/bip.scs[biptm], /opt/pdk/ams/410/spectre/c35/soac/ind.scs[indtm], /opt/pdk/ams/410/spectre/c35/soac/esddiode.scs[esddiodetm]
  Variables: Vb = 1.7; Idc = 0; Iin_TIA_AC = 0; Ipulse = 0; Vin_CA_AC = 0; vpuls = 0
  Temperature: 27
  Simulator options: reltol=100e-6 homotopy=all limit=delta additionalArgs=enable_pre_ver=yes ignorezerovar=yes
  Files: definitions /opt/pdk/ams/410/spectre/c35/soac/soac.scs
  Analysis xf: start=1m stop=1G dec=20 p=/VPI
  Analysis dc: sweep temperature start=-40 stop=85 step=1 (saves the operating point)
  Output Sensitivity = ((value(VS("/V_ptat_inv") -40) - value(VS("/V_ptat_inv") 85)) / 125) (unticked)
  Output Slope = deriv(VS("/VPI"))
  Output PSRR = db(getData("/V0" ?result "xf"))
  Signals: /VPI
Test Potentiostat_7_CA_TIA_Front_tb_calib_1: Potentiostat_Top/top/schematic, simulator spectre
  Models: /opt/pdk/ams/410/spectre/c35/soac/processOption.scs, /opt/pdk/ams/410/spectre/c35/soac/cmos53.scs[cmostm], /opt/pdk/ams/410/spectre/c35/soac/res.scs[restm], /opt/pdk/ams/410/spectre/c35/soac/cap.scs[captm], /opt/pdk/ams/410/spectre/c35/soac/bip.scs[biptm], /opt/pdk/ams/410/spectre/c35/soac/ind.scs[indtm], /opt/pdk/ams/410/spectre/c35/soac/esddiode.scs[esddiodetm]
  Variables: Vb = 1.7; Idc = 0; Iin_TIA_AC = 0; Ipulse = 0; Vin_CA_AC = 1; vpuls = -50m
  Temperature: 27
  Simulator options: reltol=100e-6 homotopy=all limit=delta additionalArgs=enable_pre_ver=yes ignorezerovar=yes
  Files: definitions /opt/pdk/ams/410/spectre/c35/soac/soac.scs
  Analysis tran: stop=800m errpreset=conservative
  Analysis dc: (saves the operating point)
  Output Bias error = mag((value(VT("/RE") 0.3) - value(VT("/WE") 0.3) - (value(VT("/V_EC") 0.3) - VS("/I2/vref"))))
  Output Output noise = getData("out" ?result "noise")
  Output CA Error = mag((value(VT("/RE") 0.3) - value(VT("/V_EC") 0.3)))
  Output rmsNoise(0.001 100000)
  Output PSRR = db(getData("/V0" ?result "xf"))
  Output TIA_Error_Adjusted = mag((VS("/vref") - value(VT("/Vout") 0.3) - ((value(IT("/I25/IPRB0/PLUS") 0.3) * (VDC("/net1") - VDC("/Vout"))) / IDC("/I25/IPRB0/PLUS")))) (unticked)
  Output Phase Margin = getData("phaseMargin" ?result "stb_margin")
  Output MUX leakage = (IDC("/I2/I25/IPRB7/PLUS") - IDC("/I2/I25/IPRB0/PLUS"))
  Output MUX voltage drop = (VDC("/I2/I25/net3") - VDC("/I2/I25/net1"))
  Output (VDC("/I2/vref") - VDC("/TIA_IN"))
  Output Vout_noise/Rf = (rmsNoise(0.001 100000) / ((VDC("/TIA_IN") - VDC("/POT_OUT")) / IDC("/I2/I25/IPRB0/PLUS")))
  Signals: /CE, /RE, /POT_OUT, /V_EC, /VDDA, /net1, /I2/vref, /TIA_IN, /I2/I25/IPRB0/PLUS (terminal), /I2/I25/IPRB7/PLUS (terminal), /I2/I25/net3, /I2/I25/net1, /WE
