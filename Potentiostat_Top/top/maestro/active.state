ADE simulation setup
Test Potentiostat_7_CA_TIA_Front_tb_calib_1: Potentiostat_Top/top/config, simulator spectre
  Models: /opt/pdk/ams/410/spectre/c35/soac/processOption.scs, /opt/pdk/ams/410/spectre/c35/soac/cmos53.scs[cmostm], /opt/pdk/ams/410/spectre/c35/soac/res.scs[restm], /opt/pdk/ams/410/spectre/c35/soac/cap.scs[captm], /opt/pdk/ams/410/spectre/c35/soac/bip.scs[biptm], /opt/pdk/ams/410/spectre/c35/soac/ind.scs[indtm], /opt/pdk/ams/410/spectre/c35/soac/esddiode.scs[esddiodetm]
  Variables: Vb = 1.7; Idc = 0; Iin_TIA_AC = 0; Ipulse = 0; Vin_CA_AC = 1; vpuls = -50m
  Temperature: 27
  Simulator options: reltol=100e-6 homotopy=all limit=delta additionalArgs=enable_pre_ver=yes ignorezerovar=yes
  Files: definitions /opt/pdk/ams/410/spectre/c35/soac/soac.scs
  Analysis tran: stop=800m errpreset=conservative
  Analysis noise: start=1m stop=1G dec=20 p=/POT_OUT
  Analysis dc: (saves the operating point)
  Analysis xf: start=1m stop=1G dec=20 p=/POT_OUT
  Output Bias error = (mag((value(VT("/WE") 0.2) - value(VT("/RE") 0.2))) - mag((value(VT("/V_EC") 0.2) - value(VT("/v1600") 0.2))))
  Output Output noise = getData("out" ?result "noise")
  Output CA Loop Error = mag((value(VT("/RE") 0.2) - value(VT("/V_EC") 0.2)))
  Output rmsNoise(0.001 100000)
  Output PSRR = db(getData("/V0" ?result "xf"))
  Output TIA loop Error = mag((value(VT("/WE") 0.2) - value(VT("/v1600") 0.2)))
  Signals: /CE, /RE, /POT_OUT, /V_EC, /VDDA, /WE, /v1600
Test Poten: Potentiostat_Top/top/config, simulator spectre
  Models: /opt/pdk/ams/410/spectre/c35/soac/processOption.scs, /opt/pdk/ams/410/spectre/c35/soac/cmos53.scs[cmostm], /opt/pdk/ams/410/spectre/c35/soac/res.scs[restm], /opt/pdk/ams/410/spectre/c35/soac/cap.scs[captm], /opt/pdk/ams/410/spectre/c35/soac/bip.scs[biptm], /opt/pdk/ams/410/spectre/c35/soac/ind.scs[indtm], /opt/pdk/ams/410/spectre/c35/soac/esddiode.scs[esddiodetm]
  Variables: Vb = 1.7; Idc = 0; Iin_TIA_AC = 0; Ipulse = 0; Vin_CA_AC = 1; vpuls = -50m
  Temperature: 27
  Simulator options: reltol=100e-6 homotopy=all limit=delta additionalArgs=enable_pre_ver=yes ignorezerovar=yes
  Files: definitions /opt/pdk/ams/410/spectre/c35/soac/soac.scs
  Analysis tran: stop=800m errpreset=conservative
  Analysis xf: start=1m stop=1G dec=20 p=/POT_OUT
  Analysis dc: (saves the operating point)
  Analysis noise: start=1m stop=1G dec=20 p=/POT_OUT
  Output Bias error = (mag((value(VT("/WE") 0.2) - value(VT("/RE") 0.2))) - mag((value(VT("/V_EC") 0.2) - value(VT("/v1600") 0.2))))
  Output Output noise = getData("out" ?result "noise")
  Output CA Loop Error = mag((value(VT("/RE") 0.2) - value(VT("/V_EC") 0.2)))
  Output rmsNoise(0.001 100000)
  Output PSRR = db(getData("/V0" ?result "xf"))
  Output TIA loop Error = mag((value(VT("/WE") 0.2) - value(VT("/v1600") 0.2)))
  Signals: /CE, /RE, /POT_OUT, /V_EC, /VDDA, /WE, /v1600
Test Poten_MC: Potentiostat_Top/top/config, simulator spectre
  Models: /opt/pdk/ams/410/spectre/c35/soac/processOption.scs, /opt/pdk/ams/410/spectre/c35/soac/cmos53.scs[cmosmc], /opt/pdk/ams/410/spectre/c35/soac/res.scs[resmc], /opt/pdk/ams/410/spectre/c35/soac/cap.scs[capmc], /opt/pdk/ams/410/spectre/c35/soac/bip.scs[bipmc], /opt/pdk/ams/410/spectre/c35/soac/ind.scs[indmc], /opt/pdk/ams/410/spectre/c35/soac/esddiode.scs[esddiodemc]
  Variables: Vb = 1.7; Idc = 0; Iin_TIA_AC = 0; Ipulse = 0; Vin_CA_AC = 1; vpuls = -50m
  Temperature: 27
  Simulator options: reltol=100e-6 homotopy=all limit=delta additionalArgs=enable_pre_ver=yes ignorezerovar=yes
  Files: definitions /opt/pdk/ams/410/spectre/c35/soac/soac.scs
  Analysis tran: stop=800m errpreset=conservative
  Analysis xf: start=1m stop=1G dec=20 p=/POT_OUT
  Analysis dc: (saves the operating point)
  Analysis noise: start=1m stop=1G dec=20 p=/POT_OUT
  Output Bias error = (mag((value(VT("/WE") 0.2) - value(VT("/RE") 0.2))) - mag((value(VT("/V_EC") 0.2) - value(VT("/v1600") 0.2))))
  Output Output noise = getData("out" ?result "noise")
  Output CA Loop Error = mag((value(VT("/RE") 0.2) - value(VT("/V_EC") 0.2)))
  Output rmsNoise(0.001 100000)
  Output PSRR = db(getData("/V0" ?result "xf"))
  Output TIA loop Error = mag((value(VT("/WE") 0.2) - value(VT("/v1600") 0.2)))
  Signals: /CE, /RE, /POT_OUT, /V_EC, /VDDA, /WE, /v1600
Test TIA_Gain_Linearity: Potentiostat_Top/top/config, simulator spectre
  Models: /opt/pdk/ams/410/spectre/c35/soac/processOption.scs, /opt/pdk/ams/410/spectre/c35/soac/cmos53.scs[cmostm], /opt/pdk/ams/410/spectre/c35/soac/res.scs[restm], /opt/pdk/ams/410/spectre/c35/soac/cap.scs[captm], /opt/pdk/ams/410/spectre/c35/soac/bip.scs[biptm], /opt/pdk/ams/410/spectre/c35/soac/ind.scs[indtm], /opt/pdk/ams/410/spectre/c35/soac/esddiode.scs[esddiodetm]
  Variables: Vb = 1.615; Idc = 0; Iin_TIA_AC = 1; Ipulse = 0; Vin_CA_AC = 0; vpuls = 0
  Temperature: 27
  Simulator options: reltol=100e-6 homotopy=all limit=delta additionalArgs=enable_pre_ver=yes ignorezerovar=yes
  Files: definitions /opt/pdk/ams/410/spectre/c35/soac/soac.scs
  Analysis ac: start=1m stop=1G dec=20
  Analysis dc: sweep Idc start=-5.5u stop=5.5u step=20n (saves the operating point)
  Analysis noise: start=1u stop=1G dec=20 p=/POT_OUT
  Output deriv(VS("/POT_OUT"))
  Output rmsNoise(0.001 100000)
  Signals: /POT_OUT
Test PTAT_MC: Potentiostat_Top/top/schematic, simulator spectre
  Models: /opt/pdk/ams/410/spectre/c35/soac/processOption.scs, /opt/pdk/ams/410/spectre/c35/soac/cmos53.scs[cmosmc], /opt/pdk/ams/410/spectre/c35/soac/res.scs[resmc], /opt/pdk/ams/410/spectre/c35/soac/cap.scs[capmc], /opt/pdk/ams/410/spectre/c35/soac/bip.scs[bipmc], /opt/pdk/ams/410/spectre/c35/soac/ind.scs[indmc], /opt/pdk/ams/410/spectre/c35/soac/esddiode.scs[esddiodemc]
  Variables: Vb = 0; Idc = 0; Iin_TIA_AC = 0; Ipulse = 0; Vin_CA_AC = 0; vpuls = 0
  Temperature: 27
  Simulator options: reltol=100e-6 homotopy=all limit=delta additionalArgs=enable_pre_ver=yes ignorezerovar=yes
  Files: definitions /opt/pdk/ams/410/spectre/c35/soac/soac.scs
  Analysis dc: sweep temperature start=-40 stop=85 step=1 (saves the operating point)
  Analysis xf: start=1m stop=1G dec=20 p=/VPI
  Output Sensitivity = ((value(VS("/V_ptat_inv") -40) - value(VS("/V_ptat_inv") 85)) / 125) (unticked)
  Output Slope = deriv(VS("/VPI"))
  Output PSRR = db(getData("/V0" ?result "xf"))
  Signals: /VPI
Test TIA_Gain_Linearity_MC: Potentiostat_Top/top/config, simulator spectre
  Models: /opt/pdk/ams/410/spectre/c35/soac/processOption.scs, /opt/pdk/ams/410/spectre/c35/soac/cmos53.scs[cmosmc], /opt/pdk/ams/410/spectre/c35/soac/res.scs[resmc], /opt/pdk/ams/410/spectre/c35/soac/cap.scs[capmc], /opt/pdk/ams/410/spectre/c35/soac/bip.scs[bipmc], /opt/pdk/ams/410/spectre/c35/soac/ind.scs[indmc], /opt/pdk/ams/410/spectre/c35/soac/esddiode.scs[esddiodemc]
  Variables: Vb = 1.615; Idc = 0; Iin_TIA_AC = 1; Ipulse = 0; Vin_CA_AC = 0; vpuls = 0
  Temperature: 27
  Simulator options: reltol=100e-6 homotopy=all limit=delta additionalArgs=enable_pre_ver=yes ignorezerovar=yes
  Files: definitions /opt/pdk/ams/410/spectre/c35/soac/soac.scs
  Analysis noise: start=1u stop=1G dec=20 p=/POT_OUT
  Analysis dc: sweep Idc start=-5.5u stop=5.5u step=20n (saves the operating point)
  Analysis ac: start=1m stop=1G dec=20
  Output deriv(VS("/POT_OUT"))
  Output rmsNoise(0.001 100000)
  Signals: /POT_OUT
Test PTAT: Potentiostat_Top/top/schematic, simulator spectre
  Models: /opt/pdk/ams/410/spectre/c35/soac/processOption.scs, /opt/pdk/ams/410/spectre/c35/soac/cmos53.scs[cmostm], /opt/pdk/ams/410/spectre/c35/soac/res.scs[restm], /opt/pdk/ams/410/spectre/c35/soac/cap.scs[captm], /opt/pdk/ams/410/spectre/c35/soac/bip.scs[biptm], /opt/pdk/ams/410/spectre/c35/soac/ind.scs[indtm], /opt/pdk/ams/410/spectre/c35/soac/esddiode.scs[esddiodetm]
  Variables: Vb = 0; Idc = 0; Iin_TIA_AC = 0; Ipulse = 0; Vin_CA_AC = 0; vpuls = 0
  Temperature: 27
  Simulator options: reltol=100e-6 homotopy=all limit=delta additionalArgs=enable_pre_ver=yes ignorezerovar=yes
  Files: definitions /opt/pdk/ams/410/spectre/c35/soac/soac.scs
  Analysis dc: sweep temperature start=-40 stop=85 step=1 (saves the operating point)
  Analysis xf: start=1m stop=1G dec=20 p=/VPI
  Output Sensitivity = ((value(VS("/V_ptat_inv") -40) - value(VS("/V_ptat_inv") 85)) / 125) (unticked)
  Output Slope = deriv(VS("/VPI"))
  Output PSRR = db(getData("/V0" ?result "xf"))
  Signals: /VPI
