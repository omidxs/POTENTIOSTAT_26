* SPICE NETLIST
***************************************

.SUBCKT tsv80 TOP BOTTOM SUB
.ENDS
***************************************
.SUBCKT rx POS NEG
.ENDS
***************************************
.SUBCKT Q C B E S G
.ENDS
***************************************
.SUBCKT lddn D G S B
.ENDS
***************************************
.SUBCKT phd POS NEG P
.ENDS
***************************************
.SUBCKT sbd A C SUB
.ENDS
***************************************
.SUBCKT esddlv2 A C
.ENDS
***************************************
.SUBCKT esddlv A C SUB
.ENDS
***************************************
.SUBCKT lddp D G S B
.ENDS
***************************************
.SUBCKT probepad pad
.ENDS
***************************************
.SUBCKT L POS NEG SUB
.ENDS
***************************************
.SUBCKT L POS NEG MID SUB
.ENDS
***************************************
.SUBCKT hall A B C D S P1 P2
.ENDS
***************************************
.SUBCKT cpolyc_CDNS_7804089061226 2 3
** N=3 EP=2 IP=0 FDC=1
C0 2 3 $[cpolya] $A=1728.34 $P=166.3 $X=1800 $Y=1000 $D=58
.ENDS
***************************************
.SUBCKT ICV_1 2 3
** N=3 EP=2 IP=6 FDC=2
X0 2 3 cpolyc_CDNS_7804089061226 $T=0 0 0 0 $X=-1350 $Y=-1350
X1 2 3 cpolyc_CDNS_7804089061226 $T=48050 0 0 0 $X=46700 $Y=-1350
.ENDS
***************************************
.SUBCKT rpolyhc_CDNS_7804089061223 1 2
** N=3 EP=2 IP=0 FDC=1
R0 1 2 L=0.00049995 W=8e-07 $[rpolyh] $X=-800 $Y=1550 $D=18
.ENDS
***************************************
.SUBCKT ICV_2 1 2 3 4
** N=5 EP=4 IP=6 FDC=2
X0 1 2 rpolyhc_CDNS_7804089061223 $T=0 0 0 0 $X=-6000 $Y=-4650
X1 3 4 rpolyhc_CDNS_7804089061223 $T=44150 19600 1 180 $X=-6000 $Y=14950
.ENDS
***************************************
.SUBCKT nmos4_CDNS_780408906124 1 2 3 4
** N=4 EP=4 IP=0 FDC=1
M0 2 3 1 4 nmos4 L=1e-06 W=5e-06 AD=4.25e-12 AS=4.25e-12 PD=6.7e-06 PS=6.7e-06 NRD=0.085 NRS=0.085 $X=0 $Y=850 $D=37
.ENDS
***************************************
.SUBCKT pmos4_CDNS_780408906126
** N=5 EP=0 IP=0 FDC=0
*.SEEDPROM
.ENDS
***************************************
.SUBCKT Inverter VDDA A Q GNDA
** N=4 EP=4 IP=0 FDC=3
D0 GNDA VDDA p_nwd AREA=17.2825 PJ=17.35 $X=550 $Y=3700 $D=87
M1 Q A GNDA GNDA nmos4 L=3.5e-07 W=4e-07 AD=5.7e-13 AS=5.7e-13 PD=2.8e-06 PS=2.8e-06 NRD=1.0625 NRS=1.0625 $X=3725 $Y=1550 $D=37
M2 Q A VDDA VDDA pmos4 L=3.5e-07 W=7e-07 AD=5.95e-13 AS=5.95e-13 PD=2.4e-06 PS=2.4e-06 NRD=0.607143 NRS=0.607143 $X=3725 $Y=4900 $D=41
.ENDS
***************************************
.SUBCKT 6_Resnet S<2> S<3> S<0> S<1> VDDA In Out GNDA
** N=27 EP=8 IP=93 FDC=41
R0 13 Out L=0.00015015 W=8e-07 $[rpolyh] $X=105925 $Y=104525 $D=18
D1 GNDA VDDA p_nwd AREA=31.24 PJ=23 $X=63725 $Y=98775 $D=87
D2 GNDA VDDA p_nwd AREA=30.14 PJ=22.5 $X=63725 $Y=111875 $D=87
D3 GNDA VDDA p_nwd AREA=30.14 PJ=22.5 $X=63725 $Y=126325 $D=87
D4 GNDA VDDA p_nwd AREA=29.15 PJ=22.05 $X=63725 $Y=139275 $D=87
D5 GNDA GNDA p_nwd AREA=18348.7 PJ=594.4 $X=84650 $Y=87750 $D=87
M6 In S<0> 13 GNDA nmos4 L=1e-06 W=5e-06 AD=2.5e-12 AS=4.25e-12 PD=1e-06 PS=6.7e-06 NRD=0.085 NRS=0.085 $X=69350 $Y=101850 $D=37
M7 13 S<0> In GNDA nmos4 L=1e-06 W=5e-06 AD=4.25e-12 AS=2.5e-12 PD=6.7e-06 PS=1e-06 NRD=0.085 NRS=0.085 $X=69350 $Y=103850 $D=37
M8 In 10 13 VDDA pmos4 L=1e-06 W=2e-06 AD=1.7e-12 AS=1.7e-12 PD=3.7e-06 PS=3.7e-06 NRD=0.2125 NRS=0.2125 $X=64925 $Y=102825 $D=41
M9 In 11 14 VDDA pmos4 L=1e-06 W=2e-06 AD=1.7e-12 AS=1.7e-12 PD=3.7e-06 PS=3.7e-06 NRD=0.2125 NRS=0.2125 $X=64925 $Y=115675 $D=41
M10 In 12 16 VDDA pmos4 L=1e-06 W=2e-06 AD=1.7e-12 AS=1.7e-12 PD=3.7e-06 PS=3.7e-06 NRD=0.2125 NRS=0.2125 $X=64925 $Y=130100 $D=41
M11 In 9 15 VDDA pmos4 L=1e-06 W=2e-06 AD=1.7e-12 AS=1.7e-12 PD=3.7e-06 PS=3.7e-06 NRD=0.2125 NRS=0.2125 $X=64925 $Y=142850 $D=41
X12 17 16 rpolyhc_CDNS_7804089061223 $T=92200 149450 1 0 $X=86200 $Y=128500
X13 18 17 rpolyhc_CDNS_7804089061223 $T=136350 169050 0 180 $X=86200 $Y=148100
X14 Out 18 rpolyhc_CDNS_7804089061223 $T=186500 133150 1 180 $X=136350 $Y=128500
X15 19 15 rpolyhc_CDNS_7804089061223 $T=186500 169050 0 180 $X=136350 $Y=148100
X16 20 23 rpolyhc_CDNS_7804089061223 $T=192500 110250 1 0 $X=186500 $Y=89300
X17 22 20 rpolyhc_CDNS_7804089061223 $T=236650 129850 0 180 $X=186500 $Y=108900
X18 21 22 rpolyhc_CDNS_7804089061223 $T=192500 149450 1 0 $X=186500 $Y=128500
X19 24 19 rpolyhc_CDNS_7804089061223 $T=236650 152750 1 180 $X=186500 $Y=148100
X20 25 27 rpolyhc_CDNS_7804089061223 $T=242650 133150 0 0 $X=236650 $Y=128500
X21 27 24 rpolyhc_CDNS_7804089061223 $T=286800 169050 0 180 $X=236650 $Y=148100
X22 Out 14 Out 21 ICV_2 $T=186500 93950 1 180 $X=136350 $Y=89300
X23 23 26 26 25 ICV_2 $T=242650 93950 0 0 $X=236650 $Y=89300
X24 14 In S<1> GNDA nmos4_CDNS_780408906124 $T=74350 114825 1 180 $X=68950 $Y=114575
X25 In 16 S<2> GNDA nmos4_CDNS_780408906124 $T=74425 131950 0 180 $X=69025 $Y=129000
X26 15 In S<3> GNDA nmos4_CDNS_780408906124 $T=69425 142025 0 0 $X=69025 $Y=141775
X32 VDDA S<0> 10 GNDA Inverter $T=60625 107275 1 270 $X=52725 $Y=100325
X33 VDDA S<1> 11 GNDA Inverter $T=60625 120425 1 270 $X=52725 $Y=113475
X34 VDDA S<2> 12 GNDA Inverter $T=60625 134450 1 270 $X=52725 $Y=127500
X35 VDDA S<3> 9 GNDA Inverter $T=60625 147200 1 270 $X=52725 $Y=140250
.ENDS
***************************************
.SUBCKT cpolyc_CDNS_7804089061213 2 3
** N=3 EP=2 IP=0 FDC=1
C0 2 3 $[cpolya] $A=2886.23 $P=214.9 $X=1800 $Y=1000 $D=58
.ENDS
***************************************
.SUBCKT P1_C_CDNS_78040890612114
** N=1 EP=0 IP=0 FDC=0
.ENDS
***************************************
.SUBCKT nmos4_CDNS_7804089061212
** N=3 EP=0 IP=0 FDC=0
.ENDS
***************************************
.SUBCKT PD_C_CDNS_78040890612111
** N=1 EP=0 IP=0 FDC=0
.ENDS
***************************************
.SUBCKT P1_C_CDNS_78040890612102
** N=3 EP=0 IP=0 FDC=0
.ENDS
***************************************
.SUBCKT ND_C_CDNS_78040890612104
** N=2 EP=0 IP=0 FDC=0
.ENDS
***************************************
.SUBCKT P1_C_CDNS_78040890612103
** N=2 EP=0 IP=0 FDC=0
.ENDS
***************************************
.SUBCKT ICV_3
** N=2 EP=0 IP=4 FDC=0
.ENDS
***************************************
.SUBCKT ICV_4
** N=2 EP=0 IP=4 FDC=0
.ENDS
***************************************
.SUBCKT pmos4_CDNS_7804089061215
** N=5 EP=0 IP=0 FDC=0
.ENDS
***************************************
.SUBCKT ICV_5
** N=8 EP=0 IP=10 FDC=0
.ENDS
***************************************
.SUBCKT ICV_6 3 4 5 9 10 13
** N=13 EP=6 IP=16 FDC=2
M0 4 9 3 13 pmos4 L=4e-06 W=1e-05 AD=8.5e-12 AS=8.5e-12 PD=1.17e-05 PS=1.17e-05 NRD=0.0425 NRS=0.0425 $X=0 $Y=7150 $D=41
M1 5 10 3 13 pmos4 L=4e-06 W=1e-05 AD=8.5e-12 AS=8.5e-12 PD=1.17e-05 PS=1.17e-05 NRD=0.0425 NRS=0.0425 $X=0 $Y=13450 $D=41
.ENDS
***************************************
.SUBCKT pmos4_CDNS_7804089061216
** N=4 EP=0 IP=0 FDC=0
.ENDS
***************************************
.SUBCKT ICV_7
** N=6 EP=0 IP=8 FDC=0
.ENDS
***************************************
.SUBCKT ICV_8
** N=8 EP=0 IP=12 FDC=0
.ENDS
***************************************
.SUBCKT nmos4_CDNS_780408906127
** N=4 EP=0 IP=0 FDC=0
.ENDS
***************************************
.SUBCKT ICV_9
** N=6 EP=0 IP=8 FDC=0
.ENDS
***************************************
.SUBCKT cvar_CDNS_7804089061211 1 2
** N=2 EP=2 IP=0 FDC=2
M0 2 1 2 1 cvar w=0.0003432 l=6.5e-07 cols=13 rows=4 $X=0 $Y=0 $D=62
D1 1 2 p_nwd AREA=723.45 PJ=109.1 $X=-300 $Y=-300 $D=87
.ENDS
***************************************
.SUBCKT ICV_10 1
** N=6 EP=1 IP=16 FDC=1
M0 1 1 1 1 pmos4 L=1e-05 W=1e-06 AD=8.5e-13 AS=8.5e-13 PD=2.7e-06 PS=2.7e-06 NRD=0.425 NRS=0.425 $X=0 $Y=850 $D=42
.ENDS
***************************************
.SUBCKT P1_C_CDNS_7804089061285
** N=2 EP=0 IP=0 FDC=0
.ENDS
***************************************
.SUBCKT nmos4_CDNS_780408906121 1 2 3 4
** N=4 EP=4 IP=0 FDC=4
M0 2 3 1 4 nmos4 L=4e-06 W=1e-06 AD=5e-13 AS=8.5e-13 PD=1e-06 PS=2.7e-06 NRD=0.425 NRS=0.425 $X=0 $Y=850 $D=37
M1 1 3 2 4 nmos4 L=4e-06 W=1e-06 AD=5e-13 AS=5e-13 PD=1e-06 PS=1e-06 NRD=0.425 NRS=0.425 $X=0 $Y=5850 $D=37
M2 2 3 1 4 nmos4 L=4e-06 W=1e-06 AD=5e-13 AS=5e-13 PD=1e-06 PS=1e-06 NRD=0.425 NRS=0.425 $X=0 $Y=10850 $D=37
M3 1 3 2 4 nmos4 L=4e-06 W=1e-06 AD=8.5e-13 AS=5e-13 PD=2.7e-06 PS=1e-06 NRD=0.425 NRS=0.425 $X=0 $Y=15850 $D=37
.ENDS
***************************************
.SUBCKT 6_TIA_Front_Layout Vout VDDA Ibias GNDA Vin- Vin+
** N=13 EP=6 IP=646 FDC=160
R0 11 13 L=3.00901e-05 W=2e-06 $[rpolyh] $X=231300 $Y=43950 $D=17
D1 GNDA VDDA p_nwd AREA=5780.76 PJ=322.9 $X=76650 $Y=12700 $D=87
D2 GNDA VDDA p_nwd AREA=20225.4 PJ=587.6 $X=700 $Y=68200 $D=87
D3 GNDA GNDA p_nwd AREA=14562.5 PJ=527 $X=188050 $Y=61950 $D=87
M4 12 12 12 GNDA nmos4 L=4e-06 W=1e-06 AD=8.5e-13 AS=8.5e-13 PD=2.7e-06 PS=2.7e-06 NRD=0.425 NRS=0.425 $X=43525 $Y=52250 $D=38
M5 12 12 12 GNDA nmos4 L=4e-06 W=1e-06 AD=8.5e-13 AS=8.5e-13 PD=2.7e-06 PS=2.7e-06 NRD=0.425 NRS=0.425 $X=72775 $Y=52250 $D=38
M6 GNDA GNDA GNDA GNDA nmos4 L=2e-05 W=5e-06 AD=4.25e-12 AS=4.25e-12 PD=6.7e-06 PS=6.7e-06 NRD=0.085 NRS=0.085 $X=191650 $Y=11725 $D=38
M7 GNDA GNDA GNDA GNDA nmos4 L=2e-05 W=5e-06 AD=4.25e-12 AS=4.25e-12 PD=6.7e-06 PS=6.7e-06 NRD=0.085 NRS=0.085 $X=191650 $Y=30475 $D=38
M8 9 12 GNDA GNDA nmos4 L=4e-06 W=1e-06 AD=8.5e-13 AS=8.5e-13 PD=2.7e-06 PS=2.7e-06 NRD=0.425 NRS=0.425 $X=45775 $Y=52250 $D=37
M9 12 12 GNDA GNDA nmos4 L=4e-06 W=1e-06 AD=8.5e-13 AS=8.5e-13 PD=2.7e-06 PS=2.7e-06 NRD=0.425 NRS=0.425 $X=48025 $Y=52250 $D=37
M10 9 12 GNDA GNDA nmos4 L=4e-06 W=1e-06 AD=8.5e-13 AS=8.5e-13 PD=2.7e-06 PS=2.7e-06 NRD=0.425 NRS=0.425 $X=50275 $Y=52250 $D=37
M11 9 12 GNDA GNDA nmos4 L=4e-06 W=1e-06 AD=8.5e-13 AS=8.5e-13 PD=2.7e-06 PS=2.7e-06 NRD=0.425 NRS=0.425 $X=52525 $Y=52250 $D=37
M12 12 12 GNDA GNDA nmos4 L=4e-06 W=1e-06 AD=8.5e-13 AS=8.5e-13 PD=2.7e-06 PS=2.7e-06 NRD=0.425 NRS=0.425 $X=54775 $Y=52250 $D=37
M13 9 12 GNDA GNDA nmos4 L=4e-06 W=1e-06 AD=8.5e-13 AS=8.5e-13 PD=2.7e-06 PS=2.7e-06 NRD=0.425 NRS=0.425 $X=57025 $Y=52250 $D=37
M14 9 12 GNDA GNDA nmos4 L=4e-06 W=1e-06 AD=8.5e-13 AS=8.5e-13 PD=2.7e-06 PS=2.7e-06 NRD=0.425 NRS=0.425 $X=59275 $Y=52250 $D=37
M15 12 12 GNDA GNDA nmos4 L=4e-06 W=1e-06 AD=8.5e-13 AS=8.5e-13 PD=2.7e-06 PS=2.7e-06 NRD=0.425 NRS=0.425 $X=61525 $Y=52250 $D=37
M16 9 12 GNDA GNDA nmos4 L=4e-06 W=1e-06 AD=8.5e-13 AS=8.5e-13 PD=2.7e-06 PS=2.7e-06 NRD=0.425 NRS=0.425 $X=63775 $Y=52250 $D=37
M17 9 12 GNDA GNDA nmos4 L=4e-06 W=1e-06 AD=8.5e-13 AS=8.5e-13 PD=2.7e-06 PS=2.7e-06 NRD=0.425 NRS=0.425 $X=66025 $Y=52250 $D=37
M18 12 12 GNDA GNDA nmos4 L=4e-06 W=1e-06 AD=8.5e-13 AS=8.5e-13 PD=2.7e-06 PS=2.7e-06 NRD=0.425 NRS=0.425 $X=68275 $Y=52250 $D=37
M19 9 12 GNDA GNDA nmos4 L=4e-06 W=1e-06 AD=8.5e-13 AS=8.5e-13 PD=2.7e-06 PS=2.7e-06 NRD=0.425 NRS=0.425 $X=70525 $Y=52250 $D=37
M20 Vout 11 GNDA GNDA nmos4 L=2e-06 W=1e-05 AD=5e-12 AS=8.5e-12 PD=1e-06 PS=1.17e-05 NRD=0.0425 NRS=0.0425 $X=191050 $Y=41500 $D=37
M21 GNDA 10 10 GNDA nmos4 L=2e-05 W=5e-06 AD=4.25e-12 AS=4.25e-12 PD=6.7e-06 PS=6.7e-06 NRD=0.085 NRS=0.085 $X=191650 $Y=17975 $D=37
M22 GNDA 10 11 GNDA nmos4 L=2e-05 W=5e-06 AD=4.25e-12 AS=4.25e-12 PD=6.7e-06 PS=6.7e-06 NRD=0.085 NRS=0.085 $X=191650 $Y=24225 $D=37
M23 GNDA 11 Vout GNDA nmos4 L=2e-06 W=1e-05 AD=5e-12 AS=5e-12 PD=1e-06 PS=1e-06 NRD=0.0425 NRS=0.0425 $X=194050 $Y=41500 $D=37
M24 Vout 11 GNDA GNDA nmos4 L=2e-06 W=1e-05 AD=5e-12 AS=5e-12 PD=1e-06 PS=1e-06 NRD=0.0425 NRS=0.0425 $X=197050 $Y=41500 $D=37
M25 GNDA 11 Vout GNDA nmos4 L=2e-06 W=1e-05 AD=5e-12 AS=5e-12 PD=1e-06 PS=1e-06 NRD=0.0425 NRS=0.0425 $X=200050 $Y=41500 $D=37
M26 Vout 11 GNDA GNDA nmos4 L=2e-06 W=1e-05 AD=5e-12 AS=5e-12 PD=1e-06 PS=1e-06 NRD=0.0425 NRS=0.0425 $X=203050 $Y=41500 $D=37
M27 GNDA 11 Vout GNDA nmos4 L=2e-06 W=1e-05 AD=5e-12 AS=5e-12 PD=1e-06 PS=1e-06 NRD=0.0425 NRS=0.0425 $X=206050 $Y=41500 $D=37
M28 Vout 11 GNDA GNDA nmos4 L=2e-06 W=1e-05 AD=5e-12 AS=5e-12 PD=1e-06 PS=1e-06 NRD=0.0425 NRS=0.0425 $X=209050 $Y=41500 $D=37
M29 GNDA 11 Vout GNDA nmos4 L=2e-06 W=1e-05 AD=5e-12 AS=5e-12 PD=1e-06 PS=1e-06 NRD=0.0425 NRS=0.0425 $X=212050 $Y=41500 $D=37
M30 Vout 11 GNDA GNDA nmos4 L=2e-06 W=1e-05 AD=5e-12 AS=5e-12 PD=1e-06 PS=1e-06 NRD=0.0425 NRS=0.0425 $X=215050 $Y=41500 $D=37
M31 GNDA 11 Vout GNDA nmos4 L=2e-06 W=1e-05 AD=8.5e-12 AS=5e-12 PD=1.17e-05 PS=1e-06 NRD=0.0425 NRS=0.0425 $X=218050 $Y=41500 $D=37
M32 VDDA VDDA VDDA VDDA pmos4 L=1e-05 W=1e-06 AD=8.5e-13 AS=8.5e-13 PD=2.7e-06 PS=2.7e-06 NRD=0.425 NRS=0.425 $X=32200 $Y=88550 $D=42
M33 VDDA VDDA VDDA VDDA pmos4 L=1e-05 W=1e-06 AD=8.5e-13 AS=8.5e-13 PD=2.7e-06 PS=2.7e-06 NRD=0.425 NRS=0.425 $X=32200 $Y=156950 $D=42
M34 VDDA VDDA VDDA VDDA pmos4 L=1e-05 W=1e-06 AD=8.5e-13 AS=8.5e-13 PD=2.7e-06 PS=2.7e-06 NRD=0.425 NRS=0.425 $X=44500 $Y=88550 $D=42
M35 VDDA VDDA VDDA VDDA pmos4 L=1e-05 W=1e-06 AD=8.5e-13 AS=8.5e-13 PD=2.7e-06 PS=2.7e-06 NRD=0.425 NRS=0.425 $X=44500 $Y=156950 $D=42
M36 VDDA VDDA VDDA VDDA pmos4 L=1e-05 W=1e-06 AD=8.5e-13 AS=8.5e-13 PD=2.7e-06 PS=2.7e-06 NRD=0.425 NRS=0.425 $X=56800 $Y=88550 $D=42
M37 VDDA VDDA VDDA VDDA pmos4 L=1e-05 W=1e-06 AD=8.5e-13 AS=8.5e-13 PD=2.7e-06 PS=2.7e-06 NRD=0.425 NRS=0.425 $X=56800 $Y=156950 $D=42
M38 VDDA VDDA VDDA VDDA pmos4 L=1e-05 W=1e-06 AD=8.5e-13 AS=8.5e-13 PD=2.7e-06 PS=2.7e-06 NRD=0.425 NRS=0.425 $X=69100 $Y=88550 $D=42
M39 VDDA VDDA VDDA VDDA pmos4 L=1e-05 W=1e-06 AD=8.5e-13 AS=8.5e-13 PD=2.7e-06 PS=2.7e-06 NRD=0.425 NRS=0.425 $X=69100 $Y=156950 $D=42
M40 VDDA VDDA VDDA VDDA pmos4 L=1e-05 W=1e-06 AD=8.5e-13 AS=8.5e-13 PD=2.7e-06 PS=2.7e-06 NRD=0.425 NRS=0.425 $X=81400 $Y=88550 $D=42
M41 VDDA VDDA VDDA VDDA pmos4 L=1e-05 W=1e-06 AD=8.5e-13 AS=8.5e-13 PD=2.7e-06 PS=2.7e-06 NRD=0.425 NRS=0.425 $X=81400 $Y=156950 $D=42
M42 VDDA VDDA VDDA VDDA pmos4 L=1e-05 W=1e-06 AD=8.5e-13 AS=8.5e-13 PD=2.7e-06 PS=2.7e-06 NRD=0.425 NRS=0.425 $X=93700 $Y=88550 $D=42
M43 VDDA VDDA VDDA VDDA pmos4 L=1e-05 W=1e-06 AD=8.5e-13 AS=8.5e-13 PD=2.7e-06 PS=2.7e-06 NRD=0.425 NRS=0.425 $X=93700 $Y=156950 $D=42
M44 VDDA VDDA VDDA VDDA pmos4 L=4e-06 W=1e-05 AD=8.5e-12 AS=8.5e-12 PD=1.17e-05 PS=1.17e-05 NRD=0.0425 NRS=0.0425 $X=93925 $Y=25100 $D=42
M45 VDDA VDDA VDDA VDDA pmos4 L=4e-06 W=1e-05 AD=8.5e-12 AS=8.5e-12 PD=1.17e-05 PS=1.17e-05 NRD=0.0425 NRS=0.0425 $X=93925 $Y=43900 $D=42
M46 VDDA VDDA VDDA VDDA pmos4 L=1e-05 W=1e-06 AD=8.5e-13 AS=8.5e-13 PD=2.7e-06 PS=2.7e-06 NRD=0.425 NRS=0.425 $X=106000 $Y=88550 $D=42
M47 VDDA VDDA VDDA VDDA pmos4 L=1e-05 W=1e-06 AD=8.5e-13 AS=8.5e-13 PD=2.7e-06 PS=2.7e-06 NRD=0.425 NRS=0.425 $X=106000 $Y=156950 $D=42
M48 VDDA VDDA VDDA VDDA pmos4 L=1e-05 W=1e-06 AD=8.5e-13 AS=8.5e-13 PD=2.7e-06 PS=2.7e-06 NRD=0.425 NRS=0.425 $X=118300 $Y=88550 $D=42
M49 VDDA VDDA VDDA VDDA pmos4 L=1e-05 W=1e-06 AD=8.5e-13 AS=8.5e-13 PD=2.7e-06 PS=2.7e-06 NRD=0.425 NRS=0.425 $X=118300 $Y=156950 $D=42
M50 VDDA VDDA VDDA VDDA pmos4 L=1e-05 W=1e-06 AD=8.5e-13 AS=8.5e-13 PD=2.7e-06 PS=2.7e-06 NRD=0.425 NRS=0.425 $X=130600 $Y=88550 $D=42
M51 VDDA VDDA VDDA VDDA pmos4 L=1e-05 W=1e-06 AD=8.5e-13 AS=8.5e-13 PD=2.7e-06 PS=2.7e-06 NRD=0.425 NRS=0.425 $X=130600 $Y=156950 $D=42
M52 VDDA VDDA VDDA VDDA pmos4 L=1e-05 W=1e-06 AD=8.5e-13 AS=8.5e-13 PD=2.7e-06 PS=2.7e-06 NRD=0.425 NRS=0.425 $X=142900 $Y=88550 $D=42
M53 VDDA VDDA VDDA VDDA pmos4 L=1e-05 W=1e-06 AD=8.5e-13 AS=8.5e-13 PD=2.7e-06 PS=2.7e-06 NRD=0.425 NRS=0.425 $X=142900 $Y=156950 $D=42
M54 VDDA VDDA VDDA VDDA pmos4 L=1e-05 W=1e-06 AD=8.5e-13 AS=8.5e-13 PD=2.7e-06 PS=2.7e-06 NRD=0.425 NRS=0.425 $X=155200 $Y=88550 $D=42
M55 VDDA VDDA VDDA VDDA pmos4 L=1e-05 W=1e-06 AD=8.5e-13 AS=8.5e-13 PD=2.7e-06 PS=2.7e-06 NRD=0.425 NRS=0.425 $X=155200 $Y=99950 $D=42
M56 VDDA VDDA VDDA VDDA pmos4 L=1e-05 W=1e-06 AD=8.5e-13 AS=8.5e-13 PD=2.7e-06 PS=2.7e-06 NRD=0.425 NRS=0.425 $X=155200 $Y=111350 $D=42
M57 VDDA VDDA VDDA VDDA pmos4 L=1e-05 W=1e-06 AD=8.5e-13 AS=8.5e-13 PD=2.7e-06 PS=2.7e-06 NRD=0.425 NRS=0.425 $X=155200 $Y=122750 $D=42
M58 VDDA VDDA VDDA VDDA pmos4 L=1e-05 W=1e-06 AD=8.5e-13 AS=8.5e-13 PD=2.7e-06 PS=2.7e-06 NRD=0.425 NRS=0.425 $X=155200 $Y=134150 $D=42
M59 VDDA VDDA VDDA VDDA pmos4 L=1e-05 W=1e-06 AD=8.5e-13 AS=8.5e-13 PD=2.7e-06 PS=2.7e-06 NRD=0.425 NRS=0.425 $X=155200 $Y=145550 $D=42
M60 VDDA VDDA VDDA VDDA pmos4 L=1e-05 W=1e-06 AD=8.5e-13 AS=8.5e-13 PD=2.7e-06 PS=2.7e-06 NRD=0.425 NRS=0.425 $X=155200 $Y=156950 $D=42
M61 VDDA VDDA VDDA VDDA pmos4 L=4e-06 W=1e-05 AD=8.5e-12 AS=8.5e-12 PD=1.17e-05 PS=1.17e-05 NRD=0.0425 NRS=0.0425 $X=163225 $Y=25100 $D=42
M62 VDDA VDDA VDDA VDDA pmos4 L=4e-06 W=1e-05 AD=8.5e-12 AS=8.5e-12 PD=1.17e-05 PS=1.17e-05 NRD=0.0425 NRS=0.0425 $X=163225 $Y=43900 $D=42
M63 Vout 7 VDDA VDDA pmos4 L=1e-05 W=1e-06 AD=8.5e-13 AS=8.5e-13 PD=2.7e-06 PS=2.7e-06 NRD=0.425 NRS=0.425 $X=32200 $Y=99950 $D=41
M64 Vout 7 VDDA VDDA pmos4 L=1e-05 W=1e-06 AD=8.5e-13 AS=8.5e-13 PD=2.7e-06 PS=2.7e-06 NRD=0.425 NRS=0.425 $X=32200 $Y=111350 $D=41
M65 Vout 7 VDDA VDDA pmos4 L=1e-05 W=1e-06 AD=8.5e-13 AS=8.5e-13 PD=2.7e-06 PS=2.7e-06 NRD=0.425 NRS=0.425 $X=32200 $Y=122750 $D=41
M66 Vout 7 VDDA VDDA pmos4 L=1e-05 W=1e-06 AD=8.5e-13 AS=8.5e-13 PD=2.7e-06 PS=2.7e-06 NRD=0.425 NRS=0.425 $X=32200 $Y=134150 $D=41
M67 Vout 7 VDDA VDDA pmos4 L=1e-05 W=1e-06 AD=8.5e-13 AS=8.5e-13 PD=2.7e-06 PS=2.7e-06 NRD=0.425 NRS=0.425 $X=32200 $Y=145550 $D=41
M68 Vout 7 VDDA VDDA pmos4 L=1e-05 W=1e-06 AD=8.5e-13 AS=8.5e-13 PD=2.7e-06 PS=2.7e-06 NRD=0.425 NRS=0.425 $X=44500 $Y=99950 $D=41
M69 Vout 7 VDDA VDDA pmos4 L=1e-05 W=1e-06 AD=8.5e-13 AS=8.5e-13 PD=2.7e-06 PS=2.7e-06 NRD=0.425 NRS=0.425 $X=44500 $Y=111350 $D=41
M70 Vout 7 VDDA VDDA pmos4 L=1e-05 W=1e-06 AD=8.5e-13 AS=8.5e-13 PD=2.7e-06 PS=2.7e-06 NRD=0.425 NRS=0.425 $X=44500 $Y=122750 $D=41
M71 Vout 7 VDDA VDDA pmos4 L=1e-05 W=1e-06 AD=8.5e-13 AS=8.5e-13 PD=2.7e-06 PS=2.7e-06 NRD=0.425 NRS=0.425 $X=44500 $Y=134150 $D=41
M72 Vout 7 VDDA VDDA pmos4 L=1e-05 W=1e-06 AD=8.5e-13 AS=8.5e-13 PD=2.7e-06 PS=2.7e-06 NRD=0.425 NRS=0.425 $X=44500 $Y=145550 $D=41
M73 Vout 7 VDDA VDDA pmos4 L=1e-05 W=1e-06 AD=8.5e-13 AS=8.5e-13 PD=2.7e-06 PS=2.7e-06 NRD=0.425 NRS=0.425 $X=56800 $Y=99950 $D=41
M74 Vout 7 VDDA VDDA pmos4 L=1e-05 W=1e-06 AD=8.5e-13 AS=8.5e-13 PD=2.7e-06 PS=2.7e-06 NRD=0.425 NRS=0.425 $X=56800 $Y=111350 $D=41
M75 8 7 VDDA VDDA pmos4 L=1e-05 W=1e-06 AD=8.5e-13 AS=8.5e-13 PD=2.7e-06 PS=2.7e-06 NRD=0.425 NRS=0.425 $X=56800 $Y=122750 $D=41
M76 Vout 7 VDDA VDDA pmos4 L=1e-05 W=1e-06 AD=8.5e-13 AS=8.5e-13 PD=2.7e-06 PS=2.7e-06 NRD=0.425 NRS=0.425 $X=56800 $Y=134150 $D=41
M77 Vout 7 VDDA VDDA pmos4 L=1e-05 W=1e-06 AD=8.5e-13 AS=8.5e-13 PD=2.7e-06 PS=2.7e-06 NRD=0.425 NRS=0.425 $X=56800 $Y=145550 $D=41
M78 Vout 7 VDDA VDDA pmos4 L=1e-05 W=1e-06 AD=8.5e-13 AS=8.5e-13 PD=2.7e-06 PS=2.7e-06 NRD=0.425 NRS=0.425 $X=69100 $Y=99950 $D=41
M79 Vout 7 VDDA VDDA pmos4 L=1e-05 W=1e-06 AD=8.5e-13 AS=8.5e-13 PD=2.7e-06 PS=2.7e-06 NRD=0.425 NRS=0.425 $X=69100 $Y=111350 $D=41
M80 8 7 VDDA VDDA pmos4 L=1e-05 W=1e-06 AD=8.5e-13 AS=8.5e-13 PD=2.7e-06 PS=2.7e-06 NRD=0.425 NRS=0.425 $X=69100 $Y=122750 $D=41
M81 Vout 7 VDDA VDDA pmos4 L=1e-05 W=1e-06 AD=8.5e-13 AS=8.5e-13 PD=2.7e-06 PS=2.7e-06 NRD=0.425 NRS=0.425 $X=69100 $Y=134150 $D=41
M82 Vout 7 VDDA VDDA pmos4 L=1e-05 W=1e-06 AD=8.5e-13 AS=8.5e-13 PD=2.7e-06 PS=2.7e-06 NRD=0.425 NRS=0.425 $X=69100 $Y=145550 $D=41
M83 Vout 7 VDDA VDDA pmos4 L=1e-05 W=1e-06 AD=8.5e-13 AS=8.5e-13 PD=2.7e-06 PS=2.7e-06 NRD=0.425 NRS=0.425 $X=81400 $Y=99950 $D=41
M84 8 7 VDDA VDDA pmos4 L=1e-05 W=1e-06 AD=8.5e-13 AS=8.5e-13 PD=2.7e-06 PS=2.7e-06 NRD=0.425 NRS=0.425 $X=81400 $Y=111350 $D=41
M85 7 7 VDDA VDDA pmos4 L=1e-05 W=1e-06 AD=8.5e-13 AS=8.5e-13 PD=2.7e-06 PS=2.7e-06 NRD=0.425 NRS=0.425 $X=81400 $Y=122750 $D=41
M86 8 7 VDDA VDDA pmos4 L=1e-05 W=1e-06 AD=8.5e-13 AS=8.5e-13 PD=2.7e-06 PS=2.7e-06 NRD=0.425 NRS=0.425 $X=81400 $Y=134150 $D=41
M87 Vout 7 VDDA VDDA pmos4 L=1e-05 W=1e-06 AD=8.5e-13 AS=8.5e-13 PD=2.7e-06 PS=2.7e-06 NRD=0.425 NRS=0.425 $X=81400 $Y=145550 $D=41
M88 Vout 7 VDDA VDDA pmos4 L=1e-05 W=1e-06 AD=8.5e-13 AS=8.5e-13 PD=2.7e-06 PS=2.7e-06 NRD=0.425 NRS=0.425 $X=93700 $Y=99950 $D=41
M89 8 7 VDDA VDDA pmos4 L=1e-05 W=1e-06 AD=8.5e-13 AS=8.5e-13 PD=2.7e-06 PS=2.7e-06 NRD=0.425 NRS=0.425 $X=93700 $Y=111350 $D=41
M90 7 7 VDDA VDDA pmos4 L=1e-05 W=1e-06 AD=8.5e-13 AS=8.5e-13 PD=2.7e-06 PS=2.7e-06 NRD=0.425 NRS=0.425 $X=93700 $Y=122750 $D=41
M91 8 7 VDDA VDDA pmos4 L=1e-05 W=1e-06 AD=8.5e-13 AS=8.5e-13 PD=2.7e-06 PS=2.7e-06 NRD=0.425 NRS=0.425 $X=93700 $Y=134150 $D=41
M92 Vout 7 VDDA VDDA pmos4 L=1e-05 W=1e-06 AD=8.5e-13 AS=8.5e-13 PD=2.7e-06 PS=2.7e-06 NRD=0.425 NRS=0.425 $X=93700 $Y=145550 $D=41
M93 Vout 7 VDDA VDDA pmos4 L=1e-05 W=1e-06 AD=8.5e-13 AS=8.5e-13 PD=2.7e-06 PS=2.7e-06 NRD=0.425 NRS=0.425 $X=106000 $Y=99950 $D=41
M94 Vout 7 VDDA VDDA pmos4 L=1e-05 W=1e-06 AD=8.5e-13 AS=8.5e-13 PD=2.7e-06 PS=2.7e-06 NRD=0.425 NRS=0.425 $X=106000 $Y=111350 $D=41
M95 8 7 VDDA VDDA pmos4 L=1e-05 W=1e-06 AD=8.5e-13 AS=8.5e-13 PD=2.7e-06 PS=2.7e-06 NRD=0.425 NRS=0.425 $X=106000 $Y=122750 $D=41
M96 Vout 7 VDDA VDDA pmos4 L=1e-05 W=1e-06 AD=8.5e-13 AS=8.5e-13 PD=2.7e-06 PS=2.7e-06 NRD=0.425 NRS=0.425 $X=106000 $Y=134150 $D=41
M97 Vout 7 VDDA VDDA pmos4 L=1e-05 W=1e-06 AD=8.5e-13 AS=8.5e-13 PD=2.7e-06 PS=2.7e-06 NRD=0.425 NRS=0.425 $X=106000 $Y=145550 $D=41
M98 11 Vin+ 8 VDDA pmos4 L=4e-06 W=1e-05 AD=8.5e-12 AS=8.5e-12 PD=1.17e-05 PS=1.17e-05 NRD=0.0425 NRS=0.0425 $X=112825 $Y=25100 $D=41
M99 10 Vin- 8 VDDA pmos4 L=4e-06 W=1e-05 AD=8.5e-12 AS=8.5e-12 PD=1.17e-05 PS=1.17e-05 NRD=0.0425 NRS=0.0425 $X=112825 $Y=43900 $D=41
M100 Vout 7 VDDA VDDA pmos4 L=1e-05 W=1e-06 AD=8.5e-13 AS=8.5e-13 PD=2.7e-06 PS=2.7e-06 NRD=0.425 NRS=0.425 $X=118300 $Y=99950 $D=41
M101 Vout 7 VDDA VDDA pmos4 L=1e-05 W=1e-06 AD=8.5e-13 AS=8.5e-13 PD=2.7e-06 PS=2.7e-06 NRD=0.425 NRS=0.425 $X=118300 $Y=111350 $D=41
M102 8 7 VDDA VDDA pmos4 L=1e-05 W=1e-06 AD=8.5e-13 AS=8.5e-13 PD=2.7e-06 PS=2.7e-06 NRD=0.425 NRS=0.425 $X=118300 $Y=122750 $D=41
M103 Vout 7 VDDA VDDA pmos4 L=1e-05 W=1e-06 AD=8.5e-13 AS=8.5e-13 PD=2.7e-06 PS=2.7e-06 NRD=0.425 NRS=0.425 $X=118300 $Y=134150 $D=41
M104 Vout 7 VDDA VDDA pmos4 L=1e-05 W=1e-06 AD=8.5e-13 AS=8.5e-13 PD=2.7e-06 PS=2.7e-06 NRD=0.425 NRS=0.425 $X=118300 $Y=145550 $D=41
M105 10 Vin- 8 VDDA pmos4 L=4e-06 W=1e-05 AD=8.5e-12 AS=8.5e-12 PD=1.17e-05 PS=1.17e-05 NRD=0.0425 NRS=0.0425 $X=119125 $Y=25100 $D=41
M106 11 Vin+ 8 VDDA pmos4 L=4e-06 W=1e-05 AD=8.5e-12 AS=8.5e-12 PD=1.17e-05 PS=1.17e-05 NRD=0.0425 NRS=0.0425 $X=119125 $Y=43900 $D=41
M107 Vout 7 VDDA VDDA pmos4 L=1e-05 W=1e-06 AD=8.5e-13 AS=8.5e-13 PD=2.7e-06 PS=2.7e-06 NRD=0.425 NRS=0.425 $X=130600 $Y=99950 $D=41
M108 Vout 7 VDDA VDDA pmos4 L=1e-05 W=1e-06 AD=8.5e-13 AS=8.5e-13 PD=2.7e-06 PS=2.7e-06 NRD=0.425 NRS=0.425 $X=130600 $Y=111350 $D=41
M109 Vout 7 VDDA VDDA pmos4 L=1e-05 W=1e-06 AD=8.5e-13 AS=8.5e-13 PD=2.7e-06 PS=2.7e-06 NRD=0.425 NRS=0.425 $X=130600 $Y=122750 $D=41
M110 Vout 7 VDDA VDDA pmos4 L=1e-05 W=1e-06 AD=8.5e-13 AS=8.5e-13 PD=2.7e-06 PS=2.7e-06 NRD=0.425 NRS=0.425 $X=130600 $Y=134150 $D=41
M111 Vout 7 VDDA VDDA pmos4 L=1e-05 W=1e-06 AD=8.5e-13 AS=8.5e-13 PD=2.7e-06 PS=2.7e-06 NRD=0.425 NRS=0.425 $X=130600 $Y=145550 $D=41
M112 11 Vin+ 8 VDDA pmos4 L=4e-06 W=1e-05 AD=8.5e-12 AS=8.5e-12 PD=1.17e-05 PS=1.17e-05 NRD=0.0425 NRS=0.0425 $X=138025 $Y=25100 $D=41
M113 10 Vin- 8 VDDA pmos4 L=4e-06 W=1e-05 AD=8.5e-12 AS=8.5e-12 PD=1.17e-05 PS=1.17e-05 NRD=0.0425 NRS=0.0425 $X=138025 $Y=43900 $D=41
M114 Vout 7 VDDA VDDA pmos4 L=1e-05 W=1e-06 AD=8.5e-13 AS=8.5e-13 PD=2.7e-06 PS=2.7e-06 NRD=0.425 NRS=0.425 $X=142900 $Y=99950 $D=41
M115 Vout 7 VDDA VDDA pmos4 L=1e-05 W=1e-06 AD=8.5e-13 AS=8.5e-13 PD=2.7e-06 PS=2.7e-06 NRD=0.425 NRS=0.425 $X=142900 $Y=111350 $D=41
M116 Vout 7 VDDA VDDA pmos4 L=1e-05 W=1e-06 AD=8.5e-13 AS=8.5e-13 PD=2.7e-06 PS=2.7e-06 NRD=0.425 NRS=0.425 $X=142900 $Y=122750 $D=41
M117 Vout 7 VDDA VDDA pmos4 L=1e-05 W=1e-06 AD=8.5e-13 AS=8.5e-13 PD=2.7e-06 PS=2.7e-06 NRD=0.425 NRS=0.425 $X=142900 $Y=134150 $D=41
M118 Vout 7 VDDA VDDA pmos4 L=1e-05 W=1e-06 AD=8.5e-13 AS=8.5e-13 PD=2.7e-06 PS=2.7e-06 NRD=0.425 NRS=0.425 $X=142900 $Y=145550 $D=41
M119 10 Vin- 8 VDDA pmos4 L=4e-06 W=1e-05 AD=8.5e-12 AS=8.5e-12 PD=1.17e-05 PS=1.17e-05 NRD=0.0425 NRS=0.0425 $X=144325 $Y=25100 $D=41
M120 11 Vin+ 8 VDDA pmos4 L=4e-06 W=1e-05 AD=8.5e-12 AS=8.5e-12 PD=1.17e-05 PS=1.17e-05 NRD=0.0425 NRS=0.0425 $X=144325 $Y=43900 $D=41
X121 Vout 13 cpolyc_CDNS_7804089061213 $T=189400 63300 0 0 $X=188050 $Y=61950
X122 Vout 13 cpolyc_CDNS_7804089061213 $T=189400 121950 0 0 $X=188050 $Y=120600
X123 Vout 13 cpolyc_CDNS_7804089061213 $T=249600 63300 0 0 $X=248250 $Y=61950
X124 Vout 13 cpolyc_CDNS_7804089061213 $T=249600 121950 0 0 $X=248250 $Y=120600
X292 8 11 10 Vin+ Vin- VDDA ICV_6 $T=93075 35100 0 270 $X=91875 $Y=23900
X293 8 10 11 Vin- Vin+ VDDA ICV_6 $T=93075 53900 0 270 $X=91875 $Y=42700
X294 8 11 10 Vin+ Vin- VDDA ICV_6 $T=118275 35100 0 270 $X=117075 $Y=23900
X295 8 10 11 Vin- Vin+ VDDA ICV_6 $T=118275 53900 0 270 $X=117075 $Y=42700
X296 8 11 10 Vin+ Vin- VDDA ICV_6 $T=143475 35100 0 270 $X=142275 $Y=23900
X297 8 10 11 Vin- Vin+ VDDA ICV_6 $T=143475 53900 0 270 $X=142275 $Y=42700
X312 GNDA Ibias cvar_CDNS_7804089061211 $T=3350 13950 1 90 $X=1800 $Y=11675
X313 GNDA 12 cvar_CDNS_7804089061211 $T=48450 13975 0 0 $X=46175 $Y=12425
X314 VDDA ICV_10 $T=19050 89550 0 270 $X=17850 $Y=87350
X315 VDDA ICV_10 $T=19050 100950 0 270 $X=17850 $Y=98750
X316 VDDA ICV_10 $T=19050 112350 0 270 $X=17850 $Y=110150
X317 VDDA ICV_10 $T=19050 123750 0 270 $X=17850 $Y=121550
X318 VDDA ICV_10 $T=19050 135150 0 270 $X=17850 $Y=132950
X319 VDDA ICV_10 $T=19050 146550 0 270 $X=17850 $Y=144350
X320 VDDA ICV_10 $T=19050 157950 0 270 $X=17850 $Y=155750
X323 9 7 Ibias GNDA nmos4_CDNS_780408906121 $T=29250 44700 0 90 $X=8300 $Y=43900
X324 12 Ibias Ibias GNDA nmos4_CDNS_780408906121 $T=29250 53700 0 90 $X=8300 $Y=52900
X325 9 7 Ibias GNDA nmos4_CDNS_780408906121 $T=29250 61900 1 270 $X=8300 $Y=60100
.ENDS
***************************************
.SUBCKT nmos4_CDNS_780408906129 1 2 3 4
** N=4 EP=4 IP=0 FDC=2
M0 2 3 1 4 nmos4 L=1e-06 W=1e-05 AD=5e-12 AS=8.5e-12 PD=1e-06 PS=1.17e-05 NRD=0.0425 NRS=0.0425 $X=0 $Y=850 $D=37
M1 1 3 2 4 nmos4 L=1e-06 W=1e-05 AD=8.5e-12 AS=5e-12 PD=1.17e-05 PS=1e-06 NRD=0.0425 NRS=0.0425 $X=0 $Y=2850 $D=37
.ENDS
***************************************
.SUBCKT pmos4_CDNS_7804089061210 1 2 3 5
** N=5 EP=4 IP=0 FDC=4
M0 2 3 1 5 pmos4 L=1e-06 W=1e-05 AD=5e-12 AS=8.5e-12 PD=1e-06 PS=1.17e-05 NRD=0.0425 NRS=0.0425 $X=0 $Y=850 $D=41
M1 1 3 2 5 pmos4 L=1e-06 W=1e-05 AD=5e-12 AS=5e-12 PD=1e-06 PS=1e-06 NRD=0.0425 NRS=0.0425 $X=0 $Y=2850 $D=41
M2 2 3 1 5 pmos4 L=1e-06 W=1e-05 AD=5e-12 AS=5e-12 PD=1e-06 PS=1e-06 NRD=0.0425 NRS=0.0425 $X=0 $Y=4850 $D=41
M3 1 3 2 5 pmos4 L=1e-06 W=1e-05 AD=8.5e-12 AS=5e-12 PD=1.17e-05 PS=1e-06 NRD=0.0425 NRS=0.0425 $X=0 $Y=6850 $D=41
.ENDS
***************************************
.SUBCKT 7_MUX21 EN VDDA A1 Out A0 GNDA
** N=7 EP=6 IP=22 FDC=16
D0 GNDA VDDA p_nwd AREA=369.675 PJ=78.7 $X=21400 $Y=4200 $D=87
X1 VDDA EN 3 GNDA Inverter $T=2150 8200 0 0 $X=2700 $Y=8225
X2 A0 Out 3 GNDA nmos4_CDNS_780408906129 $T=9950 16950 0 270 $X=9700 $Y=6250
X3 Out A1 EN GNDA nmos4_CDNS_780408906129 $T=15350 6950 1 90 $X=15100 $Y=6250
X4 Out A1 3 VDDA pmos4_CDNS_7804089061210 $T=24150 6950 1 90 $X=22950 $Y=5750
X5 A0 Out EN VDDA pmos4_CDNS_7804089061210 $T=33800 16950 0 270 $X=32600 $Y=5750
.ENDS
***************************************
.SUBCKT P1_C_CDNS_7804089061238
** N=3 EP=0 IP=0 FDC=0
.ENDS
***************************************
.SUBCKT pmos4_CDNS_780408906128
** N=5 EP=0 IP=0 FDC=0
.ENDS
***************************************
.SUBCKT ICV_11
** N=7 EP=0 IP=10 FDC=0
.ENDS
***************************************
.SUBCKT ICV_12 3 4 5 8
** N=9 EP=4 IP=14 FDC=2
M0 4 8 3 3 pmos4 L=1e-05 W=3e-06 AD=2.55e-12 AS=2.55e-12 PD=4.7e-06 PS=4.7e-06 NRD=0.141667 NRS=0.141667 $X=4250 $Y=850 $D=41
M1 5 8 3 3 pmos4 L=1e-05 W=3e-06 AD=2.55e-12 AS=2.55e-12 PD=4.7e-06 PS=4.7e-06 NRD=0.141667 NRS=0.141667 $X=8500 $Y=850 $D=41
.ENDS
***************************************
.SUBCKT ICV_13 3 4 5 6 7 8 11
** N=12 EP=7 IP=18 FDC=6
M0 6 11 3 3 pmos4 L=1e-05 W=3e-06 AD=2.55e-12 AS=2.55e-12 PD=4.7e-06 PS=4.7e-06 NRD=0.141667 NRS=0.141667 $X=12750 $Y=850 $D=41
M1 6 11 3 3 pmos4 L=1e-05 W=3e-06 AD=2.55e-12 AS=2.55e-12 PD=4.7e-06 PS=4.7e-06 NRD=0.141667 NRS=0.141667 $X=17000 $Y=850 $D=41
X2 3 4 5 11 ICV_12 $T=0 0 0 0 $X=-1200 $Y=-1200
X3 3 7 8 11 ICV_12 $T=17000 0 0 0 $X=15800 $Y=-1200
.ENDS
***************************************
.SUBCKT ICV_14 3 4 5 6 7 8 11
** N=12 EP=7 IP=24 FDC=14
M0 6 11 3 3 pmos4 L=1e-05 W=3e-06 AD=2.55e-12 AS=2.55e-12 PD=4.7e-06 PS=4.7e-06 NRD=0.141667 NRS=0.141667 $X=29750 $Y=850 $D=41
M1 6 11 3 3 pmos4 L=1e-05 W=3e-06 AD=2.55e-12 AS=2.55e-12 PD=4.7e-06 PS=4.7e-06 NRD=0.141667 NRS=0.141667 $X=34000 $Y=850 $D=41
X2 3 4 5 5 6 6 11 ICV_13 $T=0 0 0 0 $X=-1200 $Y=-1200
X3 3 6 6 7 7 8 11 ICV_13 $T=34000 0 0 0 $X=32800 $Y=-1200
.ENDS
***************************************
.SUBCKT pmos4_CDNS_780408906120 1 2 3 5
** N=5 EP=4 IP=0 FDC=2
M0 2 3 1 5 pmos4 L=1e-05 W=3e-06 AD=1.5e-12 AS=2.55e-12 PD=1e-06 PS=4.7e-06 NRD=0.141667 NRS=0.141667 $X=0 $Y=850 $D=41
M1 1 3 2 5 pmos4 L=1e-05 W=3e-06 AD=2.55e-12 AS=1.5e-12 PD=4.7e-06 PS=1e-06 NRD=0.141667 NRS=0.141667 $X=0 $Y=11850 $D=41
.ENDS
***************************************
.SUBCKT 7_Calibration_current VDDA Calib_curr curr S<0> S<3> S<2> S<1> GNDA
** N=24 EP=8 IP=199 FDC=153
D0 GNDA VDDA p_nwd AREA=1384.43 PJ=149.7 $X=47050 $Y=47200 $D=87
D1 GNDA VDDA p_nwd AREA=34.54 PJ=24.5 $X=99250 $Y=66450 $D=87
D2 GNDA VDDA p_nwd AREA=33.66 PJ=24.1 $X=117350 $Y=66450 $D=87
D3 GNDA VDDA p_nwd AREA=34.65 PJ=24.55 $X=136175 $Y=66450 $D=87
D4 GNDA VDDA p_nwd AREA=36.74 PJ=25.5 $X=153450 $Y=66450 $D=87
D5 GNDA VDDA p_nwd AREA=16842 PJ=541.1 $X=6850 $Y=82650 $D=87
M6 16 16 16 GNDA nmos4 L=4e-06 W=1e-06 AD=8.5e-13 AS=8.5e-13 PD=2.7e-06 PS=2.7e-06 NRD=0.425 NRS=0.425 $X=14350 $Y=51400 $D=38
M7 16 16 16 GNDA nmos4 L=4e-06 W=1e-06 AD=8.5e-13 AS=8.5e-13 PD=2.7e-06 PS=2.7e-06 NRD=0.425 NRS=0.425 $X=30100 $Y=51400 $D=38
M8 16 16 GNDA GNDA nmos4 L=4e-06 W=1e-06 AD=8.5e-13 AS=8.5e-13 PD=2.7e-06 PS=2.7e-06 NRD=0.425 NRS=0.425 $X=16600 $Y=51400 $D=37
M9 15 16 GNDA GNDA nmos4 L=4e-06 W=1e-06 AD=8.5e-13 AS=8.5e-13 PD=2.7e-06 PS=2.7e-06 NRD=0.425 NRS=0.425 $X=18850 $Y=51400 $D=37
M10 16 16 GNDA GNDA nmos4 L=4e-06 W=1e-06 AD=8.5e-13 AS=8.5e-13 PD=2.7e-06 PS=2.7e-06 NRD=0.425 NRS=0.425 $X=21100 $Y=51400 $D=37
M11 16 16 GNDA GNDA nmos4 L=4e-06 W=1e-06 AD=8.5e-13 AS=8.5e-13 PD=2.7e-06 PS=2.7e-06 NRD=0.425 NRS=0.425 $X=23350 $Y=51400 $D=37
M12 15 16 GNDA GNDA nmos4 L=4e-06 W=1e-06 AD=8.5e-13 AS=8.5e-13 PD=2.7e-06 PS=2.7e-06 NRD=0.425 NRS=0.425 $X=25600 $Y=51400 $D=37
M13 16 16 GNDA GNDA nmos4 L=4e-06 W=1e-06 AD=8.5e-13 AS=8.5e-13 PD=2.7e-06 PS=2.7e-06 NRD=0.425 NRS=0.425 $X=27850 $Y=51400 $D=37
M14 17 S<0> Calib_curr GNDA nmos4 L=1e-06 W=5e-06 AD=2.5e-12 AS=4.25e-12 PD=1e-06 PS=6.7e-06 NRD=0.085 NRS=0.085 $X=100300 $Y=72700 $D=37
M15 Calib_curr S<0> 17 GNDA nmos4 L=1e-06 W=5e-06 AD=4.25e-12 AS=2.5e-12 PD=6.7e-06 PS=1e-06 NRD=0.085 NRS=0.085 $X=102300 $Y=72700 $D=37
M16 13 13 13 VDDA pmos4 L=1e-05 W=3e-06 AD=2.55e-12 AS=2.55e-12 PD=4.7e-06 PS=4.7e-06 NRD=0.141667 NRS=0.141667 $X=26200 $Y=102825 $D=42
M17 13 13 13 VDDA pmos4 L=1e-05 W=3e-06 AD=2.55e-12 AS=2.55e-12 PD=4.7e-06 PS=4.7e-06 NRD=0.141667 NRS=0.141667 $X=26200 $Y=126025 $D=42
M18 13 13 13 VDDA pmos4 L=1e-05 W=3e-06 AD=2.55e-12 AS=2.55e-12 PD=4.7e-06 PS=4.7e-06 NRD=0.141667 NRS=0.141667 $X=26200 $Y=149575 $D=42
M19 13 13 13 VDDA pmos4 L=1e-05 W=3e-06 AD=2.55e-12 AS=2.55e-12 PD=4.7e-06 PS=4.7e-06 NRD=0.141667 NRS=0.141667 $X=157950 $Y=102825 $D=42
M20 13 13 13 VDDA pmos4 L=1e-05 W=3e-06 AD=2.55e-12 AS=2.55e-12 PD=4.7e-06 PS=4.7e-06 NRD=0.141667 NRS=0.141667 $X=157950 $Y=126025 $D=42
M21 13 13 13 VDDA pmos4 L=1e-05 W=3e-06 AD=2.55e-12 AS=2.55e-12 PD=4.7e-06 PS=4.7e-06 NRD=0.141667 NRS=0.141667 $X=157950 $Y=149575 $D=42
M22 10 13 VDDA VDDA pmos4 L=1e-05 W=3e-06 AD=2.55e-12 AS=2.55e-12 PD=4.7e-06 PS=4.7e-06 NRD=0.141667 NRS=0.141667 $X=89950 $Y=102825 $D=41
M23 13 13 VDDA VDDA pmos4 L=1e-05 W=3e-06 AD=2.55e-12 AS=2.55e-12 PD=4.7e-06 PS=4.7e-06 NRD=0.141667 NRS=0.141667 $X=89950 $Y=126025 $D=41
M24 VDDA 13 10 VDDA pmos4 L=1e-05 W=3e-06 AD=2.55e-12 AS=2.55e-12 PD=4.7e-06 PS=4.7e-06 NRD=0.141667 NRS=0.141667 $X=89950 $Y=149575 $D=41
M25 10 13 VDDA VDDA pmos4 L=1e-05 W=3e-06 AD=2.55e-12 AS=2.55e-12 PD=4.7e-06 PS=4.7e-06 NRD=0.141667 NRS=0.141667 $X=94200 $Y=102825 $D=41
M26 13 13 VDDA VDDA pmos4 L=1e-05 W=3e-06 AD=2.55e-12 AS=2.55e-12 PD=4.7e-06 PS=4.7e-06 NRD=0.141667 NRS=0.141667 $X=94200 $Y=126025 $D=41
M27 VDDA 13 10 VDDA pmos4 L=1e-05 W=3e-06 AD=2.55e-12 AS=2.55e-12 PD=4.7e-06 PS=4.7e-06 NRD=0.141667 NRS=0.141667 $X=94200 $Y=149575 $D=41
M28 Calib_curr 21 17 VDDA pmos4 L=1e-06 W=2e-06 AD=1.7e-12 AS=1.7e-12 PD=3.7e-06 PS=3.7e-06 NRD=0.2125 NRS=0.2125 $X=101300 $Y=67650 $D=41
M29 18 22 Calib_curr VDDA pmos4 L=1e-06 W=2e-06 AD=1.7e-12 AS=1.7e-12 PD=3.7e-06 PS=3.7e-06 NRD=0.2125 NRS=0.2125 $X=119400 $Y=67650 $D=41
M30 19 23 Calib_curr VDDA pmos4 L=1e-06 W=2e-06 AD=1.7e-12 AS=1.7e-12 PD=3.7e-06 PS=3.7e-06 NRD=0.2125 NRS=0.2125 $X=138225 $Y=67650 $D=41
M31 20 24 Calib_curr VDDA pmos4 L=1e-06 W=2e-06 AD=1.7e-12 AS=1.7e-12 PD=3.7e-06 PS=3.7e-06 NRD=0.2125 NRS=0.2125 $X=155500 $Y=67650 $D=41
X32 Calib_curr 18 S<3> GNDA nmos4_CDNS_780408906124 $T=118550 77350 0 270 $X=118300 $Y=71950
X33 Calib_curr 19 S<2> GNDA nmos4_CDNS_780408906124 $T=137375 77350 0 270 $X=137125 $Y=71950
X34 Calib_curr 20 S<1> GNDA nmos4_CDNS_780408906124 $T=154650 77350 0 270 $X=154400 $Y=71950
X39 VDDA S<0> 21 GNDA Inverter $T=91450 67550 0 0 $X=92000 $Y=67575
X40 VDDA S<3> 22 GNDA Inverter $T=108850 67550 0 0 $X=109400 $Y=67575
X41 VDDA S<2> 23 GNDA Inverter $T=128600 67550 0 0 $X=129150 $Y=67575
X42 VDDA S<1> 24 GNDA Inverter $T=145200 67550 0 0 $X=145750 $Y=67575
X47 16 curr curr GNDA nmos4_CDNS_780408906121 $T=19250 69850 0 270 $X=19000 $Y=68050
X48 15 14 curr GNDA nmos4_CDNS_780408906121 $T=19250 73450 0 270 $X=19000 $Y=71650
X49 16 curr curr GNDA nmos4_CDNS_780408906121 $T=19250 77050 0 270 $X=19000 $Y=75250
X56 VDDA 10 10 10 10 10 13 ICV_14 $T=26200 101975 0 0 $X=25000 $Y=100775
X57 VDDA 12 12 12 11 9 13 ICV_14 $T=26200 125175 0 0 $X=25000 $Y=123975
X58 VDDA 10 10 10 10 10 13 ICV_14 $T=26200 160425 1 0 $X=25000 $Y=147525
X59 VDDA 10 10 10 10 10 13 ICV_14 $T=94200 101975 0 0 $X=93000 $Y=100775
X60 VDDA 9 11 12 12 12 13 ICV_14 $T=94200 125175 0 0 $X=93000 $Y=123975
X61 VDDA 10 10 10 10 10 13 ICV_14 $T=94200 160425 1 0 $X=93000 $Y=147525
X62 12 20 14 VDDA pmos4_CDNS_780408906120 $T=52375 75250 1 0 $X=51175 $Y=51350
X63 11 19 14 VDDA pmos4_CDNS_780408906120 $T=59325 75250 1 0 $X=58125 $Y=51350
X64 13 14 14 VDDA pmos4_CDNS_780408906120 $T=66275 75250 1 0 $X=65075 $Y=51350
X65 9 18 14 VDDA pmos4_CDNS_780408906120 $T=73225 75250 1 0 $X=72025 $Y=51350
X66 10 17 14 VDDA pmos4_CDNS_780408906120 $T=80175 75250 1 0 $X=78975 $Y=51350
.ENDS
***************************************
.SUBCKT P1_C_CDNS_78040890612130
** N=3 EP=0 IP=0 FDC=0
.ENDS
***************************************
.SUBCKT ND_C_CDNS_78040890612141
** N=2 EP=0 IP=0 FDC=0
.ENDS
***************************************
.SUBCKT P1_C_CDNS_78040890612129
** N=2 EP=0 IP=0 FDC=0
.ENDS
***************************************
.SUBCKT P1_C_CDNS_78040890612135
** N=1 EP=0 IP=0 FDC=0
.ENDS
***************************************
.SUBCKT ICV_15 1 2 3 4
** N=4 EP=4 IP=8 FDC=2
M0 2 4 1 1 nmos4 L=4e-06 W=1e-06 AD=8.5e-13 AS=8.5e-13 PD=2.7e-06 PS=2.7e-06 NRD=0.425 NRS=0.425 $X=0 $Y=-5450 $D=37
M1 3 4 1 1 nmos4 L=4e-06 W=1e-06 AD=8.5e-13 AS=8.5e-13 PD=2.7e-06 PS=2.7e-06 NRD=0.425 NRS=0.425 $X=0 $Y=850 $D=37
.ENDS
***************************************
.SUBCKT ICV_16 1 2 3 4 5
** N=6 EP=5 IP=26 FDC=8
M0 1 1 1 1 pmos4 L=4e-06 W=1e-05 AD=8.5e-12 AS=8.5e-12 PD=1.17e-05 PS=1.17e-05 NRD=0.0425 NRS=0.0425 $X=0 $Y=850 $D=42
M1 2 4 1 1 pmos4 L=4e-06 W=1e-05 AD=8.5e-12 AS=8.5e-12 PD=1.17e-05 PS=1.17e-05 NRD=0.0425 NRS=0.0425 $X=0 $Y=19750 $D=41
M2 3 5 1 1 pmos4 L=4e-06 W=1e-05 AD=8.5e-12 AS=8.5e-12 PD=1.17e-05 PS=1.17e-05 NRD=0.0425 NRS=0.0425 $X=0 $Y=26050 $D=41
M3 2 4 1 1 pmos4 L=4e-06 W=1e-05 AD=8.5e-12 AS=8.5e-12 PD=1.17e-05 PS=1.17e-05 NRD=0.0425 NRS=0.0425 $X=0 $Y=44950 $D=41
X4 1 2 3 4 5 1 ICV_6 $T=0 0 0 0 $X=-1200 $Y=-1200
X5 1 2 3 4 5 1 ICV_6 $T=0 25200 0 0 $X=-1200 $Y=24000
.ENDS
***************************************
.SUBCKT pmos4_CDNS_7804089061221
** N=4 EP=0 IP=0 FDC=0
.ENDS
***************************************
.SUBCKT ICV_17
** N=6 EP=0 IP=8 FDC=0
.ENDS
***************************************
.SUBCKT ICV_18
** N=9 EP=0 IP=12 FDC=0
.ENDS
***************************************
.SUBCKT ICV_19 1
** N=8 EP=1 IP=27 FDC=2
M0 1 1 1 1 pmos4 L=1e-05 W=2e-06 AD=1.7e-12 AS=1.7e-12 PD=3.7e-06 PS=3.7e-06 NRD=0.2125 NRS=0.2125 $X=0 $Y=850 $D=42
M1 1 1 1 1 pmos4 L=1e-05 W=2e-06 AD=1.7e-12 AS=1.7e-12 PD=3.7e-06 PS=3.7e-06 NRD=0.2125 NRS=0.2125 $X=0 $Y=136150 $D=42
.ENDS
***************************************
.SUBCKT 6_CA_Front_Layout GNDA Vout VDDA Ibias Vin- Vin+
** N=13 EP=6 IP=420 FDC=152
R0 5 11 L=9.01902e-05 W=2e-06 $[rpolyh] $X=125725 $Y=12550 $D=17
M1 Ibias GNDA Ibias GNDA cvar w=0.0002112 l=6.5e-07 cols=16 rows=2 $X=29925 $Y=26950 $D=62
D2 GNDA Ibias p_nwd AREA=426.58 PJ=86.2 $X=29625 $Y=26650 $D=87
D3 GNDA 8 p_nwd AREA=5058.12 PJ=304.9 $X=7150 $Y=45100 $D=87
D4 GNDA GNDA p_nwd AREA=5519.48 PJ=302.1 $X=121050 $Y=6900 $D=87
D5 GNDA VDDA p_nwd AREA=23782.7 PJ=626.3 $X=2150 $Y=97000 $D=87
M6 GNDA GNDA GNDA GNDA nmos4 L=2e-05 W=5e-06 AD=4.25e-12 AS=4.25e-12 PD=6.7e-06 PS=6.7e-06 NRD=0.085 NRS=0.085 $X=61350 $Y=19875 $D=38
M7 GNDA GNDA GNDA GNDA nmos4 L=2e-05 W=5e-06 AD=4.25e-12 AS=4.25e-12 PD=6.7e-06 PS=6.7e-06 NRD=0.085 NRS=0.085 $X=80100 $Y=19875 $D=38
M8 5 6 GNDA GNDA nmos4 L=2e-05 W=5e-06 AD=4.25e-12 AS=4.25e-12 PD=6.7e-06 PS=6.7e-06 NRD=0.085 NRS=0.085 $X=67600 $Y=19875 $D=37
M9 6 6 GNDA GNDA nmos4 L=2e-05 W=5e-06 AD=4.25e-12 AS=4.25e-12 PD=6.7e-06 PS=6.7e-06 NRD=0.085 NRS=0.085 $X=73850 $Y=19875 $D=37
M10 GNDA 5 Vout GNDA nmos4 L=4e-06 W=2e-05 AD=1e-11 AS=1.7e-11 PD=1e-06 PS=2.17e-05 NRD=0.02125 NRS=0.02125 $X=91450 $Y=14975 $D=37
M11 Vout 5 GNDA GNDA nmos4 L=4e-06 W=2e-05 AD=1e-11 AS=1e-11 PD=1e-06 PS=1e-06 NRD=0.02125 NRS=0.02125 $X=96450 $Y=14975 $D=37
M12 GNDA 5 Vout GNDA nmos4 L=4e-06 W=2e-05 AD=1e-11 AS=1e-11 PD=1e-06 PS=1e-06 NRD=0.02125 NRS=0.02125 $X=101450 $Y=14975 $D=37
M13 Vout 5 GNDA GNDA nmos4 L=4e-06 W=2e-05 AD=1e-11 AS=1e-11 PD=1e-06 PS=1e-06 NRD=0.02125 NRS=0.02125 $X=106450 $Y=14975 $D=37
M14 GNDA 5 Vout GNDA nmos4 L=4e-06 W=2e-05 AD=1.7e-11 AS=1e-11 PD=2.17e-05 PS=1e-06 NRD=0.02125 NRS=0.02125 $X=111450 $Y=14975 $D=37
M15 VDDA VDDA VDDA VDDA pmos4 L=1e-05 W=2e-06 AD=1.7e-12 AS=1.7e-12 PD=3.7e-06 PS=3.7e-06 NRD=0.2125 NRS=0.2125 $X=33625 $Y=117350 $D=42
M16 VDDA VDDA VDDA VDDA pmos4 L=1e-05 W=2e-06 AD=1.7e-12 AS=1.7e-12 PD=3.7e-06 PS=3.7e-06 NRD=0.2125 NRS=0.2125 $X=33625 $Y=204150 $D=42
M17 VDDA VDDA VDDA VDDA pmos4 L=1e-05 W=2e-06 AD=1.7e-12 AS=1.7e-12 PD=3.7e-06 PS=3.7e-06 NRD=0.2125 NRS=0.2125 $X=45925 $Y=117350 $D=42
M18 VDDA VDDA VDDA VDDA pmos4 L=1e-05 W=2e-06 AD=1.7e-12 AS=1.7e-12 PD=3.7e-06 PS=3.7e-06 NRD=0.2125 NRS=0.2125 $X=45925 $Y=204150 $D=42
M19 VDDA VDDA VDDA VDDA pmos4 L=1e-05 W=2e-06 AD=1.7e-12 AS=1.7e-12 PD=3.7e-06 PS=3.7e-06 NRD=0.2125 NRS=0.2125 $X=58225 $Y=117350 $D=42
M20 VDDA VDDA VDDA VDDA pmos4 L=1e-05 W=2e-06 AD=1.7e-12 AS=1.7e-12 PD=3.7e-06 PS=3.7e-06 NRD=0.2125 NRS=0.2125 $X=58225 $Y=204150 $D=42
M21 VDDA VDDA VDDA VDDA pmos4 L=1e-05 W=2e-06 AD=1.7e-12 AS=1.7e-12 PD=3.7e-06 PS=3.7e-06 NRD=0.2125 NRS=0.2125 $X=70525 $Y=117350 $D=42
M22 VDDA VDDA VDDA VDDA pmos4 L=1e-05 W=2e-06 AD=1.7e-12 AS=1.7e-12 PD=3.7e-06 PS=3.7e-06 NRD=0.2125 NRS=0.2125 $X=70525 $Y=204150 $D=42
M23 VDDA VDDA VDDA VDDA pmos4 L=1e-05 W=2e-06 AD=1.7e-12 AS=1.7e-12 PD=3.7e-06 PS=3.7e-06 NRD=0.2125 NRS=0.2125 $X=82825 $Y=117350 $D=42
M24 VDDA VDDA VDDA VDDA pmos4 L=1e-05 W=2e-06 AD=1.7e-12 AS=1.7e-12 PD=3.7e-06 PS=3.7e-06 NRD=0.2125 NRS=0.2125 $X=82825 $Y=204150 $D=42
M25 8 8 8 8 pmos4 L=4e-06 W=1e-05 AD=8.5e-12 AS=8.5e-12 PD=1.17e-05 PS=1.17e-05 NRD=0.0425 NRS=0.0425 $X=91625 $Y=56425 $D=42
M26 8 8 8 8 pmos4 L=4e-06 W=1e-05 AD=8.5e-12 AS=8.5e-12 PD=1.17e-05 PS=1.17e-05 NRD=0.0425 NRS=0.0425 $X=91625 $Y=72575 $D=42
M27 VDDA VDDA VDDA VDDA pmos4 L=1e-05 W=2e-06 AD=1.7e-12 AS=1.7e-12 PD=3.7e-06 PS=3.7e-06 NRD=0.2125 NRS=0.2125 $X=95125 $Y=117350 $D=42
M28 VDDA VDDA VDDA VDDA pmos4 L=1e-05 W=2e-06 AD=1.7e-12 AS=1.7e-12 PD=3.7e-06 PS=3.7e-06 NRD=0.2125 NRS=0.2125 $X=95125 $Y=204150 $D=42
M29 VDDA VDDA VDDA VDDA pmos4 L=1e-05 W=2e-06 AD=1.7e-12 AS=1.7e-12 PD=3.7e-06 PS=3.7e-06 NRD=0.2125 NRS=0.2125 $X=107425 $Y=117350 $D=42
M30 VDDA VDDA VDDA VDDA pmos4 L=1e-05 W=2e-06 AD=1.7e-12 AS=1.7e-12 PD=3.7e-06 PS=3.7e-06 NRD=0.2125 NRS=0.2125 $X=107425 $Y=204150 $D=42
M31 VDDA VDDA VDDA VDDA pmos4 L=1e-05 W=2e-06 AD=1.7e-12 AS=1.7e-12 PD=3.7e-06 PS=3.7e-06 NRD=0.2125 NRS=0.2125 $X=119725 $Y=117350 $D=42
M32 VDDA VDDA VDDA VDDA pmos4 L=1e-05 W=2e-06 AD=1.7e-12 AS=1.7e-12 PD=3.7e-06 PS=3.7e-06 NRD=0.2125 NRS=0.2125 $X=119725 $Y=204150 $D=42
M33 VDDA VDDA VDDA VDDA pmos4 L=1e-05 W=2e-06 AD=1.7e-12 AS=1.7e-12 PD=3.7e-06 PS=3.7e-06 NRD=0.2125 NRS=0.2125 $X=132025 $Y=117350 $D=42
M34 VDDA VDDA VDDA VDDA pmos4 L=1e-05 W=2e-06 AD=1.7e-12 AS=1.7e-12 PD=3.7e-06 PS=3.7e-06 NRD=0.2125 NRS=0.2125 $X=132025 $Y=204150 $D=42
M35 VDDA VDDA VDDA VDDA pmos4 L=1e-05 W=2e-06 AD=1.7e-12 AS=1.7e-12 PD=3.7e-06 PS=3.7e-06 NRD=0.2125 NRS=0.2125 $X=144325 $Y=117350 $D=42
M36 VDDA VDDA VDDA VDDA pmos4 L=1e-05 W=2e-06 AD=1.7e-12 AS=1.7e-12 PD=3.7e-06 PS=3.7e-06 NRD=0.2125 NRS=0.2125 $X=144325 $Y=204150 $D=42
M37 Vout 2 VDDA VDDA pmos4 L=1e-05 W=2e-06 AD=1.7e-12 AS=1.7e-12 PD=3.7e-06 PS=3.7e-06 NRD=0.2125 NRS=0.2125 $X=33625 $Y=129750 $D=41
M38 Vout 2 VDDA VDDA pmos4 L=1e-05 W=2e-06 AD=1.7e-12 AS=1.7e-12 PD=3.7e-06 PS=3.7e-06 NRD=0.2125 NRS=0.2125 $X=33625 $Y=142150 $D=41
M39 Vout 2 VDDA VDDA pmos4 L=1e-05 W=2e-06 AD=1.7e-12 AS=1.7e-12 PD=3.7e-06 PS=3.7e-06 NRD=0.2125 NRS=0.2125 $X=33625 $Y=154550 $D=41
M40 Vout 2 VDDA VDDA pmos4 L=1e-05 W=2e-06 AD=1.7e-12 AS=1.7e-12 PD=3.7e-06 PS=3.7e-06 NRD=0.2125 NRS=0.2125 $X=33625 $Y=166950 $D=41
M41 Vout 2 VDDA VDDA pmos4 L=1e-05 W=2e-06 AD=1.7e-12 AS=1.7e-12 PD=3.7e-06 PS=3.7e-06 NRD=0.2125 NRS=0.2125 $X=33625 $Y=179350 $D=41
M42 Vout 2 VDDA VDDA pmos4 L=1e-05 W=2e-06 AD=1.7e-12 AS=1.7e-12 PD=3.7e-06 PS=3.7e-06 NRD=0.2125 NRS=0.2125 $X=33625 $Y=191750 $D=41
M43 Vout 2 VDDA VDDA pmos4 L=1e-05 W=2e-06 AD=1.7e-12 AS=1.7e-12 PD=3.7e-06 PS=3.7e-06 NRD=0.2125 NRS=0.2125 $X=45925 $Y=129750 $D=41
M44 Vout 2 VDDA VDDA pmos4 L=1e-05 W=2e-06 AD=1.7e-12 AS=1.7e-12 PD=3.7e-06 PS=3.7e-06 NRD=0.2125 NRS=0.2125 $X=45925 $Y=142150 $D=41
M45 Vout 2 VDDA VDDA pmos4 L=1e-05 W=2e-06 AD=1.7e-12 AS=1.7e-12 PD=3.7e-06 PS=3.7e-06 NRD=0.2125 NRS=0.2125 $X=45925 $Y=154550 $D=41
M46 Vout 2 VDDA VDDA pmos4 L=1e-05 W=2e-06 AD=1.7e-12 AS=1.7e-12 PD=3.7e-06 PS=3.7e-06 NRD=0.2125 NRS=0.2125 $X=45925 $Y=166950 $D=41
M47 Vout 2 VDDA VDDA pmos4 L=1e-05 W=2e-06 AD=1.7e-12 AS=1.7e-12 PD=3.7e-06 PS=3.7e-06 NRD=0.2125 NRS=0.2125 $X=45925 $Y=179350 $D=41
M48 Vout 2 VDDA VDDA pmos4 L=1e-05 W=2e-06 AD=1.7e-12 AS=1.7e-12 PD=3.7e-06 PS=3.7e-06 NRD=0.2125 NRS=0.2125 $X=45925 $Y=191750 $D=41
M49 Vout 2 VDDA VDDA pmos4 L=1e-05 W=2e-06 AD=1.7e-12 AS=1.7e-12 PD=3.7e-06 PS=3.7e-06 NRD=0.2125 NRS=0.2125 $X=58225 $Y=129750 $D=41
M50 Vout 2 VDDA VDDA pmos4 L=1e-05 W=2e-06 AD=1.7e-12 AS=1.7e-12 PD=3.7e-06 PS=3.7e-06 NRD=0.2125 NRS=0.2125 $X=58225 $Y=142150 $D=41
M51 Vout 2 VDDA VDDA pmos4 L=1e-05 W=2e-06 AD=1.7e-12 AS=1.7e-12 PD=3.7e-06 PS=3.7e-06 NRD=0.2125 NRS=0.2125 $X=58225 $Y=154550 $D=41
M52 Vout 2 VDDA VDDA pmos4 L=1e-05 W=2e-06 AD=1.7e-12 AS=1.7e-12 PD=3.7e-06 PS=3.7e-06 NRD=0.2125 NRS=0.2125 $X=58225 $Y=166950 $D=41
M53 Vout 2 VDDA VDDA pmos4 L=1e-05 W=2e-06 AD=1.7e-12 AS=1.7e-12 PD=3.7e-06 PS=3.7e-06 NRD=0.2125 NRS=0.2125 $X=58225 $Y=179350 $D=41
M54 Vout 2 VDDA VDDA pmos4 L=1e-05 W=2e-06 AD=1.7e-12 AS=1.7e-12 PD=3.7e-06 PS=3.7e-06 NRD=0.2125 NRS=0.2125 $X=58225 $Y=191750 $D=41
M55 Vout 2 VDDA VDDA pmos4 L=1e-05 W=2e-06 AD=1.7e-12 AS=1.7e-12 PD=3.7e-06 PS=3.7e-06 NRD=0.2125 NRS=0.2125 $X=70525 $Y=129750 $D=41
M56 Vout 2 VDDA VDDA pmos4 L=1e-05 W=2e-06 AD=1.7e-12 AS=1.7e-12 PD=3.7e-06 PS=3.7e-06 NRD=0.2125 NRS=0.2125 $X=70525 $Y=142150 $D=41
M57 8 2 VDDA VDDA pmos4 L=1e-05 W=2e-06 AD=1.7e-12 AS=1.7e-12 PD=3.7e-06 PS=3.7e-06 NRD=0.2125 NRS=0.2125 $X=70525 $Y=154550 $D=41
M58 Vout 2 VDDA VDDA pmos4 L=1e-05 W=2e-06 AD=1.7e-12 AS=1.7e-12 PD=3.7e-06 PS=3.7e-06 NRD=0.2125 NRS=0.2125 $X=70525 $Y=166950 $D=41
M59 Vout 2 VDDA VDDA pmos4 L=1e-05 W=2e-06 AD=1.7e-12 AS=1.7e-12 PD=3.7e-06 PS=3.7e-06 NRD=0.2125 NRS=0.2125 $X=70525 $Y=179350 $D=41
M60 Vout 2 VDDA VDDA pmos4 L=1e-05 W=2e-06 AD=1.7e-12 AS=1.7e-12 PD=3.7e-06 PS=3.7e-06 NRD=0.2125 NRS=0.2125 $X=70525 $Y=191750 $D=41
M61 6 Vin- 8 8 pmos4 L=4e-06 W=1e-05 AD=8.5e-12 AS=8.5e-12 PD=1.17e-05 PS=1.17e-05 NRD=0.0425 NRS=0.0425 $X=72725 $Y=56425 $D=41
M62 5 Vin+ 8 8 pmos4 L=4e-06 W=1e-05 AD=8.5e-12 AS=8.5e-12 PD=1.17e-05 PS=1.17e-05 NRD=0.0425 NRS=0.0425 $X=72725 $Y=72575 $D=41
M63 Vout 2 VDDA VDDA pmos4 L=1e-05 W=2e-06 AD=1.7e-12 AS=1.7e-12 PD=3.7e-06 PS=3.7e-06 NRD=0.2125 NRS=0.2125 $X=82825 $Y=129750 $D=41
M64 8 2 VDDA VDDA pmos4 L=1e-05 W=2e-06 AD=1.7e-12 AS=1.7e-12 PD=3.7e-06 PS=3.7e-06 NRD=0.2125 NRS=0.2125 $X=82825 $Y=142150 $D=41
M65 2 2 VDDA VDDA pmos4 L=1e-05 W=2e-06 AD=1.7e-12 AS=1.7e-12 PD=3.7e-06 PS=3.7e-06 NRD=0.2125 NRS=0.2125 $X=82825 $Y=154550 $D=41
M66 8 2 VDDA VDDA pmos4 L=1e-05 W=2e-06 AD=1.7e-12 AS=1.7e-12 PD=3.7e-06 PS=3.7e-06 NRD=0.2125 NRS=0.2125 $X=82825 $Y=166950 $D=41
M67 8 2 VDDA VDDA pmos4 L=1e-05 W=2e-06 AD=1.7e-12 AS=1.7e-12 PD=3.7e-06 PS=3.7e-06 NRD=0.2125 NRS=0.2125 $X=82825 $Y=179350 $D=41
M68 Vout 2 VDDA VDDA pmos4 L=1e-05 W=2e-06 AD=1.7e-12 AS=1.7e-12 PD=3.7e-06 PS=3.7e-06 NRD=0.2125 NRS=0.2125 $X=82825 $Y=191750 $D=41
M69 Vout 2 VDDA VDDA pmos4 L=1e-05 W=2e-06 AD=1.7e-12 AS=1.7e-12 PD=3.7e-06 PS=3.7e-06 NRD=0.2125 NRS=0.2125 $X=95125 $Y=129750 $D=41
M70 8 2 VDDA VDDA pmos4 L=1e-05 W=2e-06 AD=1.7e-12 AS=1.7e-12 PD=3.7e-06 PS=3.7e-06 NRD=0.2125 NRS=0.2125 $X=95125 $Y=142150 $D=41
M71 8 2 VDDA VDDA pmos4 L=1e-05 W=2e-06 AD=1.7e-12 AS=1.7e-12 PD=3.7e-06 PS=3.7e-06 NRD=0.2125 NRS=0.2125 $X=95125 $Y=154550 $D=41
M72 2 2 VDDA VDDA pmos4 L=1e-05 W=2e-06 AD=1.7e-12 AS=1.7e-12 PD=3.7e-06 PS=3.7e-06 NRD=0.2125 NRS=0.2125 $X=95125 $Y=166950 $D=41
M73 8 2 VDDA VDDA pmos4 L=1e-05 W=2e-06 AD=1.7e-12 AS=1.7e-12 PD=3.7e-06 PS=3.7e-06 NRD=0.2125 NRS=0.2125 $X=95125 $Y=179350 $D=41
M74 Vout 2 VDDA VDDA pmos4 L=1e-05 W=2e-06 AD=1.7e-12 AS=1.7e-12 PD=3.7e-06 PS=3.7e-06 NRD=0.2125 NRS=0.2125 $X=95125 $Y=191750 $D=41
M75 Vout 2 VDDA VDDA pmos4 L=1e-05 W=2e-06 AD=1.7e-12 AS=1.7e-12 PD=3.7e-06 PS=3.7e-06 NRD=0.2125 NRS=0.2125 $X=107425 $Y=129750 $D=41
M76 Vout 2 VDDA VDDA pmos4 L=1e-05 W=2e-06 AD=1.7e-12 AS=1.7e-12 PD=3.7e-06 PS=3.7e-06 NRD=0.2125 NRS=0.2125 $X=107425 $Y=142150 $D=41
M77 Vout 2 VDDA VDDA pmos4 L=1e-05 W=2e-06 AD=1.7e-12 AS=1.7e-12 PD=3.7e-06 PS=3.7e-06 NRD=0.2125 NRS=0.2125 $X=107425 $Y=154550 $D=41
M78 8 2 VDDA VDDA pmos4 L=1e-05 W=2e-06 AD=1.7e-12 AS=1.7e-12 PD=3.7e-06 PS=3.7e-06 NRD=0.2125 NRS=0.2125 $X=107425 $Y=166950 $D=41
M79 Vout 2 VDDA VDDA pmos4 L=1e-05 W=2e-06 AD=1.7e-12 AS=1.7e-12 PD=3.7e-06 PS=3.7e-06 NRD=0.2125 NRS=0.2125 $X=107425 $Y=179350 $D=41
M80 Vout 2 VDDA VDDA pmos4 L=1e-05 W=2e-06 AD=1.7e-12 AS=1.7e-12 PD=3.7e-06 PS=3.7e-06 NRD=0.2125 NRS=0.2125 $X=107425 $Y=191750 $D=41
M81 Vout 2 VDDA VDDA pmos4 L=1e-05 W=2e-06 AD=1.7e-12 AS=1.7e-12 PD=3.7e-06 PS=3.7e-06 NRD=0.2125 NRS=0.2125 $X=119725 $Y=129750 $D=41
M82 Vout 2 VDDA VDDA pmos4 L=1e-05 W=2e-06 AD=1.7e-12 AS=1.7e-12 PD=3.7e-06 PS=3.7e-06 NRD=0.2125 NRS=0.2125 $X=119725 $Y=142150 $D=41
M83 Vout 2 VDDA VDDA pmos4 L=1e-05 W=2e-06 AD=1.7e-12 AS=1.7e-12 PD=3.7e-06 PS=3.7e-06 NRD=0.2125 NRS=0.2125 $X=119725 $Y=154550 $D=41
M84 Vout 2 VDDA VDDA pmos4 L=1e-05 W=2e-06 AD=1.7e-12 AS=1.7e-12 PD=3.7e-06 PS=3.7e-06 NRD=0.2125 NRS=0.2125 $X=119725 $Y=166950 $D=41
M85 Vout 2 VDDA VDDA pmos4 L=1e-05 W=2e-06 AD=1.7e-12 AS=1.7e-12 PD=3.7e-06 PS=3.7e-06 NRD=0.2125 NRS=0.2125 $X=119725 $Y=179350 $D=41
M86 Vout 2 VDDA VDDA pmos4 L=1e-05 W=2e-06 AD=1.7e-12 AS=1.7e-12 PD=3.7e-06 PS=3.7e-06 NRD=0.2125 NRS=0.2125 $X=119725 $Y=191750 $D=41
M87 Vout 2 VDDA VDDA pmos4 L=1e-05 W=2e-06 AD=1.7e-12 AS=1.7e-12 PD=3.7e-06 PS=3.7e-06 NRD=0.2125 NRS=0.2125 $X=132025 $Y=129750 $D=41
M88 Vout 2 VDDA VDDA pmos4 L=1e-05 W=2e-06 AD=1.7e-12 AS=1.7e-12 PD=3.7e-06 PS=3.7e-06 NRD=0.2125 NRS=0.2125 $X=132025 $Y=142150 $D=41
M89 Vout 2 VDDA VDDA pmos4 L=1e-05 W=2e-06 AD=1.7e-12 AS=1.7e-12 PD=3.7e-06 PS=3.7e-06 NRD=0.2125 NRS=0.2125 $X=132025 $Y=154550 $D=41
M90 Vout 2 VDDA VDDA pmos4 L=1e-05 W=2e-06 AD=1.7e-12 AS=1.7e-12 PD=3.7e-06 PS=3.7e-06 NRD=0.2125 NRS=0.2125 $X=132025 $Y=166950 $D=41
M91 Vout 2 VDDA VDDA pmos4 L=1e-05 W=2e-06 AD=1.7e-12 AS=1.7e-12 PD=3.7e-06 PS=3.7e-06 NRD=0.2125 NRS=0.2125 $X=132025 $Y=179350 $D=41
M92 Vout 2 VDDA VDDA pmos4 L=1e-05 W=2e-06 AD=1.7e-12 AS=1.7e-12 PD=3.7e-06 PS=3.7e-06 NRD=0.2125 NRS=0.2125 $X=132025 $Y=191750 $D=41
M93 Vout 2 VDDA VDDA pmos4 L=1e-05 W=2e-06 AD=1.7e-12 AS=1.7e-12 PD=3.7e-06 PS=3.7e-06 NRD=0.2125 NRS=0.2125 $X=144325 $Y=129750 $D=41
M94 Vout 2 VDDA VDDA pmos4 L=1e-05 W=2e-06 AD=1.7e-12 AS=1.7e-12 PD=3.7e-06 PS=3.7e-06 NRD=0.2125 NRS=0.2125 $X=144325 $Y=142150 $D=41
M95 Vout 2 VDDA VDDA pmos4 L=1e-05 W=2e-06 AD=1.7e-12 AS=1.7e-12 PD=3.7e-06 PS=3.7e-06 NRD=0.2125 NRS=0.2125 $X=144325 $Y=154550 $D=41
M96 Vout 2 VDDA VDDA pmos4 L=1e-05 W=2e-06 AD=1.7e-12 AS=1.7e-12 PD=3.7e-06 PS=3.7e-06 NRD=0.2125 NRS=0.2125 $X=144325 $Y=166950 $D=41
M97 Vout 2 VDDA VDDA pmos4 L=1e-05 W=2e-06 AD=1.7e-12 AS=1.7e-12 PD=3.7e-06 PS=3.7e-06 NRD=0.2125 NRS=0.2125 $X=144325 $Y=179350 $D=41
M98 Vout 2 VDDA VDDA pmos4 L=1e-05 W=2e-06 AD=1.7e-12 AS=1.7e-12 PD=3.7e-06 PS=3.7e-06 NRD=0.2125 NRS=0.2125 $X=144325 $Y=191750 $D=41
C99 Vout 11 $[cpolya] $A=3466.12 $P=235.5 $X=124200 $Y=31550 $D=58
X140 8 5 6 Vin+ Vin- 8 ICV_6 $T=71875 66425 0 270 $X=70675 $Y=55225
X141 8 6 5 Vin- Vin+ 8 ICV_6 $T=71875 82575 0 270 $X=70675 $Y=71375
X142 9 Ibias Ibias GNDA nmos4_CDNS_780408906121 $T=4175 32450 1 90 $X=3925 $Y=31650
X143 1 2 Ibias GNDA nmos4_CDNS_780408906121 $T=4175 39750 0 270 $X=3925 $Y=37950
X220 GNDA 9 1 9 ICV_15 $T=15375 13250 0 90 $X=9425 $Y=12850
X221 GNDA 1 9 9 ICV_15 $T=15375 18150 0 90 $X=9425 $Y=17750
X222 GNDA 9 1 9 ICV_15 $T=27975 13250 0 90 $X=22025 $Y=12850
X223 GNDA 1 9 9 ICV_15 $T=27975 18150 0 90 $X=22025 $Y=17750
X224 8 5 6 Vin+ Vin- ICV_16 $T=21475 66425 0 270 $X=20275 $Y=55225
X225 8 6 5 Vin- Vin+ ICV_16 $T=21475 82575 0 270 $X=20275 $Y=71375
X226 VDDA ICV_19 $T=20475 117350 1 90 $X=19275 $Y=116150
X227 VDDA ICV_19 $T=20475 129750 1 90 $X=19275 $Y=128550
X228 VDDA ICV_19 $T=20475 142150 1 90 $X=19275 $Y=140950
X229 VDDA ICV_19 $T=20475 154550 1 90 $X=19275 $Y=153350
X230 VDDA ICV_19 $T=20475 166950 1 90 $X=19275 $Y=165750
X231 VDDA ICV_19 $T=20475 179350 1 90 $X=19275 $Y=178150
X232 VDDA ICV_19 $T=20475 191750 1 90 $X=19275 $Y=190550
X233 VDDA ICV_19 $T=20475 204150 1 90 $X=19275 $Y=202950
.ENDS
***************************************
.SUBCKT 8_CA_TIA_Front_calib VDDA CE RE EN_100mV V_EC v1500 S<0> S<3> S<2> Calib_EN S<1> WE Ibias9 TIA_in Vref Vout Ibias8 Calib_cur GNDA
** N=21 EP=19 IP=60 FDC=552
R0 GNDA GNDA L=5e-06 W=8e-07 $[rpolyh] $X=774075 $Y=129600 $D=18
D1 GNDA GNDA p_nwd AREA=25169.9 PJ=728.4 $X=761775 $Y=21250 $D=87
X2 Vout TIA_in cpolyc_CDNS_7804089061226 $T=959475 26750 0 0 $X=958125 $Y=25400
X3 Vout TIA_in cpolyc_CDNS_7804089061226 $T=959475 73250 0 0 $X=958125 $Y=71900
X4 Vout TIA_in ICV_1 $T=767275 26750 0 0 $X=765925 $Y=25400
X5 Vout TIA_in ICV_1 $T=767275 73250 0 0 $X=765925 $Y=71900
X6 Vout TIA_in ICV_1 $T=863375 26750 0 0 $X=862025 $Y=25400
X7 Vout TIA_in ICV_1 $T=863375 73250 0 0 $X=862025 $Y=71900
X8 S<2> S<3> S<0> S<1> VDDA TIA_in Vout GNDA 6_Resnet $T=716250 66000 0 0 $X=766125 $Y=141898
X9 GNDA Calib_cur cvar_CDNS_7804089061211 $T=255125 24450 1 180 $X=230350 $Y=22900
X10 Vout VDDA Ibias9 GNDA TIA_in Vref 6_TIA_Front_Layout $T=427675 63900 0 0 $X=426225 $Y=65550
X11 EN_100mV VDDA v1500 19 V_EC GNDA 7_MUX21 $T=237275 220800 0 0 $X=237700 $Y=221550
X12 Calib_EN VDDA 13 TIA_in WE GNDA 7_MUX21 $T=359275 220675 0 0 $X=359700 $Y=221425
X13 VDDA 13 Calib_cur S<0> S<3> S<2> S<1> GNDA 7_Calibration_current $T=222350 24000 0 0 $X=227250 $Y=60898
X14 GNDA CE VDDA Ibias8 RE 19 6_CA_Front_Layout $T=196375 17300 1 180 $X=8600 $Y=19098
.ENDS
***************************************
