* SPICE NETLIST
***************************************

.SUBCKT tsv80 TOP BOTTOM SUB
.ENDS
***************************************
.SUBCKT rx POS NEG
.ENDS
***************************************
.SUBCKT Q C B E S G
.ENDS
***************************************
.SUBCKT lddn D G S B
.ENDS
***************************************
.SUBCKT phd POS NEG P
.ENDS
***************************************
.SUBCKT sbd A C SUB
.ENDS
***************************************
.SUBCKT esddlv2 A C
.ENDS
***************************************
.SUBCKT esddlv A C SUB
.ENDS
***************************************
.SUBCKT lddp D G S B
.ENDS
***************************************
.SUBCKT probepad pad
.ENDS
***************************************
.SUBCKT L POS NEG SUB
.ENDS
***************************************
.SUBCKT L POS NEG MID SUB
.ENDS
***************************************
.SUBCKT hall A B C D S P1 P2
.ENDS
***************************************
.SUBCKT vert10_4 1 2
** N=2 EP=2 IP=0 FDC=1
Q0 2 2 1 pnpvert10 AREA=1e-12 $X=1400 $Y=1400 $D=33
.ENDS
***************************************
.SUBCKT rpolyhc_CDNS_779828569771 1 2
** N=3 EP=2 IP=0 FDC=1
R0 1 2 L=5.255e-05 W=2e-06 $[rpolyh] $X=-2000 $Y=2750 $D=18
.ENDS
***************************************
.SUBCKT ICV_1 1 2 3 4
** N=5 EP=4 IP=6 FDC=2
X0 1 2 rpolyhc_CDNS_779828569771 $T=0 0 0 0 $X=-7750 $Y=-5750
X1 3 4 rpolyhc_CDNS_779828569771 $T=18050 0 0 0 $X=10300 $Y=-5750
.ENDS
***************************************
.SUBCKT ICV_2 1 2 3 4
** N=5 EP=4 IP=6 FDC=2
X0 1 2 rpolyhc_CDNS_779828569771 $T=-18050 0 0 0 $X=-25800 $Y=-5750
X1 3 4 rpolyhc_CDNS_779828569771 $T=0 0 0 0 $X=-7750 $Y=-5750
.ENDS
***************************************
.SUBCKT ICV_3 1 2 3
** N=3 EP=3 IP=4 FDC=2
X0 1 2 vert10_4 $T=0 0 0 0 $X=0 $Y=0
X1 3 2 vert10_4 $T=16900 0 0 0 $X=16900 $Y=0
.ENDS
***************************************
.SUBCKT ICV_4 1 2 3 4 5
** N=5 EP=5 IP=6 FDC=4
X0 1 2 3 ICV_3 $T=0 0 0 0 $X=0 $Y=0
X1 4 2 5 ICV_3 $T=33800 0 0 0 $X=33800 $Y=0
.ENDS
***************************************
.SUBCKT ND_C_CDNS_7798285697742
** N=2 EP=0 IP=0 FDC=0
.ENDS
***************************************
.SUBCKT nmos4_CDNS_779828569774
** N=4 EP=0 IP=0 FDC=0
.ENDS
***************************************
.SUBCKT nmos4_CDNS_779828569776 1 2 3
** N=3 EP=3 IP=0 FDC=1
M0 2 3 1 1 nmos4 L=1e-05 W=1e-05 AD=8.5e-12 AS=8.5e-12 PD=1.17e-05 PS=1.17e-05 NRD=0.0425 NRS=0.0425 $X=0 $Y=850 $D=37
.ENDS
***************************************
.SUBCKT P1_C_CDNS_7798285697719
** N=2 EP=0 IP=0 FDC=0
.ENDS
***************************************
.SUBCKT pmos4_CDNS_779828569778
** N=4 EP=0 IP=0 FDC=0
.ENDS
***************************************
.SUBCKT P1_C_CDNS_7798285697734
** N=2 EP=0 IP=0 FDC=0
.ENDS
***************************************
.SUBCKT ND_C_CDNS_7798285697753
** N=2 EP=0 IP=0 FDC=0
.ENDS
***************************************
.SUBCKT P1_C_CDNS_779828569774
** N=2 EP=0 IP=0 FDC=0
.ENDS
***************************************
.SUBCKT ND_C_CDNS_7798285697743
** N=2 EP=0 IP=0 FDC=0
.ENDS
***************************************
.SUBCKT pmos4_CDNS_779828569777
** N=4 EP=0 IP=0 FDC=0
.ENDS
***************************************
.SUBCKT ICV_5
** N=6 EP=0 IP=8 FDC=0
.ENDS
***************************************
.SUBCKT ND_C_CDNS_7798285697744
** N=2 EP=0 IP=0 FDC=0
.ENDS
***************************************
.SUBCKT ICV_6 1 2 3 5 6
** N=8 EP=5 IP=12 FDC=3
M0 2 5 1 1 pmos4 L=4e-06 W=2.5e-05 AD=2.125e-11 AS=2.125e-11 PD=2.67e-05 PS=2.67e-05 NRD=0.017 NRS=0.017 $X=0 $Y=-18050 $D=41
M1 3 6 1 1 pmos4 L=4e-06 W=2.5e-05 AD=2.125e-11 AS=2.125e-11 PD=2.67e-05 PS=2.67e-05 NRD=0.017 NRS=0.017 $X=0 $Y=-11750 $D=41
M2 2 5 1 1 pmos4 L=4e-06 W=2.5e-05 AD=2.125e-11 AS=2.125e-11 PD=2.67e-05 PS=2.67e-05 NRD=0.017 NRS=0.017 $X=0 $Y=-5450 $D=41
.ENDS
***************************************
.SUBCKT P1_C_CDNS_7798285697711
** N=2 EP=0 IP=0 FDC=0
.ENDS
***************************************
.SUBCKT PD_C_CDNS_7798285697746
** N=1 EP=0 IP=0 FDC=0
.ENDS
***************************************
.SUBCKT ND_C_CDNS_7798285697735
** N=2 EP=0 IP=0 FDC=0
.ENDS
***************************************
.SUBCKT pmos4_CDNS_779828569773
** N=4 EP=0 IP=0 FDC=0
.ENDS
***************************************
.SUBCKT ICV_7
** N=6 EP=0 IP=8 FDC=0
.ENDS
***************************************
.SUBCKT ICV_8
** N=8 EP=0 IP=12 FDC=0
.ENDS
***************************************
.SUBCKT ICV_9 1
** N=9 EP=1 IP=26 FDC=2
M0 1 1 1 1 pmos4 L=1e-05 W=5e-06 AD=4.25e-12 AS=4.25e-12 PD=6.7e-06 PS=6.7e-06 NRD=0.085 NRS=0.085 $X=0 $Y=-122150 $D=42
M1 1 1 1 1 pmos4 L=1e-05 W=5e-06 AD=4.25e-12 AS=4.25e-12 PD=6.7e-06 PS=6.7e-06 NRD=0.085 NRS=0.085 $X=0 $Y=850 $D=42
.ENDS
***************************************
.SUBCKT fecg_bandgap3_layout BG_REF VDDA GNDA BIAS
** N=56 EP=4 IP=636 FDC=248
D0 GNDA VDDA p_nwd AREA=30907.1 PJ=704.2 $X=4250 $Y=202850 $D=87
D1 GNDA GNDA p_nwd AREA=4092.2 PJ=255.9 $X=4275 $Y=135225 $D=87
D2 GNDA 3 p_nwd AREA=7338.63 PJ=343.3 $X=123850 $Y=119100 $D=87
D3 GNDA 4 p_nwd AREA=1888.05 PJ=175 $X=193000 $Y=211450 $D=87
D4 GNDA GNDA p_nwd AREA=17415.8 PJ=546.1 $X=239000 $Y=120500 $D=87
M5 BIAS BIAS BIAS GNDA nmos4 L=1e-05 W=5e-06 AD=4.25e-12 AS=4.25e-12 PD=6.7e-06 PS=6.7e-06 NRD=0.085 NRS=0.085 $X=203275 $Y=323775 $D=38
M6 BIAS BIAS BIAS GNDA nmos4 L=1e-05 W=5e-06 AD=4.25e-12 AS=4.25e-12 PD=6.7e-06 PS=6.7e-06 NRD=0.085 NRS=0.085 $X=203275 $Y=355025 $D=38
M7 GNDA BIAS BIAS GNDA nmos4 L=1e-05 W=5e-06 AD=4.25e-12 AS=4.25e-12 PD=6.7e-06 PS=6.7e-06 NRD=0.085 NRS=0.085 $X=203275 $Y=330025 $D=37
M8 GNDA BIAS 1 GNDA nmos4 L=1e-05 W=5e-06 AD=4.25e-12 AS=4.25e-12 PD=6.7e-06 PS=6.7e-06 NRD=0.085 NRS=0.085 $X=203275 $Y=336275 $D=37
M9 GNDA BIAS BIAS GNDA nmos4 L=1e-05 W=5e-06 AD=4.25e-12 AS=4.25e-12 PD=6.7e-06 PS=6.7e-06 NRD=0.085 NRS=0.085 $X=203275 $Y=342525 $D=37
M10 GNDA BIAS 1 GNDA nmos4 L=1e-05 W=5e-06 AD=4.25e-12 AS=4.25e-12 PD=6.7e-06 PS=6.7e-06 NRD=0.085 NRS=0.085 $X=203275 $Y=348775 $D=37
M11 14 8 GNDA GNDA nmos4 L=1e-06 W=5e-06 AD=2.5e-12 AS=4.25e-12 PD=1e-06 PS=6.7e-06 NRD=0.085 NRS=0.085 $X=219775 $Y=173375 $D=37
M12 BG_REF 10 14 GNDA nmos4 L=1e-05 W=5e-06 AD=4.25e-12 AS=4.25e-12 PD=6.7e-06 PS=6.7e-06 NRD=0.085 NRS=0.085 $X=220000 $Y=190850 $D=37
M13 GNDA 8 14 GNDA nmos4 L=1e-06 W=5e-06 AD=4.25e-12 AS=2.5e-12 PD=6.7e-06 PS=1e-06 NRD=0.085 NRS=0.085 $X=221775 $Y=173375 $D=37
M14 5 5 GNDA GNDA nmos4 L=1e-05 W=5e-07 AD=5.9e-13 AS=5.9e-13 PD=2.7e-06 PS=2.7e-06 NRD=0.85 NRS=0.85 $X=236350 $Y=232050 $D=37
M15 VDDA VDDA VDDA VDDA pmos4 L=1e-05 W=5e-06 AD=4.25e-12 AS=4.25e-12 PD=6.7e-06 PS=6.7e-06 NRD=0.085 NRS=0.085 $X=42725 $Y=219700 $D=42
M16 VDDA VDDA VDDA VDDA pmos4 L=1e-05 W=5e-06 AD=4.25e-12 AS=4.25e-12 PD=6.7e-06 PS=6.7e-06 NRD=0.085 NRS=0.085 $X=42725 $Y=347800 $D=42
M17 VDDA VDDA VDDA VDDA pmos4 L=1e-05 W=5e-06 AD=4.25e-12 AS=4.25e-12 PD=6.7e-06 PS=6.7e-06 NRD=0.085 NRS=0.085 $X=55025 $Y=219700 $D=42
M18 VDDA VDDA VDDA VDDA pmos4 L=1e-05 W=5e-06 AD=4.25e-12 AS=4.25e-12 PD=6.7e-06 PS=6.7e-06 NRD=0.085 NRS=0.085 $X=55025 $Y=347800 $D=42
M19 VDDA VDDA VDDA VDDA pmos4 L=1e-05 W=5e-06 AD=4.25e-12 AS=4.25e-12 PD=6.7e-06 PS=6.7e-06 NRD=0.085 NRS=0.085 $X=67325 $Y=219700 $D=42
M20 VDDA VDDA VDDA VDDA pmos4 L=1e-05 W=5e-06 AD=4.25e-12 AS=4.25e-12 PD=6.7e-06 PS=6.7e-06 NRD=0.085 NRS=0.085 $X=67325 $Y=347800 $D=42
M21 VDDA VDDA VDDA VDDA pmos4 L=1e-05 W=5e-06 AD=4.25e-12 AS=4.25e-12 PD=6.7e-06 PS=6.7e-06 NRD=0.085 NRS=0.085 $X=79625 $Y=219700 $D=42
M22 VDDA VDDA VDDA VDDA pmos4 L=1e-05 W=5e-06 AD=4.25e-12 AS=4.25e-12 PD=6.7e-06 PS=6.7e-06 NRD=0.085 NRS=0.085 $X=79625 $Y=347800 $D=42
M23 VDDA VDDA VDDA VDDA pmos4 L=1e-05 W=5e-06 AD=4.25e-12 AS=4.25e-12 PD=6.7e-06 PS=6.7e-06 NRD=0.085 NRS=0.085 $X=91925 $Y=219700 $D=42
M24 VDDA VDDA VDDA VDDA pmos4 L=1e-05 W=5e-06 AD=4.25e-12 AS=4.25e-12 PD=6.7e-06 PS=6.7e-06 NRD=0.085 NRS=0.085 $X=91925 $Y=347800 $D=42
M25 VDDA VDDA VDDA VDDA pmos4 L=1e-05 W=5e-06 AD=4.25e-12 AS=4.25e-12 PD=6.7e-06 PS=6.7e-06 NRD=0.085 NRS=0.085 $X=104225 $Y=219700 $D=42
M26 VDDA VDDA VDDA VDDA pmos4 L=1e-05 W=5e-06 AD=4.25e-12 AS=4.25e-12 PD=6.7e-06 PS=6.7e-06 NRD=0.085 NRS=0.085 $X=104225 $Y=347800 $D=42
M27 VDDA VDDA VDDA VDDA pmos4 L=1e-05 W=5e-06 AD=4.25e-12 AS=4.25e-12 PD=6.7e-06 PS=6.7e-06 NRD=0.085 NRS=0.085 $X=116525 $Y=219700 $D=42
M28 VDDA VDDA VDDA VDDA pmos4 L=1e-05 W=5e-06 AD=4.25e-12 AS=4.25e-12 PD=6.7e-06 PS=6.7e-06 NRD=0.085 NRS=0.085 $X=116525 $Y=347800 $D=42
M29 VDDA VDDA VDDA VDDA pmos4 L=1e-05 W=5e-06 AD=4.25e-12 AS=4.25e-12 PD=6.7e-06 PS=6.7e-06 NRD=0.085 NRS=0.085 $X=128825 $Y=219700 $D=42
M30 VDDA VDDA VDDA VDDA pmos4 L=1e-05 W=5e-06 AD=4.25e-12 AS=4.25e-12 PD=6.7e-06 PS=6.7e-06 NRD=0.085 NRS=0.085 $X=128825 $Y=347800 $D=42
M31 3 3 3 3 pmos4 L=4e-06 W=2.5e-05 AD=2.125e-11 AS=2.125e-11 PD=2.67e-05 PS=2.67e-05 NRD=0.017 NRS=0.017 $X=139025 $Y=130450 $D=42
M32 3 3 3 3 pmos4 L=4e-06 W=2.5e-05 AD=2.125e-11 AS=2.125e-11 PD=2.67e-05 PS=2.67e-05 NRD=0.017 NRS=0.017 $X=139025 $Y=163350 $D=42
M33 VDDA VDDA VDDA VDDA pmos4 L=1e-05 W=5e-06 AD=4.25e-12 AS=4.25e-12 PD=6.7e-06 PS=6.7e-06 NRD=0.085 NRS=0.085 $X=141125 $Y=219700 $D=42
M34 VDDA VDDA VDDA VDDA pmos4 L=1e-05 W=5e-06 AD=4.25e-12 AS=4.25e-12 PD=6.7e-06 PS=6.7e-06 NRD=0.085 NRS=0.085 $X=141125 $Y=347800 $D=42
M35 3 3 3 3 pmos4 L=4e-06 W=2.5e-05 AD=2.125e-11 AS=2.125e-11 PD=2.67e-05 PS=2.67e-05 NRD=0.017 NRS=0.017 $X=195725 $Y=130450 $D=42
M36 3 3 3 3 pmos4 L=4e-06 W=2.5e-05 AD=2.125e-11 AS=2.125e-11 PD=2.67e-05 PS=2.67e-05 NRD=0.017 NRS=0.017 $X=195725 $Y=163350 $D=42
M37 4 4 4 4 pmos4 L=3.5e-07 W=1e-05 AD=8.5e-12 AS=8.5e-12 PD=1.17e-05 PS=1.17e-05 NRD=0.0425 NRS=0.0425 $X=208175 $Y=222800 $D=42
M38 4 4 4 4 pmos4 L=3.5e-07 W=1e-05 AD=8.5e-12 AS=8.5e-12 PD=1.17e-05 PS=1.17e-05 NRD=0.0425 NRS=0.0425 $X=208175 $Y=238950 $D=42
M39 4 4 4 4 pmos4 L=3.5e-07 W=1e-05 AD=8.5e-12 AS=8.5e-12 PD=1.17e-05 PS=1.17e-05 NRD=0.0425 NRS=0.0425 $X=216125 $Y=222800 $D=42
M40 4 4 4 4 pmos4 L=3.5e-07 W=1e-05 AD=8.5e-12 AS=8.5e-12 PD=1.17e-05 PS=1.17e-05 NRD=0.0425 NRS=0.0425 $X=216125 $Y=238950 $D=42
M41 VDDA 1 BG_REF VDDA pmos4 L=1e-05 W=5e-06 AD=4.25e-12 AS=4.25e-12 PD=6.7e-06 PS=6.7e-06 NRD=0.085 NRS=0.085 $X=42725 $Y=238000 $D=41
M42 VDDA 1 BG_REF VDDA pmos4 L=1e-05 W=5e-06 AD=4.25e-12 AS=4.25e-12 PD=6.7e-06 PS=6.7e-06 NRD=0.085 NRS=0.085 $X=42725 $Y=256300 $D=41
M43 VDDA 1 BG_REF VDDA pmos4 L=1e-05 W=5e-06 AD=4.25e-12 AS=4.25e-12 PD=6.7e-06 PS=6.7e-06 NRD=0.085 NRS=0.085 $X=42725 $Y=274600 $D=41
M44 VDDA 1 BG_REF VDDA pmos4 L=1e-05 W=5e-06 AD=4.25e-12 AS=4.25e-12 PD=6.7e-06 PS=6.7e-06 NRD=0.085 NRS=0.085 $X=42725 $Y=292900 $D=41
M45 VDDA 1 BG_REF VDDA pmos4 L=1e-05 W=5e-06 AD=4.25e-12 AS=4.25e-12 PD=6.7e-06 PS=6.7e-06 NRD=0.085 NRS=0.085 $X=42725 $Y=311200 $D=41
M46 VDDA 1 BG_REF VDDA pmos4 L=1e-05 W=5e-06 AD=4.25e-12 AS=4.25e-12 PD=6.7e-06 PS=6.7e-06 NRD=0.085 NRS=0.085 $X=42725 $Y=329500 $D=41
M47 VDDA 1 BG_REF VDDA pmos4 L=1e-05 W=5e-06 AD=4.25e-12 AS=4.25e-12 PD=6.7e-06 PS=6.7e-06 NRD=0.085 NRS=0.085 $X=55025 $Y=238000 $D=41
M48 VDDA 1 3 VDDA pmos4 L=1e-05 W=5e-06 AD=4.25e-12 AS=4.25e-12 PD=6.7e-06 PS=6.7e-06 NRD=0.085 NRS=0.085 $X=55025 $Y=256300 $D=41
M49 VDDA 1 BG_REF VDDA pmos4 L=1e-05 W=5e-06 AD=4.25e-12 AS=4.25e-12 PD=6.7e-06 PS=6.7e-06 NRD=0.085 NRS=0.085 $X=55025 $Y=274600 $D=41
M50 VDDA 1 BG_REF VDDA pmos4 L=1e-05 W=5e-06 AD=4.25e-12 AS=4.25e-12 PD=6.7e-06 PS=6.7e-06 NRD=0.085 NRS=0.085 $X=55025 $Y=292900 $D=41
M51 VDDA 1 3 VDDA pmos4 L=1e-05 W=5e-06 AD=4.25e-12 AS=4.25e-12 PD=6.7e-06 PS=6.7e-06 NRD=0.085 NRS=0.085 $X=55025 $Y=311200 $D=41
M52 VDDA 1 BG_REF VDDA pmos4 L=1e-05 W=5e-06 AD=4.25e-12 AS=4.25e-12 PD=6.7e-06 PS=6.7e-06 NRD=0.085 NRS=0.085 $X=55025 $Y=329500 $D=41
M53 VDDA 1 BG_REF VDDA pmos4 L=1e-05 W=5e-06 AD=4.25e-12 AS=4.25e-12 PD=6.7e-06 PS=6.7e-06 NRD=0.085 NRS=0.085 $X=67325 $Y=238000 $D=41
M54 VDDA 1 3 VDDA pmos4 L=1e-05 W=5e-06 AD=4.25e-12 AS=4.25e-12 PD=6.7e-06 PS=6.7e-06 NRD=0.085 NRS=0.085 $X=67325 $Y=256300 $D=41
M55 VDDA 1 3 VDDA pmos4 L=1e-05 W=5e-06 AD=4.25e-12 AS=4.25e-12 PD=6.7e-06 PS=6.7e-06 NRD=0.085 NRS=0.085 $X=67325 $Y=274600 $D=41
M56 VDDA 1 3 VDDA pmos4 L=1e-05 W=5e-06 AD=4.25e-12 AS=4.25e-12 PD=6.7e-06 PS=6.7e-06 NRD=0.085 NRS=0.085 $X=67325 $Y=292900 $D=41
M57 VDDA 1 3 VDDA pmos4 L=1e-05 W=5e-06 AD=4.25e-12 AS=4.25e-12 PD=6.7e-06 PS=6.7e-06 NRD=0.085 NRS=0.085 $X=67325 $Y=311200 $D=41
M58 VDDA 1 BG_REF VDDA pmos4 L=1e-05 W=5e-06 AD=4.25e-12 AS=4.25e-12 PD=6.7e-06 PS=6.7e-06 NRD=0.085 NRS=0.085 $X=67325 $Y=329500 $D=41
M59 VDDA 1 BG_REF VDDA pmos4 L=1e-05 W=5e-06 AD=4.25e-12 AS=4.25e-12 PD=6.7e-06 PS=6.7e-06 NRD=0.085 NRS=0.085 $X=79625 $Y=238000 $D=41
M60 VDDA 1 3 VDDA pmos4 L=1e-05 W=5e-06 AD=4.25e-12 AS=4.25e-12 PD=6.7e-06 PS=6.7e-06 NRD=0.085 NRS=0.085 $X=79625 $Y=256300 $D=41
M61 VDDA 1 1 VDDA pmos4 L=1e-05 W=5e-06 AD=4.25e-12 AS=4.25e-12 PD=6.7e-06 PS=6.7e-06 NRD=0.085 NRS=0.085 $X=79625 $Y=274600 $D=41
M62 VDDA 1 3 VDDA pmos4 L=1e-05 W=5e-06 AD=4.25e-12 AS=4.25e-12 PD=6.7e-06 PS=6.7e-06 NRD=0.085 NRS=0.085 $X=79625 $Y=292900 $D=41
M63 VDDA 1 3 VDDA pmos4 L=1e-05 W=5e-06 AD=4.25e-12 AS=4.25e-12 PD=6.7e-06 PS=6.7e-06 NRD=0.085 NRS=0.085 $X=79625 $Y=311200 $D=41
M64 VDDA 1 BG_REF VDDA pmos4 L=1e-05 W=5e-06 AD=4.25e-12 AS=4.25e-12 PD=6.7e-06 PS=6.7e-06 NRD=0.085 NRS=0.085 $X=79625 $Y=329500 $D=41
M65 VDDA 1 BG_REF VDDA pmos4 L=1e-05 W=5e-06 AD=4.25e-12 AS=4.25e-12 PD=6.7e-06 PS=6.7e-06 NRD=0.085 NRS=0.085 $X=91925 $Y=238000 $D=41
M66 VDDA 1 3 VDDA pmos4 L=1e-05 W=5e-06 AD=4.25e-12 AS=4.25e-12 PD=6.7e-06 PS=6.7e-06 NRD=0.085 NRS=0.085 $X=91925 $Y=256300 $D=41
M67 VDDA 1 5 VDDA pmos4 L=1e-05 W=5e-06 AD=4.25e-12 AS=4.25e-12 PD=6.7e-06 PS=6.7e-06 NRD=0.085 NRS=0.085 $X=91925 $Y=274600 $D=41
M68 VDDA 1 4 VDDA pmos4 L=1e-05 W=5e-06 AD=4.25e-12 AS=4.25e-12 PD=6.7e-06 PS=6.7e-06 NRD=0.085 NRS=0.085 $X=91925 $Y=292900 $D=41
M69 VDDA 1 3 VDDA pmos4 L=1e-05 W=5e-06 AD=4.25e-12 AS=4.25e-12 PD=6.7e-06 PS=6.7e-06 NRD=0.085 NRS=0.085 $X=91925 $Y=311200 $D=41
M70 VDDA 1 BG_REF VDDA pmos4 L=1e-05 W=5e-06 AD=4.25e-12 AS=4.25e-12 PD=6.7e-06 PS=6.7e-06 NRD=0.085 NRS=0.085 $X=91925 $Y=329500 $D=41
M71 VDDA 1 BG_REF VDDA pmos4 L=1e-05 W=5e-06 AD=4.25e-12 AS=4.25e-12 PD=6.7e-06 PS=6.7e-06 NRD=0.085 NRS=0.085 $X=104225 $Y=238000 $D=41
M72 VDDA 1 3 VDDA pmos4 L=1e-05 W=5e-06 AD=4.25e-12 AS=4.25e-12 PD=6.7e-06 PS=6.7e-06 NRD=0.085 NRS=0.085 $X=104225 $Y=256300 $D=41
M73 VDDA 1 3 VDDA pmos4 L=1e-05 W=5e-06 AD=4.25e-12 AS=4.25e-12 PD=6.7e-06 PS=6.7e-06 NRD=0.085 NRS=0.085 $X=104225 $Y=274600 $D=41
M74 VDDA 1 1 VDDA pmos4 L=1e-05 W=5e-06 AD=4.25e-12 AS=4.25e-12 PD=6.7e-06 PS=6.7e-06 NRD=0.085 NRS=0.085 $X=104225 $Y=292900 $D=41
M75 VDDA 1 3 VDDA pmos4 L=1e-05 W=5e-06 AD=4.25e-12 AS=4.25e-12 PD=6.7e-06 PS=6.7e-06 NRD=0.085 NRS=0.085 $X=104225 $Y=311200 $D=41
M76 VDDA 1 BG_REF VDDA pmos4 L=1e-05 W=5e-06 AD=4.25e-12 AS=4.25e-12 PD=6.7e-06 PS=6.7e-06 NRD=0.085 NRS=0.085 $X=104225 $Y=329500 $D=41
M77 VDDA 1 BG_REF VDDA pmos4 L=1e-05 W=5e-06 AD=4.25e-12 AS=4.25e-12 PD=6.7e-06 PS=6.7e-06 NRD=0.085 NRS=0.085 $X=116525 $Y=238000 $D=41
M78 VDDA 1 3 VDDA pmos4 L=1e-05 W=5e-06 AD=4.25e-12 AS=4.25e-12 PD=6.7e-06 PS=6.7e-06 NRD=0.085 NRS=0.085 $X=116525 $Y=256300 $D=41
M79 VDDA 1 3 VDDA pmos4 L=1e-05 W=5e-06 AD=4.25e-12 AS=4.25e-12 PD=6.7e-06 PS=6.7e-06 NRD=0.085 NRS=0.085 $X=116525 $Y=274600 $D=41
M80 VDDA 1 3 VDDA pmos4 L=1e-05 W=5e-06 AD=4.25e-12 AS=4.25e-12 PD=6.7e-06 PS=6.7e-06 NRD=0.085 NRS=0.085 $X=116525 $Y=292900 $D=41
M81 VDDA 1 3 VDDA pmos4 L=1e-05 W=5e-06 AD=4.25e-12 AS=4.25e-12 PD=6.7e-06 PS=6.7e-06 NRD=0.085 NRS=0.085 $X=116525 $Y=311200 $D=41
M82 VDDA 1 BG_REF VDDA pmos4 L=1e-05 W=5e-06 AD=4.25e-12 AS=4.25e-12 PD=6.7e-06 PS=6.7e-06 NRD=0.085 NRS=0.085 $X=116525 $Y=329500 $D=41
M83 VDDA 1 BG_REF VDDA pmos4 L=1e-05 W=5e-06 AD=4.25e-12 AS=4.25e-12 PD=6.7e-06 PS=6.7e-06 NRD=0.085 NRS=0.085 $X=128825 $Y=238000 $D=41
M84 VDDA 1 3 VDDA pmos4 L=1e-05 W=5e-06 AD=4.25e-12 AS=4.25e-12 PD=6.7e-06 PS=6.7e-06 NRD=0.085 NRS=0.085 $X=128825 $Y=256300 $D=41
M85 VDDA 1 BG_REF VDDA pmos4 L=1e-05 W=5e-06 AD=4.25e-12 AS=4.25e-12 PD=6.7e-06 PS=6.7e-06 NRD=0.085 NRS=0.085 $X=128825 $Y=274600 $D=41
M86 VDDA 1 BG_REF VDDA pmos4 L=1e-05 W=5e-06 AD=4.25e-12 AS=4.25e-12 PD=6.7e-06 PS=6.7e-06 NRD=0.085 NRS=0.085 $X=128825 $Y=292900 $D=41
M87 VDDA 1 3 VDDA pmos4 L=1e-05 W=5e-06 AD=4.25e-12 AS=4.25e-12 PD=6.7e-06 PS=6.7e-06 NRD=0.085 NRS=0.085 $X=128825 $Y=311200 $D=41
M88 VDDA 1 BG_REF VDDA pmos4 L=1e-05 W=5e-06 AD=4.25e-12 AS=4.25e-12 PD=6.7e-06 PS=6.7e-06 NRD=0.085 NRS=0.085 $X=128825 $Y=329500 $D=41
M89 VDDA 1 BG_REF VDDA pmos4 L=1e-05 W=5e-06 AD=4.25e-12 AS=4.25e-12 PD=6.7e-06 PS=6.7e-06 NRD=0.085 NRS=0.085 $X=141125 $Y=238000 $D=41
M90 VDDA 1 BG_REF VDDA pmos4 L=1e-05 W=5e-06 AD=4.25e-12 AS=4.25e-12 PD=6.7e-06 PS=6.7e-06 NRD=0.085 NRS=0.085 $X=141125 $Y=256300 $D=41
M91 VDDA 1 BG_REF VDDA pmos4 L=1e-05 W=5e-06 AD=4.25e-12 AS=4.25e-12 PD=6.7e-06 PS=6.7e-06 NRD=0.085 NRS=0.085 $X=141125 $Y=274600 $D=41
M92 VDDA 1 BG_REF VDDA pmos4 L=1e-05 W=5e-06 AD=4.25e-12 AS=4.25e-12 PD=6.7e-06 PS=6.7e-06 NRD=0.085 NRS=0.085 $X=141125 $Y=292900 $D=41
M93 VDDA 1 BG_REF VDDA pmos4 L=1e-05 W=5e-06 AD=4.25e-12 AS=4.25e-12 PD=6.7e-06 PS=6.7e-06 NRD=0.085 NRS=0.085 $X=141125 $Y=311200 $D=41
M94 VDDA 1 BG_REF VDDA pmos4 L=1e-05 W=5e-06 AD=4.25e-12 AS=4.25e-12 PD=6.7e-06 PS=6.7e-06 NRD=0.085 NRS=0.085 $X=141125 $Y=329500 $D=41
M95 3 12 8 3 pmos4 L=4e-06 W=2.5e-05 AD=2.125e-11 AS=2.125e-11 PD=2.67e-05 PS=2.67e-05 NRD=0.017 NRS=0.017 $X=164225 $Y=130450 $D=41
M96 3 15 7 3 pmos4 L=4e-06 W=2.5e-05 AD=2.125e-11 AS=2.125e-11 PD=2.67e-05 PS=2.67e-05 NRD=0.017 NRS=0.017 $X=164225 $Y=163350 $D=41
M97 3 12 8 3 pmos4 L=4e-06 W=2.5e-05 AD=2.125e-11 AS=2.125e-11 PD=2.67e-05 PS=2.67e-05 NRD=0.017 NRS=0.017 $X=189425 $Y=130450 $D=41
M98 3 15 7 3 pmos4 L=4e-06 W=2.5e-05 AD=2.125e-11 AS=2.125e-11 PD=2.67e-05 PS=2.67e-05 NRD=0.017 NRS=0.017 $X=189425 $Y=163350 $D=41
M99 11 BG_REF 4 4 pmos4 L=3.5e-07 W=1e-05 AD=8.5e-12 AS=8.5e-12 PD=1.17e-05 PS=1.17e-05 NRD=0.0425 NRS=0.0425 $X=210825 $Y=222800 $D=41
M100 10 5 4 4 pmos4 L=3.5e-07 W=1e-05 AD=8.5e-12 AS=8.5e-12 PD=1.17e-05 PS=1.17e-05 NRD=0.0425 NRS=0.0425 $X=210825 $Y=238950 $D=41
M101 10 5 4 4 pmos4 L=3.5e-07 W=1e-05 AD=8.5e-12 AS=8.5e-12 PD=1.17e-05 PS=1.17e-05 NRD=0.0425 NRS=0.0425 $X=213475 $Y=222800 $D=41
M102 11 BG_REF 4 4 pmos4 L=3.5e-07 W=1e-05 AD=8.5e-12 AS=8.5e-12 PD=1.17e-05 PS=1.17e-05 NRD=0.0425 NRS=0.0425 $X=213475 $Y=238950 $D=41
C103 BG_REF 8 $[cpolya] $A=3466.12 $P=235.5 $X=7425 $Y=137575 $D=58
X104 GNDA GNDA vert10_4 $T=386925 249650 1 0 $X=386925 $Y=232850
X105 GNDA GNDA vert10_4 $T=386925 268350 1 0 $X=386925 $Y=251550
X106 GNDA GNDA vert10_4 $T=386925 287050 1 0 $X=386925 $Y=270250
X107 GNDA GNDA vert10_4 $T=386925 305750 1 0 $X=386925 $Y=288950
X108 GNDA GNDA vert10_4 $T=386925 324450 1 0 $X=386925 $Y=307650
X109 GNDA GNDA vert10_4 $T=386925 343150 1 0 $X=386925 $Y=326350
X110 GNDA GNDA vert10_4 $T=386925 361850 1 0 $X=386925 $Y=345050
X111 32 17 rpolyhc_CDNS_779828569771 $T=248275 127775 0 0 $X=240525 $Y=122025
X112 29 12 rpolyhc_CDNS_779828569771 $T=256825 146275 1 180 $X=240525 $Y=140525
X113 35 15 rpolyhc_CDNS_779828569771 $T=248275 177775 1 0 $X=240525 $Y=159025
X114 BG_REF 16 rpolyhc_CDNS_779828569771 $T=248275 183275 0 0 $X=240525 $Y=177525
X115 BG_REF 30 rpolyhc_CDNS_779828569771 $T=248275 214775 1 0 $X=240525 $Y=196025
X116 17 34 rpolyhc_CDNS_779828569771 $T=266325 146275 0 0 $X=258575 $Y=140525
X117 21 15 rpolyhc_CDNS_779828569771 $T=274875 177775 0 180 $X=258575 $Y=159025
X118 34 35 rpolyhc_CDNS_779828569771 $T=284375 164775 0 0 $X=276625 $Y=159025
X119 43 38 rpolyhc_CDNS_779828569771 $T=310975 127775 1 180 $X=294675 $Y=122025
X120 GNDA GNDA rpolyhc_CDNS_779828569771 $T=320475 127775 0 0 $X=312725 $Y=122025
X121 22 41 rpolyhc_CDNS_779828569771 $T=329025 159275 0 180 $X=312725 $Y=140525
X122 41 43 rpolyhc_CDNS_779828569771 $T=338525 140775 1 0 $X=330775 $Y=122025
X123 23 22 rpolyhc_CDNS_779828569771 $T=347075 164775 1 180 $X=330775 $Y=159025
X124 42 24 rpolyhc_CDNS_779828569771 $T=338525 183275 0 0 $X=330775 $Y=177525
X125 54 45 rpolyhc_CDNS_779828569771 $T=365125 127775 1 180 $X=348825 $Y=122025
X126 46 47 rpolyhc_CDNS_779828569771 $T=356575 164775 0 0 $X=348825 $Y=159025
X127 27 50 rpolyhc_CDNS_779828569771 $T=383175 140775 0 180 $X=366875 $Y=122025
X128 52 54 rpolyhc_CDNS_779828569771 $T=392675 140775 1 0 $X=384925 $Y=122025
X129 51 55 rpolyhc_CDNS_779828569771 $T=392675 196275 1 0 $X=384925 $Y=177525
X130 30 18 33 19 ICV_1 $T=266325 196275 1 0 $X=258575 $Y=177525
X131 16 33 18 36 ICV_1 $T=266325 201775 0 0 $X=258575 $Y=196025
X132 36 42 39 40 ICV_1 $T=302425 196275 1 0 $X=294675 $Y=177525
X133 19 39 GNDA GNDA ICV_1 $T=302425 201775 0 0 $X=294675 $Y=196025
X134 40 44 24 48 ICV_1 $T=338525 201775 0 0 $X=330775 $Y=196025
X135 44 25 48 28 ICV_1 $T=356575 196275 1 0 $X=348825 $Y=177525
X136 25 51 28 56 ICV_1 $T=374625 201775 0 0 $X=366875 $Y=196025
X137 20 32 31 29 ICV_2 $T=274875 140775 0 180 $X=258575 $Y=122025
X138 47 20 37 31 ICV_2 $T=292925 159275 0 180 $X=276625 $Y=140525
X139 49 21 38 37 ICV_2 $T=310975 164775 1 180 $X=294675 $Y=159025
X140 50 23 45 46 ICV_2 $T=347075 146275 1 180 $X=330775 $Y=140525
X141 55 27 53 52 ICV_2 $T=383175 159275 0 180 $X=366875 $Y=140525
X142 56 53 26 49 ICV_2 $T=383175 177775 0 180 $X=366875 $Y=159025
X143 GNDA GNDA GNDA GNDA GNDA ICV_4 $T=251725 249650 1 0 $X=251725 $Y=232850
X144 GNDA GNDA 26 26 26 ICV_4 $T=251725 268350 1 0 $X=251725 $Y=251550
X145 GNDA GNDA 26 26 26 ICV_4 $T=251725 287050 1 0 $X=251725 $Y=270250
X146 GNDA GNDA 26 26 26 ICV_4 $T=251725 305750 1 0 $X=251725 $Y=288950
X147 GNDA GNDA 26 26 GNDA ICV_4 $T=251725 324450 1 0 $X=251725 $Y=307650
X148 GNDA GNDA 26 26 26 ICV_4 $T=251725 343150 1 0 $X=251725 $Y=326350
X149 GNDA GNDA GNDA GNDA GNDA ICV_4 $T=251725 361850 1 0 $X=251725 $Y=345050
X150 GNDA GNDA GNDA GNDA GNDA ICV_4 $T=319325 249650 1 0 $X=319325 $Y=232850
X151 GNDA GNDA 26 26 26 ICV_4 $T=319325 268350 1 0 $X=319325 $Y=251550
X152 26 GNDA 26 26 26 ICV_4 $T=319325 287050 1 0 $X=319325 $Y=270250
X153 12 GNDA 26 26 26 ICV_4 $T=319325 305750 1 0 $X=319325 $Y=288950
X154 26 GNDA GNDA 26 26 ICV_4 $T=319325 324450 1 0 $X=319325 $Y=307650
X155 26 GNDA 26 26 26 ICV_4 $T=319325 343150 1 0 $X=319325 $Y=326350
X156 GNDA GNDA GNDA GNDA GNDA ICV_4 $T=319325 361850 1 0 $X=319325 $Y=345050
X168 GNDA 7 7 nmos4_CDNS_779828569776 $T=83875 144125 0 270 $X=83625 $Y=133725
X169 GNDA 8 7 nmos4_CDNS_779828569776 $T=83875 157525 0 270 $X=83625 $Y=147125
X170 GNDA 8 7 nmos4_CDNS_779828569776 $T=96675 144125 0 270 $X=96425 $Y=133725
X171 GNDA 7 7 nmos4_CDNS_779828569776 $T=96675 157525 0 270 $X=96425 $Y=147125
X172 GNDA 10 11 nmos4_CDNS_779828569776 $T=203625 277400 0 0 $X=203225 $Y=277150
X173 GNDA 11 11 nmos4_CDNS_779828569776 $T=203625 289700 0 0 $X=203225 $Y=289450
X174 GNDA 11 11 nmos4_CDNS_779828569776 $T=217125 277400 0 0 $X=216725 $Y=277150
X175 GNDA 10 11 nmos4_CDNS_779828569776 $T=217125 289700 0 0 $X=216725 $Y=289450
X205 3 7 8 15 12 ICV_6 $T=143875 155450 1 270 $X=136975 $Y=129250
X206 3 8 7 12 15 ICV_6 $T=143875 188350 1 270 $X=136975 $Y=162150
X207 3 7 8 15 12 ICV_6 $T=169075 155450 1 270 $X=162175 $Y=129250
X208 3 8 7 12 15 ICV_6 $T=169075 188350 1 270 $X=162175 $Y=162150
X303 VDDA ICV_9 $T=41275 219700 0 90 $X=28375 $Y=218500
X304 VDDA ICV_9 $T=41275 238000 0 90 $X=28375 $Y=236800
X305 VDDA ICV_9 $T=41275 256300 0 90 $X=28375 $Y=255100
X306 VDDA ICV_9 $T=41275 274600 0 90 $X=28375 $Y=273400
X307 VDDA ICV_9 $T=41275 292900 0 90 $X=28375 $Y=291700
X308 VDDA ICV_9 $T=41275 311200 0 90 $X=28375 $Y=310000
X309 VDDA ICV_9 $T=41275 329500 0 90 $X=28375 $Y=328300
X310 VDDA ICV_9 $T=41275 347800 0 90 $X=28375 $Y=346600
.ENDS
***************************************
