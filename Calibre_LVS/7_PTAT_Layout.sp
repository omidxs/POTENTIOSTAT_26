* SPICE NETLIST
***************************************

.SUBCKT tsv80 TOP BOTTOM SUB
.ENDS
***************************************
.SUBCKT rx POS NEG
.ENDS
***************************************
.SUBCKT Q C B E S G
.ENDS
***************************************
.SUBCKT lddn D G S B
.ENDS
***************************************
.SUBCKT phd POS NEG P
.ENDS
***************************************
.SUBCKT sbd A C SUB
.ENDS
***************************************
.SUBCKT esddlv2 A C
.ENDS
***************************************
.SUBCKT esddlv A C SUB
.ENDS
***************************************
.SUBCKT lddp D G S B
.ENDS
***************************************
.SUBCKT probepad pad
.ENDS
***************************************
.SUBCKT L POS NEG SUB
.ENDS
***************************************
.SUBCKT L POS NEG MID SUB
.ENDS
***************************************
.SUBCKT hall A B C D S P1 P2
.ENDS
***************************************
.SUBCKT cpolyc_CDNS_7804135732819 2 3
** N=3 EP=2 IP=0 FDC=1
C0 2 3 $[cpolya] $A=2306.26 $P=192.1 $X=1800 $Y=1000 $D=58
.ENDS
***************************************
.SUBCKT ICV_1 2 3
** N=3 EP=2 IP=6 FDC=2
X0 2 3 cpolyc_CDNS_7804135732819 $T=0 0 0 0 $X=-1350 $Y=-1350
X1 2 3 cpolyc_CDNS_7804135732819 $T=54900 0 0 0 $X=53550 $Y=-1350
.ENDS
***************************************
.SUBCKT P1_C_CDNS_7804135732817
** N=2 EP=0 IP=0 FDC=0
.ENDS
***************************************
.SUBCKT P1_C_CDNS_7804135732828
** N=2 EP=0 IP=0 FDC=0
.ENDS
***************************************
.SUBCKT ND_C_CDNS_7804135732891
** N=2 EP=0 IP=0 FDC=0
.ENDS
***************************************
.SUBCKT cpolyc_CDNS_780413573287 2 3
** N=3 EP=2 IP=0 FDC=1
C0 2 3 $[cpolya] $A=3466.12 $P=235.5 $X=1800 $Y=1000 $D=58
.ENDS
***************************************
.SUBCKT P1_C_CDNS_7804135732884
** N=2 EP=0 IP=0 FDC=0
.ENDS
***************************************
.SUBCKT P1_C_CDNS_7804135732886
** N=1 EP=0 IP=0 FDC=0
.ENDS
***************************************
.SUBCKT nmos4_CDNS_780413573289
** N=3 EP=0 IP=0 FDC=0
.ENDS
***************************************
.SUBCKT pmos4_CDNS_7804135732812
** N=4 EP=0 IP=0 FDC=0
.ENDS
***************************************
.SUBCKT ICV_2
** N=6 EP=0 IP=8 FDC=0
.ENDS
***************************************
.SUBCKT ICV_3 1 3 4 7 8
** N=10 EP=5 IP=12 FDC=2
M0 3 7 1 1 pmos4 L=4e-06 W=1e-05 AD=8.5e-12 AS=8.5e-12 PD=1.17e-05 PS=1.17e-05 NRD=0.0425 NRS=0.0425 $X=0 $Y=7150 $D=41
M1 4 8 1 1 pmos4 L=4e-06 W=1e-05 AD=8.5e-12 AS=8.5e-12 PD=1.17e-05 PS=1.17e-05 NRD=0.0425 NRS=0.0425 $X=0 $Y=13450 $D=41
.ENDS
***************************************
.SUBCKT nmos4_CDNS_7804135732811 1 2 3
** N=3 EP=3 IP=0 FDC=1
M0 2 3 1 1 nmos4 L=4e-06 W=1e-06 AD=8.5e-13 AS=8.5e-13 PD=2.7e-06 PS=2.7e-06 NRD=0.425 NRS=0.425 $X=0 $Y=850 $D=37
.ENDS
***************************************
.SUBCKT ICV_4 1 2 3 4
** N=4 EP=4 IP=6 FDC=2
X0 1 2 4 nmos4_CDNS_7804135732811 $T=0 -6300 0 0 $X=-400 $Y=-6550
X1 1 3 4 nmos4_CDNS_7804135732811 $T=0 0 0 0 $X=-400 $Y=-250
.ENDS
***************************************
.SUBCKT ICV_5 1 2 3 4 5
** N=6 EP=5 IP=20 FDC=8
M0 1 1 1 1 pmos4 L=4e-06 W=1e-05 AD=8.5e-12 AS=8.5e-12 PD=1.17e-05 PS=1.17e-05 NRD=0.0425 NRS=0.0425 $X=0 $Y=850 $D=42
M1 2 4 1 1 pmos4 L=4e-06 W=1e-05 AD=8.5e-12 AS=8.5e-12 PD=1.17e-05 PS=1.17e-05 NRD=0.0425 NRS=0.0425 $X=0 $Y=19750 $D=41
M2 3 5 1 1 pmos4 L=4e-06 W=1e-05 AD=8.5e-12 AS=8.5e-12 PD=1.17e-05 PS=1.17e-05 NRD=0.0425 NRS=0.0425 $X=0 $Y=26050 $D=41
M3 2 4 1 1 pmos4 L=4e-06 W=1e-05 AD=8.5e-12 AS=8.5e-12 PD=1.17e-05 PS=1.17e-05 NRD=0.0425 NRS=0.0425 $X=0 $Y=44950 $D=41
X4 1 2 3 4 5 ICV_3 $T=0 0 0 0 $X=-1200 $Y=-1200
X5 1 2 3 4 5 ICV_3 $T=0 25200 0 0 $X=-1200 $Y=24000
.ENDS
***************************************
.SUBCKT pmos4_CDNS_7804135732813
** N=4 EP=0 IP=0 FDC=0
.ENDS
***************************************
.SUBCKT ICV_6
** N=6 EP=0 IP=8 FDC=0
.ENDS
***************************************
.SUBCKT ICV_7
** N=9 EP=0 IP=12 FDC=0
.ENDS
***************************************
.SUBCKT ICV_8 1
** N=8 EP=1 IP=27 FDC=2
M0 1 1 1 1 pmos4 L=1e-05 W=2e-06 AD=1.7e-12 AS=1.7e-12 PD=3.7e-06 PS=3.7e-06 NRD=0.2125 NRS=0.2125 $X=0 $Y=850 $D=42
M1 1 1 1 1 pmos4 L=1e-05 W=2e-06 AD=1.7e-12 AS=1.7e-12 PD=3.7e-06 PS=3.7e-06 NRD=0.2125 NRS=0.2125 $X=0 $Y=136150 $D=42
.ENDS
***************************************
.SUBCKT nmos4_CDNS_780413573288 1 2 3 4
** N=4 EP=4 IP=0 FDC=4
M0 2 3 1 4 nmos4 L=4e-06 W=1e-06 AD=5e-13 AS=8.5e-13 PD=1e-06 PS=2.7e-06 NRD=0.425 NRS=0.425 $X=0 $Y=850 $D=37
M1 1 3 2 4 nmos4 L=4e-06 W=1e-06 AD=5e-13 AS=5e-13 PD=1e-06 PS=1e-06 NRD=0.425 NRS=0.425 $X=0 $Y=5850 $D=37
M2 2 3 1 4 nmos4 L=4e-06 W=1e-06 AD=5e-13 AS=5e-13 PD=1e-06 PS=1e-06 NRD=0.425 NRS=0.425 $X=0 $Y=10850 $D=37
M3 1 3 2 4 nmos4 L=4e-06 W=1e-06 AD=8.5e-13 AS=5e-13 PD=2.7e-06 PS=1e-06 NRD=0.425 NRS=0.425 $X=0 $Y=15850 $D=37
.ENDS
***************************************
.SUBCKT 6_CA_Front_Layout GNDA Vout VDDA Ibias Vin- Vin+
** N=13 EP=6 IP=357 FDC=152
R0 5 11 L=9.01902e-05 W=2e-06 $[rpolyh] $X=125725 $Y=12550 $D=17
M1 Ibias GNDA Ibias GNDA cvar w=0.0002112 l=6.5e-07 cols=16 rows=2 $X=29925 $Y=26950 $D=62
D2 GNDA Ibias p_nwd AREA=426.58 PJ=86.2 $X=29625 $Y=26650 $D=87
D3 GNDA 8 p_nwd AREA=5058.12 PJ=304.9 $X=7150 $Y=45100 $D=87
D4 GNDA GNDA p_nwd AREA=5519.48 PJ=302.1 $X=121050 $Y=6900 $D=87
D5 GNDA VDDA p_nwd AREA=23782.7 PJ=626.3 $X=2150 $Y=97000 $D=87
M6 GNDA GNDA GNDA GNDA nmos4 L=2e-05 W=5e-06 AD=4.25e-12 AS=4.25e-12 PD=6.7e-06 PS=6.7e-06 NRD=0.085 NRS=0.085 $X=61350 $Y=19875 $D=38
M7 GNDA GNDA GNDA GNDA nmos4 L=2e-05 W=5e-06 AD=4.25e-12 AS=4.25e-12 PD=6.7e-06 PS=6.7e-06 NRD=0.085 NRS=0.085 $X=80100 $Y=19875 $D=38
M8 5 6 GNDA GNDA nmos4 L=2e-05 W=5e-06 AD=4.25e-12 AS=4.25e-12 PD=6.7e-06 PS=6.7e-06 NRD=0.085 NRS=0.085 $X=67600 $Y=19875 $D=37
M9 6 6 GNDA GNDA nmos4 L=2e-05 W=5e-06 AD=4.25e-12 AS=4.25e-12 PD=6.7e-06 PS=6.7e-06 NRD=0.085 NRS=0.085 $X=73850 $Y=19875 $D=37
M10 GNDA 5 Vout GNDA nmos4 L=4e-06 W=2e-05 AD=1e-11 AS=1.7e-11 PD=1e-06 PS=2.17e-05 NRD=0.02125 NRS=0.02125 $X=91450 $Y=14975 $D=37
M11 Vout 5 GNDA GNDA nmos4 L=4e-06 W=2e-05 AD=1e-11 AS=1e-11 PD=1e-06 PS=1e-06 NRD=0.02125 NRS=0.02125 $X=96450 $Y=14975 $D=37
M12 GNDA 5 Vout GNDA nmos4 L=4e-06 W=2e-05 AD=1e-11 AS=1e-11 PD=1e-06 PS=1e-06 NRD=0.02125 NRS=0.02125 $X=101450 $Y=14975 $D=37
M13 Vout 5 GNDA GNDA nmos4 L=4e-06 W=2e-05 AD=1e-11 AS=1e-11 PD=1e-06 PS=1e-06 NRD=0.02125 NRS=0.02125 $X=106450 $Y=14975 $D=37
M14 GNDA 5 Vout GNDA nmos4 L=4e-06 W=2e-05 AD=1.7e-11 AS=1e-11 PD=2.17e-05 PS=1e-06 NRD=0.02125 NRS=0.02125 $X=111450 $Y=14975 $D=37
M15 VDDA VDDA VDDA VDDA pmos4 L=1e-05 W=2e-06 AD=1.7e-12 AS=1.7e-12 PD=3.7e-06 PS=3.7e-06 NRD=0.2125 NRS=0.2125 $X=33625 $Y=117350 $D=42
M16 VDDA VDDA VDDA VDDA pmos4 L=1e-05 W=2e-06 AD=1.7e-12 AS=1.7e-12 PD=3.7e-06 PS=3.7e-06 NRD=0.2125 NRS=0.2125 $X=33625 $Y=204150 $D=42
M17 VDDA VDDA VDDA VDDA pmos4 L=1e-05 W=2e-06 AD=1.7e-12 AS=1.7e-12 PD=3.7e-06 PS=3.7e-06 NRD=0.2125 NRS=0.2125 $X=45925 $Y=117350 $D=42
M18 VDDA VDDA VDDA VDDA pmos4 L=1e-05 W=2e-06 AD=1.7e-12 AS=1.7e-12 PD=3.7e-06 PS=3.7e-06 NRD=0.2125 NRS=0.2125 $X=45925 $Y=204150 $D=42
M19 VDDA VDDA VDDA VDDA pmos4 L=1e-05 W=2e-06 AD=1.7e-12 AS=1.7e-12 PD=3.7e-06 PS=3.7e-06 NRD=0.2125 NRS=0.2125 $X=58225 $Y=117350 $D=42
M20 VDDA VDDA VDDA VDDA pmos4 L=1e-05 W=2e-06 AD=1.7e-12 AS=1.7e-12 PD=3.7e-06 PS=3.7e-06 NRD=0.2125 NRS=0.2125 $X=58225 $Y=204150 $D=42
M21 VDDA VDDA VDDA VDDA pmos4 L=1e-05 W=2e-06 AD=1.7e-12 AS=1.7e-12 PD=3.7e-06 PS=3.7e-06 NRD=0.2125 NRS=0.2125 $X=70525 $Y=117350 $D=42
M22 VDDA VDDA VDDA VDDA pmos4 L=1e-05 W=2e-06 AD=1.7e-12 AS=1.7e-12 PD=3.7e-06 PS=3.7e-06 NRD=0.2125 NRS=0.2125 $X=70525 $Y=204150 $D=42
M23 VDDA VDDA VDDA VDDA pmos4 L=1e-05 W=2e-06 AD=1.7e-12 AS=1.7e-12 PD=3.7e-06 PS=3.7e-06 NRD=0.2125 NRS=0.2125 $X=82825 $Y=117350 $D=42
M24 VDDA VDDA VDDA VDDA pmos4 L=1e-05 W=2e-06 AD=1.7e-12 AS=1.7e-12 PD=3.7e-06 PS=3.7e-06 NRD=0.2125 NRS=0.2125 $X=82825 $Y=204150 $D=42
M25 8 8 8 8 pmos4 L=4e-06 W=1e-05 AD=8.5e-12 AS=8.5e-12 PD=1.17e-05 PS=1.17e-05 NRD=0.0425 NRS=0.0425 $X=91625 $Y=56425 $D=42
M26 8 8 8 8 pmos4 L=4e-06 W=1e-05 AD=8.5e-12 AS=8.5e-12 PD=1.17e-05 PS=1.17e-05 NRD=0.0425 NRS=0.0425 $X=91625 $Y=72575 $D=42
M27 VDDA VDDA VDDA VDDA pmos4 L=1e-05 W=2e-06 AD=1.7e-12 AS=1.7e-12 PD=3.7e-06 PS=3.7e-06 NRD=0.2125 NRS=0.2125 $X=95125 $Y=117350 $D=42
M28 VDDA VDDA VDDA VDDA pmos4 L=1e-05 W=2e-06 AD=1.7e-12 AS=1.7e-12 PD=3.7e-06 PS=3.7e-06 NRD=0.2125 NRS=0.2125 $X=95125 $Y=204150 $D=42
M29 VDDA VDDA VDDA VDDA pmos4 L=1e-05 W=2e-06 AD=1.7e-12 AS=1.7e-12 PD=3.7e-06 PS=3.7e-06 NRD=0.2125 NRS=0.2125 $X=107425 $Y=117350 $D=42
M30 VDDA VDDA VDDA VDDA pmos4 L=1e-05 W=2e-06 AD=1.7e-12 AS=1.7e-12 PD=3.7e-06 PS=3.7e-06 NRD=0.2125 NRS=0.2125 $X=107425 $Y=204150 $D=42
M31 VDDA VDDA VDDA VDDA pmos4 L=1e-05 W=2e-06 AD=1.7e-12 AS=1.7e-12 PD=3.7e-06 PS=3.7e-06 NRD=0.2125 NRS=0.2125 $X=119725 $Y=117350 $D=42
M32 VDDA VDDA VDDA VDDA pmos4 L=1e-05 W=2e-06 AD=1.7e-12 AS=1.7e-12 PD=3.7e-06 PS=3.7e-06 NRD=0.2125 NRS=0.2125 $X=119725 $Y=204150 $D=42
M33 VDDA VDDA VDDA VDDA pmos4 L=1e-05 W=2e-06 AD=1.7e-12 AS=1.7e-12 PD=3.7e-06 PS=3.7e-06 NRD=0.2125 NRS=0.2125 $X=132025 $Y=117350 $D=42
M34 VDDA VDDA VDDA VDDA pmos4 L=1e-05 W=2e-06 AD=1.7e-12 AS=1.7e-12 PD=3.7e-06 PS=3.7e-06 NRD=0.2125 NRS=0.2125 $X=132025 $Y=204150 $D=42
M35 VDDA VDDA VDDA VDDA pmos4 L=1e-05 W=2e-06 AD=1.7e-12 AS=1.7e-12 PD=3.7e-06 PS=3.7e-06 NRD=0.2125 NRS=0.2125 $X=144325 $Y=117350 $D=42
M36 VDDA VDDA VDDA VDDA pmos4 L=1e-05 W=2e-06 AD=1.7e-12 AS=1.7e-12 PD=3.7e-06 PS=3.7e-06 NRD=0.2125 NRS=0.2125 $X=144325 $Y=204150 $D=42
M37 Vout 2 VDDA VDDA pmos4 L=1e-05 W=2e-06 AD=1.7e-12 AS=1.7e-12 PD=3.7e-06 PS=3.7e-06 NRD=0.2125 NRS=0.2125 $X=33625 $Y=129750 $D=41
M38 Vout 2 VDDA VDDA pmos4 L=1e-05 W=2e-06 AD=1.7e-12 AS=1.7e-12 PD=3.7e-06 PS=3.7e-06 NRD=0.2125 NRS=0.2125 $X=33625 $Y=142150 $D=41
M39 Vout 2 VDDA VDDA pmos4 L=1e-05 W=2e-06 AD=1.7e-12 AS=1.7e-12 PD=3.7e-06 PS=3.7e-06 NRD=0.2125 NRS=0.2125 $X=33625 $Y=154550 $D=41
M40 Vout 2 VDDA VDDA pmos4 L=1e-05 W=2e-06 AD=1.7e-12 AS=1.7e-12 PD=3.7e-06 PS=3.7e-06 NRD=0.2125 NRS=0.2125 $X=33625 $Y=166950 $D=41
M41 Vout 2 VDDA VDDA pmos4 L=1e-05 W=2e-06 AD=1.7e-12 AS=1.7e-12 PD=3.7e-06 PS=3.7e-06 NRD=0.2125 NRS=0.2125 $X=33625 $Y=179350 $D=41
M42 Vout 2 VDDA VDDA pmos4 L=1e-05 W=2e-06 AD=1.7e-12 AS=1.7e-12 PD=3.7e-06 PS=3.7e-06 NRD=0.2125 NRS=0.2125 $X=33625 $Y=191750 $D=41
M43 Vout 2 VDDA VDDA pmos4 L=1e-05 W=2e-06 AD=1.7e-12 AS=1.7e-12 PD=3.7e-06 PS=3.7e-06 NRD=0.2125 NRS=0.2125 $X=45925 $Y=129750 $D=41
M44 Vout 2 VDDA VDDA pmos4 L=1e-05 W=2e-06 AD=1.7e-12 AS=1.7e-12 PD=3.7e-06 PS=3.7e-06 NRD=0.2125 NRS=0.2125 $X=45925 $Y=142150 $D=41
M45 Vout 2 VDDA VDDA pmos4 L=1e-05 W=2e-06 AD=1.7e-12 AS=1.7e-12 PD=3.7e-06 PS=3.7e-06 NRD=0.2125 NRS=0.2125 $X=45925 $Y=154550 $D=41
M46 Vout 2 VDDA VDDA pmos4 L=1e-05 W=2e-06 AD=1.7e-12 AS=1.7e-12 PD=3.7e-06 PS=3.7e-06 NRD=0.2125 NRS=0.2125 $X=45925 $Y=166950 $D=41
M47 Vout 2 VDDA VDDA pmos4 L=1e-05 W=2e-06 AD=1.7e-12 AS=1.7e-12 PD=3.7e-06 PS=3.7e-06 NRD=0.2125 NRS=0.2125 $X=45925 $Y=179350 $D=41
M48 Vout 2 VDDA VDDA pmos4 L=1e-05 W=2e-06 AD=1.7e-12 AS=1.7e-12 PD=3.7e-06 PS=3.7e-06 NRD=0.2125 NRS=0.2125 $X=45925 $Y=191750 $D=41
M49 Vout 2 VDDA VDDA pmos4 L=1e-05 W=2e-06 AD=1.7e-12 AS=1.7e-12 PD=3.7e-06 PS=3.7e-06 NRD=0.2125 NRS=0.2125 $X=58225 $Y=129750 $D=41
M50 Vout 2 VDDA VDDA pmos4 L=1e-05 W=2e-06 AD=1.7e-12 AS=1.7e-12 PD=3.7e-06 PS=3.7e-06 NRD=0.2125 NRS=0.2125 $X=58225 $Y=142150 $D=41
M51 Vout 2 VDDA VDDA pmos4 L=1e-05 W=2e-06 AD=1.7e-12 AS=1.7e-12 PD=3.7e-06 PS=3.7e-06 NRD=0.2125 NRS=0.2125 $X=58225 $Y=154550 $D=41
M52 Vout 2 VDDA VDDA pmos4 L=1e-05 W=2e-06 AD=1.7e-12 AS=1.7e-12 PD=3.7e-06 PS=3.7e-06 NRD=0.2125 NRS=0.2125 $X=58225 $Y=166950 $D=41
M53 Vout 2 VDDA VDDA pmos4 L=1e-05 W=2e-06 AD=1.7e-12 AS=1.7e-12 PD=3.7e-06 PS=3.7e-06 NRD=0.2125 NRS=0.2125 $X=58225 $Y=179350 $D=41
M54 Vout 2 VDDA VDDA pmos4 L=1e-05 W=2e-06 AD=1.7e-12 AS=1.7e-12 PD=3.7e-06 PS=3.7e-06 NRD=0.2125 NRS=0.2125 $X=58225 $Y=191750 $D=41
M55 Vout 2 VDDA VDDA pmos4 L=1e-05 W=2e-06 AD=1.7e-12 AS=1.7e-12 PD=3.7e-06 PS=3.7e-06 NRD=0.2125 NRS=0.2125 $X=70525 $Y=129750 $D=41
M56 Vout 2 VDDA VDDA pmos4 L=1e-05 W=2e-06 AD=1.7e-12 AS=1.7e-12 PD=3.7e-06 PS=3.7e-06 NRD=0.2125 NRS=0.2125 $X=70525 $Y=142150 $D=41
M57 8 2 VDDA VDDA pmos4 L=1e-05 W=2e-06 AD=1.7e-12 AS=1.7e-12 PD=3.7e-06 PS=3.7e-06 NRD=0.2125 NRS=0.2125 $X=70525 $Y=154550 $D=41
M58 Vout 2 VDDA VDDA pmos4 L=1e-05 W=2e-06 AD=1.7e-12 AS=1.7e-12 PD=3.7e-06 PS=3.7e-06 NRD=0.2125 NRS=0.2125 $X=70525 $Y=166950 $D=41
M59 Vout 2 VDDA VDDA pmos4 L=1e-05 W=2e-06 AD=1.7e-12 AS=1.7e-12 PD=3.7e-06 PS=3.7e-06 NRD=0.2125 NRS=0.2125 $X=70525 $Y=179350 $D=41
M60 Vout 2 VDDA VDDA pmos4 L=1e-05 W=2e-06 AD=1.7e-12 AS=1.7e-12 PD=3.7e-06 PS=3.7e-06 NRD=0.2125 NRS=0.2125 $X=70525 $Y=191750 $D=41
M61 6 Vin- 8 8 pmos4 L=4e-06 W=1e-05 AD=8.5e-12 AS=8.5e-12 PD=1.17e-05 PS=1.17e-05 NRD=0.0425 NRS=0.0425 $X=72725 $Y=56425 $D=41
M62 5 Vin+ 8 8 pmos4 L=4e-06 W=1e-05 AD=8.5e-12 AS=8.5e-12 PD=1.17e-05 PS=1.17e-05 NRD=0.0425 NRS=0.0425 $X=72725 $Y=72575 $D=41
M63 Vout 2 VDDA VDDA pmos4 L=1e-05 W=2e-06 AD=1.7e-12 AS=1.7e-12 PD=3.7e-06 PS=3.7e-06 NRD=0.2125 NRS=0.2125 $X=82825 $Y=129750 $D=41
M64 8 2 VDDA VDDA pmos4 L=1e-05 W=2e-06 AD=1.7e-12 AS=1.7e-12 PD=3.7e-06 PS=3.7e-06 NRD=0.2125 NRS=0.2125 $X=82825 $Y=142150 $D=41
M65 2 2 VDDA VDDA pmos4 L=1e-05 W=2e-06 AD=1.7e-12 AS=1.7e-12 PD=3.7e-06 PS=3.7e-06 NRD=0.2125 NRS=0.2125 $X=82825 $Y=154550 $D=41
M66 8 2 VDDA VDDA pmos4 L=1e-05 W=2e-06 AD=1.7e-12 AS=1.7e-12 PD=3.7e-06 PS=3.7e-06 NRD=0.2125 NRS=0.2125 $X=82825 $Y=166950 $D=41
M67 8 2 VDDA VDDA pmos4 L=1e-05 W=2e-06 AD=1.7e-12 AS=1.7e-12 PD=3.7e-06 PS=3.7e-06 NRD=0.2125 NRS=0.2125 $X=82825 $Y=179350 $D=41
M68 Vout 2 VDDA VDDA pmos4 L=1e-05 W=2e-06 AD=1.7e-12 AS=1.7e-12 PD=3.7e-06 PS=3.7e-06 NRD=0.2125 NRS=0.2125 $X=82825 $Y=191750 $D=41
M69 Vout 2 VDDA VDDA pmos4 L=1e-05 W=2e-06 AD=1.7e-12 AS=1.7e-12 PD=3.7e-06 PS=3.7e-06 NRD=0.2125 NRS=0.2125 $X=95125 $Y=129750 $D=41
M70 8 2 VDDA VDDA pmos4 L=1e-05 W=2e-06 AD=1.7e-12 AS=1.7e-12 PD=3.7e-06 PS=3.7e-06 NRD=0.2125 NRS=0.2125 $X=95125 $Y=142150 $D=41
M71 8 2 VDDA VDDA pmos4 L=1e-05 W=2e-06 AD=1.7e-12 AS=1.7e-12 PD=3.7e-06 PS=3.7e-06 NRD=0.2125 NRS=0.2125 $X=95125 $Y=154550 $D=41
M72 2 2 VDDA VDDA pmos4 L=1e-05 W=2e-06 AD=1.7e-12 AS=1.7e-12 PD=3.7e-06 PS=3.7e-06 NRD=0.2125 NRS=0.2125 $X=95125 $Y=166950 $D=41
M73 8 2 VDDA VDDA pmos4 L=1e-05 W=2e-06 AD=1.7e-12 AS=1.7e-12 PD=3.7e-06 PS=3.7e-06 NRD=0.2125 NRS=0.2125 $X=95125 $Y=179350 $D=41
M74 Vout 2 VDDA VDDA pmos4 L=1e-05 W=2e-06 AD=1.7e-12 AS=1.7e-12 PD=3.7e-06 PS=3.7e-06 NRD=0.2125 NRS=0.2125 $X=95125 $Y=191750 $D=41
M75 Vout 2 VDDA VDDA pmos4 L=1e-05 W=2e-06 AD=1.7e-12 AS=1.7e-12 PD=3.7e-06 PS=3.7e-06 NRD=0.2125 NRS=0.2125 $X=107425 $Y=129750 $D=41
M76 Vout 2 VDDA VDDA pmos4 L=1e-05 W=2e-06 AD=1.7e-12 AS=1.7e-12 PD=3.7e-06 PS=3.7e-06 NRD=0.2125 NRS=0.2125 $X=107425 $Y=142150 $D=41
M77 Vout 2 VDDA VDDA pmos4 L=1e-05 W=2e-06 AD=1.7e-12 AS=1.7e-12 PD=3.7e-06 PS=3.7e-06 NRD=0.2125 NRS=0.2125 $X=107425 $Y=154550 $D=41
M78 8 2 VDDA VDDA pmos4 L=1e-05 W=2e-06 AD=1.7e-12 AS=1.7e-12 PD=3.7e-06 PS=3.7e-06 NRD=0.2125 NRS=0.2125 $X=107425 $Y=166950 $D=41
M79 Vout 2 VDDA VDDA pmos4 L=1e-05 W=2e-06 AD=1.7e-12 AS=1.7e-12 PD=3.7e-06 PS=3.7e-06 NRD=0.2125 NRS=0.2125 $X=107425 $Y=179350 $D=41
M80 Vout 2 VDDA VDDA pmos4 L=1e-05 W=2e-06 AD=1.7e-12 AS=1.7e-12 PD=3.7e-06 PS=3.7e-06 NRD=0.2125 NRS=0.2125 $X=107425 $Y=191750 $D=41
M81 Vout 2 VDDA VDDA pmos4 L=1e-05 W=2e-06 AD=1.7e-12 AS=1.7e-12 PD=3.7e-06 PS=3.7e-06 NRD=0.2125 NRS=0.2125 $X=119725 $Y=129750 $D=41
M82 Vout 2 VDDA VDDA pmos4 L=1e-05 W=2e-06 AD=1.7e-12 AS=1.7e-12 PD=3.7e-06 PS=3.7e-06 NRD=0.2125 NRS=0.2125 $X=119725 $Y=142150 $D=41
M83 Vout 2 VDDA VDDA pmos4 L=1e-05 W=2e-06 AD=1.7e-12 AS=1.7e-12 PD=3.7e-06 PS=3.7e-06 NRD=0.2125 NRS=0.2125 $X=119725 $Y=154550 $D=41
M84 Vout 2 VDDA VDDA pmos4 L=1e-05 W=2e-06 AD=1.7e-12 AS=1.7e-12 PD=3.7e-06 PS=3.7e-06 NRD=0.2125 NRS=0.2125 $X=119725 $Y=166950 $D=41
M85 Vout 2 VDDA VDDA pmos4 L=1e-05 W=2e-06 AD=1.7e-12 AS=1.7e-12 PD=3.7e-06 PS=3.7e-06 NRD=0.2125 NRS=0.2125 $X=119725 $Y=179350 $D=41
M86 Vout 2 VDDA VDDA pmos4 L=1e-05 W=2e-06 AD=1.7e-12 AS=1.7e-12 PD=3.7e-06 PS=3.7e-06 NRD=0.2125 NRS=0.2125 $X=119725 $Y=191750 $D=41
M87 Vout 2 VDDA VDDA pmos4 L=1e-05 W=2e-06 AD=1.7e-12 AS=1.7e-12 PD=3.7e-06 PS=3.7e-06 NRD=0.2125 NRS=0.2125 $X=132025 $Y=129750 $D=41
M88 Vout 2 VDDA VDDA pmos4 L=1e-05 W=2e-06 AD=1.7e-12 AS=1.7e-12 PD=3.7e-06 PS=3.7e-06 NRD=0.2125 NRS=0.2125 $X=132025 $Y=142150 $D=41
M89 Vout 2 VDDA VDDA pmos4 L=1e-05 W=2e-06 AD=1.7e-12 AS=1.7e-12 PD=3.7e-06 PS=3.7e-06 NRD=0.2125 NRS=0.2125 $X=132025 $Y=154550 $D=41
M90 Vout 2 VDDA VDDA pmos4 L=1e-05 W=2e-06 AD=1.7e-12 AS=1.7e-12 PD=3.7e-06 PS=3.7e-06 NRD=0.2125 NRS=0.2125 $X=132025 $Y=166950 $D=41
M91 Vout 2 VDDA VDDA pmos4 L=1e-05 W=2e-06 AD=1.7e-12 AS=1.7e-12 PD=3.7e-06 PS=3.7e-06 NRD=0.2125 NRS=0.2125 $X=132025 $Y=179350 $D=41
M92 Vout 2 VDDA VDDA pmos4 L=1e-05 W=2e-06 AD=1.7e-12 AS=1.7e-12 PD=3.7e-06 PS=3.7e-06 NRD=0.2125 NRS=0.2125 $X=132025 $Y=191750 $D=41
M93 Vout 2 VDDA VDDA pmos4 L=1e-05 W=2e-06 AD=1.7e-12 AS=1.7e-12 PD=3.7e-06 PS=3.7e-06 NRD=0.2125 NRS=0.2125 $X=144325 $Y=129750 $D=41
M94 Vout 2 VDDA VDDA pmos4 L=1e-05 W=2e-06 AD=1.7e-12 AS=1.7e-12 PD=3.7e-06 PS=3.7e-06 NRD=0.2125 NRS=0.2125 $X=144325 $Y=142150 $D=41
M95 Vout 2 VDDA VDDA pmos4 L=1e-05 W=2e-06 AD=1.7e-12 AS=1.7e-12 PD=3.7e-06 PS=3.7e-06 NRD=0.2125 NRS=0.2125 $X=144325 $Y=154550 $D=41
M96 Vout 2 VDDA VDDA pmos4 L=1e-05 W=2e-06 AD=1.7e-12 AS=1.7e-12 PD=3.7e-06 PS=3.7e-06 NRD=0.2125 NRS=0.2125 $X=144325 $Y=166950 $D=41
M97 Vout 2 VDDA VDDA pmos4 L=1e-05 W=2e-06 AD=1.7e-12 AS=1.7e-12 PD=3.7e-06 PS=3.7e-06 NRD=0.2125 NRS=0.2125 $X=144325 $Y=179350 $D=41
M98 Vout 2 VDDA VDDA pmos4 L=1e-05 W=2e-06 AD=1.7e-12 AS=1.7e-12 PD=3.7e-06 PS=3.7e-06 NRD=0.2125 NRS=0.2125 $X=144325 $Y=191750 $D=41
X205 Vout 11 cpolyc_CDNS_780413573287 $T=123200 92600 0 270 $X=121850 $Y=29200
X216 8 5 6 Vin+ Vin- ICV_3 $T=71875 66425 0 270 $X=70675 $Y=55225
X217 8 6 5 Vin- Vin+ ICV_3 $T=71875 82575 0 270 $X=70675 $Y=71375
X218 GNDA 9 1 9 ICV_4 $T=15375 13250 0 90 $X=9425 $Y=12850
X219 GNDA 1 9 9 ICV_4 $T=15375 18150 0 90 $X=9425 $Y=17750
X220 GNDA 9 1 9 ICV_4 $T=27975 13250 0 90 $X=22025 $Y=12850
X221 GNDA 1 9 9 ICV_4 $T=27975 18150 0 90 $X=22025 $Y=17750
X222 8 5 6 Vin+ Vin- ICV_5 $T=21475 66425 0 270 $X=20275 $Y=55225
X223 8 6 5 Vin- Vin+ ICV_5 $T=21475 82575 0 270 $X=20275 $Y=71375
X224 VDDA ICV_8 $T=20475 117350 1 90 $X=19275 $Y=116150
X225 VDDA ICV_8 $T=20475 129750 1 90 $X=19275 $Y=128550
X226 VDDA ICV_8 $T=20475 142150 1 90 $X=19275 $Y=140950
X227 VDDA ICV_8 $T=20475 154550 1 90 $X=19275 $Y=153350
X228 VDDA ICV_8 $T=20475 166950 1 90 $X=19275 $Y=165750
X229 VDDA ICV_8 $T=20475 179350 1 90 $X=19275 $Y=178150
X230 VDDA ICV_8 $T=20475 191750 1 90 $X=19275 $Y=190550
X231 VDDA ICV_8 $T=20475 204150 1 90 $X=19275 $Y=202950
X232 9 Ibias Ibias GNDA nmos4_CDNS_780413573288 $T=4175 32450 1 90 $X=3925 $Y=31650
X233 1 2 Ibias GNDA nmos4_CDNS_780413573288 $T=4175 39750 0 270 $X=3925 $Y=37950
.ENDS
***************************************
.SUBCKT rpolyhc_CDNS_780413573280 1 2
** N=3 EP=2 IP=0 FDC=1
R0 1 2 L=5.005e-05 W=8e-07 $[rpolyh] $X=-800 $Y=1550 $D=18
.ENDS
***************************************
.SUBCKT vert10_4 1 2
** N=2 EP=2 IP=0 FDC=1
Q0 2 2 1 pnpvert10 AREA=1e-12 $X=1400 $Y=1400 $D=33
.ENDS
***************************************
.SUBCKT ICV_9 1 2 3
** N=3 EP=3 IP=4 FDC=2
X0 1 2 vert10_4 $T=0 0 0 0 $X=0 $Y=0
X1 3 2 vert10_4 $T=16900 0 0 0 $X=16900 $Y=0
.ENDS
***************************************
.SUBCKT ICV_10 1 2 3
** N=3 EP=3 IP=6 FDC=4
X0 2 1 3 ICV_9 $T=0 0 0 0 $X=0 $Y=0
X1 3 1 3 ICV_9 $T=33800 0 0 0 $X=33800 $Y=0
.ENDS
***************************************
.SUBCKT ICV_11 1 2 3
** N=3 EP=3 IP=8 FDC=9
X0 1 1 vert10_4 $T=135200 0 0 0 $X=135200 $Y=0
X1 1 1 2 ICV_10 $T=0 0 0 0 $X=0 $Y=0
X2 1 3 2 ICV_10 $T=67600 0 0 0 $X=67600 $Y=0
.ENDS
***************************************
.SUBCKT cvar_CDNS_7804135732820 1 2
** N=2 EP=2 IP=0 FDC=2
M0 2 1 2 1 cvar w=0.0004752 l=6.5e-07 cols=9 rows=8 $X=0 $Y=0 $D=62
D1 1 2 p_nwd AREA=1043.29 PJ=161.5 $X=-300 $Y=-300 $D=87
.ENDS
***************************************
.SUBCKT cvar_CDNS_7804135732822 1 2
** N=2 EP=2 IP=0 FDC=2
M0 2 1 2 1 cvar w=0.0006864 l=6.5e-07 cols=13 rows=8 $X=0 $Y=0 $D=62
D1 1 2 p_nwd AREA=1469.65 PJ=174.7 $X=-300 $Y=-300 $D=87
.ENDS
***************************************
.SUBCKT rpolyhc_CDNS_780413573281 1 2
** N=3 EP=2 IP=0 FDC=1
R0 1 2 L=0.00015005 W=2e-06 $[rpolyh] $X=-2000 $Y=2750 $D=18
.ENDS
***************************************
.SUBCKT P1_C_CDNS_7804135732867
** N=2 EP=0 IP=0 FDC=0
.ENDS
***************************************
.SUBCKT P1_C_CDNS_780413573283
** N=3 EP=0 IP=0 FDC=0
.ENDS
***************************************
.SUBCKT pmos4_CDNS_7804135732818
** N=4 EP=0 IP=0 FDC=0
.ENDS
***************************************
.SUBCKT ICV_12
** N=6 EP=0 IP=8 FDC=0
.ENDS
***************************************
.SUBCKT cvar_CDNS_7804135732823 1 2
** N=2 EP=2 IP=0 FDC=2
M0 2 1 2 1 cvar w=0.0003564 l=6.5e-07 cols=9 rows=6 $X=0 $Y=0 $D=62
D1 1 2 p_nwd AREA=778.43 PJ=128.7 $X=-300 $Y=-300 $D=87
.ENDS
***************************************
.SUBCKT nmos4_CDNS_7804135732815 1 2 3
** N=3 EP=3 IP=0 FDC=1
M0 2 3 1 1 nmos4 L=1e-05 W=1e-05 AD=8.5e-12 AS=8.5e-12 PD=1.17e-05 PS=1.17e-05 NRD=0.0425 NRS=0.0425 $X=0 $Y=850 $D=37
.ENDS
***************************************
.SUBCKT pmos4_CDNS_7804135732817
** N=4 EP=0 IP=0 FDC=0
.ENDS
***************************************
.SUBCKT ICV_13
** N=8 EP=0 IP=12 FDC=0
.ENDS
***************************************
.SUBCKT nmos4_CDNS_780413573285
** N=4 EP=0 IP=0 FDC=0
.ENDS
***************************************
.SUBCKT pmos4_CDNS_7804135732816
** N=4 EP=0 IP=0 FDC=0
.ENDS
***************************************
.SUBCKT ICV_14
** N=6 EP=0 IP=8 FDC=0
.ENDS
***************************************
.SUBCKT ICV_15 1 2 3 5 6
** N=8 EP=5 IP=12 FDC=3
M0 2 5 1 1 pmos4 L=2e-06 W=1e-05 AD=8.5e-12 AS=8.5e-12 PD=1.17e-05 PS=1.17e-05 NRD=0.0425 NRS=0.0425 $X=0 $Y=-12050 $D=41
M1 3 6 1 1 pmos4 L=2e-06 W=1e-05 AD=8.5e-12 AS=8.5e-12 PD=1.17e-05 PS=1.17e-05 NRD=0.0425 NRS=0.0425 $X=0 $Y=-7750 $D=41
M2 2 5 1 1 pmos4 L=2e-06 W=1e-05 AD=8.5e-12 AS=8.5e-12 PD=1.17e-05 PS=1.17e-05 NRD=0.0425 NRS=0.0425 $X=0 $Y=-3450 $D=41
.ENDS
***************************************
.SUBCKT P1_C_CDNS_7804135732820
** N=3 EP=0 IP=0 FDC=0
.ENDS
***************************************
.SUBCKT ICV_16 1 2 3 5 6
** N=8 EP=5 IP=16 FDC=7
M0 3 6 1 1 pmos4 L=2e-06 W=1e-05 AD=8.5e-12 AS=8.5e-12 PD=1.17e-05 PS=1.17e-05 NRD=0.0425 NRS=0.0425 $X=0 $Y=-16350 $D=41
X1 1 2 3 5 6 ICV_15 $T=0 -17200 0 0 $X=-1200 $Y=-31300
X2 1 2 3 5 6 ICV_15 $T=0 0 0 0 $X=-1200 $Y=-14100
.ENDS
***************************************
.SUBCKT P1_C_CDNS_7804135732831
** N=2 EP=0 IP=0 FDC=0
.ENDS
***************************************
.SUBCKT nmos4_CDNS_780413573282
** N=4 EP=0 IP=0 FDC=0
.ENDS
***************************************
.SUBCKT ICV_17
** N=6 EP=0 IP=8 FDC=0
.ENDS
***************************************
.SUBCKT ND_C_CDNS_7804135732863
** N=2 EP=0 IP=0 FDC=0
.ENDS
***************************************
.SUBCKT ICV_18 1
** N=7 EP=1 IP=26 FDC=2
M0 1 1 1 1 pmos4 L=1e-05 W=5e-06 AD=4.25e-12 AS=4.25e-12 PD=6.7e-06 PS=6.7e-06 NRD=0.085 NRS=0.085 $X=0 $Y=850 $D=42
M1 1 1 1 1 pmos4 L=1e-05 W=5e-06 AD=4.25e-12 AS=4.25e-12 PD=6.7e-06 PS=6.7e-06 NRD=0.085 NRS=0.085 $X=0 $Y=123850 $D=42
.ENDS
***************************************
.SUBCKT cvar_CDNS_7804135732821 1 2
** N=2 EP=2 IP=0 FDC=2
M0 2 1 2 1 cvar w=0.0003432 l=6.5e-07 cols=13 rows=4 $X=0 $Y=0 $D=62
D1 1 2 p_nwd AREA=723.45 PJ=109.1 $X=-300 $Y=-300 $D=87
.ENDS
***************************************
.SUBCKT 7_PTAT_Layout VDDA GNDA V_ptat_inv vref Ibias
** N=36 EP=5 IP=723 FDC=487
R0 GNDA GNDA L=5e-06 W=8e-07 $[rpolyh] $X=724325 $Y=435825 $D=18
D1 GNDA 2 p_nwd AREA=5489.96 PJ=326.3 $X=79825 $Y=219275 $D=87
D2 GNDA VDDA p_nwd AREA=29240.8 PJ=684 $X=2425 $Y=271500 $D=87
D3 GNDA 12 p_nwd AREA=1335.79 PJ=147.1 $X=180775 $Y=349950 $D=87
D4 GNDA GNDA p_nwd AREA=14782.1 PJ=544.4 $X=203025 $Y=210300 $D=87
D5 GNDA VDDA p_nwd AREA=4481.05 PJ=291.75 $X=179375 $Y=397025 $D=87
D6 GNDA GNDA p_nwd AREA=2501.19 PJ=209.45 $X=404725 $Y=214525 $D=87
D7 GNDA GNDA p_nwd AREA=58283.2 PJ=999.7 $X=689300 $Y=217750 $D=87
M8 Ibias Ibias Ibias GNDA nmos4 L=1e-05 W=5e-06 AD=4.25e-12 AS=4.25e-12 PD=6.7e-06 PS=6.7e-06 NRD=0.085 NRS=0.085 $X=8450 $Y=248900 $D=38
M9 5 5 5 GNDA nmos4 L=2e-05 W=1e-05 AD=8.5e-12 AS=8.5e-12 PD=1.17e-05 PS=1.17e-05 NRD=0.0425 NRS=0.0425 $X=31000 $Y=211750 $D=38
M10 Ibias Ibias Ibias GNDA nmos4 L=1e-05 W=5e-06 AD=4.25e-12 AS=4.25e-12 PD=6.7e-06 PS=6.7e-06 NRD=0.085 NRS=0.085 $X=64700 $Y=248900 $D=38
M11 5 5 5 GNDA nmos4 L=2e-05 W=1e-05 AD=8.5e-12 AS=8.5e-12 PD=1.17e-05 PS=1.17e-05 NRD=0.0425 NRS=0.0425 $X=64750 $Y=211750 $D=38
M12 1 Ibias GNDA GNDA nmos4 L=1e-05 W=5e-06 AD=4.25e-12 AS=4.25e-12 PD=6.7e-06 PS=6.7e-06 NRD=0.085 NRS=0.085 $X=14700 $Y=248900 $D=37
M13 Ibias Ibias GNDA GNDA nmos4 L=1e-05 W=5e-06 AD=4.25e-12 AS=4.25e-12 PD=6.7e-06 PS=6.7e-06 NRD=0.085 NRS=0.085 $X=20950 $Y=248900 $D=37
M14 18 Ibias GNDA GNDA nmos4 L=1e-05 W=5e-06 AD=4.25e-12 AS=4.25e-12 PD=6.7e-06 PS=6.7e-06 NRD=0.085 NRS=0.085 $X=27200 $Y=248900 $D=37
M15 1 Ibias GNDA GNDA nmos4 L=1e-05 W=5e-06 AD=4.25e-12 AS=4.25e-12 PD=6.7e-06 PS=6.7e-06 NRD=0.085 NRS=0.085 $X=33450 $Y=248900 $D=37
M16 1 Ibias GNDA GNDA nmos4 L=1e-05 W=5e-06 AD=4.25e-12 AS=4.25e-12 PD=6.7e-06 PS=6.7e-06 NRD=0.085 NRS=0.085 $X=39700 $Y=248900 $D=37
M17 6 5 GNDA GNDA nmos4 L=2e-05 W=1e-05 AD=8.5e-12 AS=8.5e-12 PD=1.17e-05 PS=1.17e-05 NRD=0.0425 NRS=0.0425 $X=42250 $Y=211750 $D=37
M18 18 Ibias GNDA GNDA nmos4 L=1e-05 W=5e-06 AD=4.25e-12 AS=4.25e-12 PD=6.7e-06 PS=6.7e-06 NRD=0.085 NRS=0.085 $X=45950 $Y=248900 $D=37
M19 Ibias Ibias GNDA GNDA nmos4 L=1e-05 W=5e-06 AD=4.25e-12 AS=4.25e-12 PD=6.7e-06 PS=6.7e-06 NRD=0.085 NRS=0.085 $X=52200 $Y=248900 $D=37
M20 5 5 GNDA GNDA nmos4 L=2e-05 W=1e-05 AD=8.5e-12 AS=8.5e-12 PD=1.17e-05 PS=1.17e-05 NRD=0.0425 NRS=0.0425 $X=53500 $Y=211750 $D=37
M21 1 Ibias GNDA GNDA nmos4 L=1e-05 W=5e-06 AD=4.25e-12 AS=4.25e-12 PD=6.7e-06 PS=6.7e-06 NRD=0.085 NRS=0.085 $X=58450 $Y=248900 $D=37
M22 3 8 19 GNDA nmos4 L=1e-05 W=5e-06 AD=4.25e-12 AS=4.25e-12 PD=6.7e-06 PS=6.7e-06 NRD=0.085 NRS=0.085 $X=182150 $Y=288300 $D=37
M23 19 6 GNDA GNDA nmos4 L=1e-06 W=5e-06 AD=2.5e-12 AS=4.25e-12 PD=1e-06 PS=6.7e-06 NRD=0.085 NRS=0.085 $X=188550 $Y=275750 $D=37
M24 GNDA 6 19 GNDA nmos4 L=1e-06 W=5e-06 AD=4.25e-12 AS=2.5e-12 PD=6.7e-06 PS=1e-06 NRD=0.085 NRS=0.085 $X=190550 $Y=275750 $D=37
M25 9 9 GNDA GNDA nmos4 L=1e-05 W=5e-07 AD=5.9e-13 AS=5.9e-13 PD=2.7e-06 PS=2.7e-06 NRD=0.85 NRS=0.85 $X=224800 $Y=364600 $D=37
M26 VDDA VDDA VDDA VDDA pmos4 L=1e-05 W=5e-06 AD=4.25e-12 AS=4.25e-12 PD=6.7e-06 PS=6.7e-06 NRD=0.085 NRS=0.085 $X=33925 $Y=289850 $D=42
M27 VDDA VDDA VDDA VDDA pmos4 L=1e-05 W=5e-06 AD=4.25e-12 AS=4.25e-12 PD=6.7e-06 PS=6.7e-06 NRD=0.085 NRS=0.085 $X=33925 $Y=416750 $D=42
M28 VDDA VDDA VDDA VDDA pmos4 L=1e-05 W=5e-06 AD=4.25e-12 AS=4.25e-12 PD=6.7e-06 PS=6.7e-06 NRD=0.085 NRS=0.085 $X=46225 $Y=289850 $D=42
M29 VDDA VDDA VDDA VDDA pmos4 L=1e-05 W=5e-06 AD=4.25e-12 AS=4.25e-12 PD=6.7e-06 PS=6.7e-06 NRD=0.085 NRS=0.085 $X=46225 $Y=416750 $D=42
M30 VDDA VDDA VDDA VDDA pmos4 L=1e-05 W=5e-06 AD=4.25e-12 AS=4.25e-12 PD=6.7e-06 PS=6.7e-06 NRD=0.085 NRS=0.085 $X=58525 $Y=289850 $D=42
M31 VDDA VDDA VDDA VDDA pmos4 L=1e-05 W=5e-06 AD=4.25e-12 AS=4.25e-12 PD=6.7e-06 PS=6.7e-06 NRD=0.085 NRS=0.085 $X=58525 $Y=416750 $D=42
M32 VDDA VDDA VDDA VDDA pmos4 L=1e-05 W=5e-06 AD=4.25e-12 AS=4.25e-12 PD=6.7e-06 PS=6.7e-06 NRD=0.085 NRS=0.085 $X=70825 $Y=289850 $D=42
M33 VDDA VDDA VDDA VDDA pmos4 L=1e-05 W=5e-06 AD=4.25e-12 AS=4.25e-12 PD=6.7e-06 PS=6.7e-06 NRD=0.085 NRS=0.085 $X=70825 $Y=416750 $D=42
M34 VDDA VDDA VDDA VDDA pmos4 L=1e-05 W=5e-06 AD=4.25e-12 AS=4.25e-12 PD=6.7e-06 PS=6.7e-06 NRD=0.085 NRS=0.085 $X=83125 $Y=289850 $D=42
M35 VDDA VDDA VDDA VDDA pmos4 L=1e-05 W=5e-06 AD=4.25e-12 AS=4.25e-12 PD=6.7e-06 PS=6.7e-06 NRD=0.085 NRS=0.085 $X=83125 $Y=416750 $D=42
M36 2 2 2 2 pmos4 L=2e-06 W=1e-05 AD=8.5e-12 AS=8.5e-12 PD=1.17e-05 PS=1.17e-05 NRD=0.0425 NRS=0.0425 $X=91525 $Y=230125 $D=42
M37 2 2 2 2 pmos4 L=2e-06 W=1e-05 AD=8.5e-12 AS=8.5e-12 PD=1.17e-05 PS=1.17e-05 NRD=0.0425 NRS=0.0425 $X=91525 $Y=245875 $D=42
M38 VDDA VDDA VDDA VDDA pmos4 L=1e-05 W=5e-06 AD=4.25e-12 AS=4.25e-12 PD=6.7e-06 PS=6.7e-06 NRD=0.085 NRS=0.085 $X=95425 $Y=289850 $D=42
M39 VDDA VDDA VDDA VDDA pmos4 L=1e-05 W=5e-06 AD=4.25e-12 AS=4.25e-12 PD=6.7e-06 PS=6.7e-06 NRD=0.085 NRS=0.085 $X=95425 $Y=416750 $D=42
M40 VDDA VDDA VDDA VDDA pmos4 L=1e-05 W=5e-06 AD=4.25e-12 AS=4.25e-12 PD=6.7e-06 PS=6.7e-06 NRD=0.085 NRS=0.085 $X=107725 $Y=289850 $D=42
M41 VDDA VDDA VDDA VDDA pmos4 L=1e-05 W=5e-06 AD=4.25e-12 AS=4.25e-12 PD=6.7e-06 PS=6.7e-06 NRD=0.085 NRS=0.085 $X=107725 $Y=416750 $D=42
M42 VDDA VDDA VDDA VDDA pmos4 L=1e-05 W=5e-06 AD=4.25e-12 AS=4.25e-12 PD=6.7e-06 PS=6.7e-06 NRD=0.085 NRS=0.085 $X=120025 $Y=289850 $D=42
M43 VDDA VDDA VDDA VDDA pmos4 L=1e-05 W=5e-06 AD=4.25e-12 AS=4.25e-12 PD=6.7e-06 PS=6.7e-06 NRD=0.085 NRS=0.085 $X=120025 $Y=416750 $D=42
M44 VDDA VDDA VDDA VDDA pmos4 L=1e-05 W=5e-06 AD=4.25e-12 AS=4.25e-12 PD=6.7e-06 PS=6.7e-06 NRD=0.085 NRS=0.085 $X=132325 $Y=289850 $D=42
M45 VDDA VDDA VDDA VDDA pmos4 L=1e-05 W=5e-06 AD=4.25e-12 AS=4.25e-12 PD=6.7e-06 PS=6.7e-06 NRD=0.085 NRS=0.085 $X=132325 $Y=416750 $D=42
M46 2 2 2 2 pmos4 L=2e-06 W=1e-05 AD=8.5e-12 AS=8.5e-12 PD=1.17e-05 PS=1.17e-05 NRD=0.0425 NRS=0.0425 $X=181825 $Y=230125 $D=42
M47 2 2 2 2 pmos4 L=2e-06 W=1e-05 AD=8.5e-12 AS=8.5e-12 PD=1.17e-05 PS=1.17e-05 NRD=0.0425 NRS=0.0425 $X=181825 $Y=245875 $D=42
M48 12 12 12 12 pmos4 L=3.5e-07 W=1e-05 AD=8.5e-12 AS=8.5e-12 PD=1.17e-05 PS=1.17e-05 NRD=0.0425 NRS=0.0425 $X=192975 $Y=357300 $D=42
M49 12 12 12 12 pmos4 L=3.5e-07 W=1e-05 AD=8.5e-12 AS=8.5e-12 PD=1.17e-05 PS=1.17e-05 NRD=0.0425 NRS=0.0425 $X=192975 $Y=373450 $D=42
M50 VDDA VDDA VDDA VDDA pmos4 L=1e-05 W=5e-06 AD=4.25e-12 AS=4.25e-12 PD=6.7e-06 PS=6.7e-06 NRD=0.085 NRS=0.085 $X=194575 $Y=411350 $D=42
M51 VDDA VDDA VDDA VDDA pmos4 L=1e-05 W=5e-06 AD=4.25e-12 AS=4.25e-12 PD=6.7e-06 PS=6.7e-06 NRD=0.085 NRS=0.085 $X=194575 $Y=421650 $D=42
M52 12 12 12 12 pmos4 L=3.5e-07 W=1e-05 AD=8.5e-12 AS=8.5e-12 PD=1.17e-05 PS=1.17e-05 NRD=0.0425 NRS=0.0425 $X=200925 $Y=357300 $D=42
M53 12 12 12 12 pmos4 L=3.5e-07 W=1e-05 AD=8.5e-12 AS=8.5e-12 PD=1.17e-05 PS=1.17e-05 NRD=0.0425 NRS=0.0425 $X=200925 $Y=373450 $D=42
M54 VDDA VDDA VDDA VDDA pmos4 L=1e-05 W=5e-06 AD=4.25e-12 AS=4.25e-12 PD=6.7e-06 PS=6.7e-06 NRD=0.085 NRS=0.085 $X=256075 $Y=411350 $D=42
M55 VDDA VDDA VDDA VDDA pmos4 L=1e-05 W=5e-06 AD=4.25e-12 AS=4.25e-12 PD=6.7e-06 PS=6.7e-06 NRD=0.085 NRS=0.085 $X=256075 $Y=421650 $D=42
M56 3 1 VDDA VDDA pmos4 L=1e-05 W=5e-06 AD=4.25e-12 AS=4.25e-12 PD=6.7e-06 PS=6.7e-06 NRD=0.085 NRS=0.085 $X=33925 $Y=303950 $D=41
M57 3 1 VDDA VDDA pmos4 L=1e-05 W=5e-06 AD=4.25e-12 AS=4.25e-12 PD=6.7e-06 PS=6.7e-06 NRD=0.085 NRS=0.085 $X=33925 $Y=318050 $D=41
M58 3 1 VDDA VDDA pmos4 L=1e-05 W=5e-06 AD=4.25e-12 AS=4.25e-12 PD=6.7e-06 PS=6.7e-06 NRD=0.085 NRS=0.085 $X=33925 $Y=332150 $D=41
M59 3 1 VDDA VDDA pmos4 L=1e-05 W=5e-06 AD=4.25e-12 AS=4.25e-12 PD=6.7e-06 PS=6.7e-06 NRD=0.085 NRS=0.085 $X=33925 $Y=346250 $D=41
M60 3 1 VDDA VDDA pmos4 L=1e-05 W=5e-06 AD=4.25e-12 AS=4.25e-12 PD=6.7e-06 PS=6.7e-06 NRD=0.085 NRS=0.085 $X=33925 $Y=360350 $D=41
M61 3 1 VDDA VDDA pmos4 L=1e-05 W=5e-06 AD=4.25e-12 AS=4.25e-12 PD=6.7e-06 PS=6.7e-06 NRD=0.085 NRS=0.085 $X=33925 $Y=374450 $D=41
M62 3 1 VDDA VDDA pmos4 L=1e-05 W=5e-06 AD=4.25e-12 AS=4.25e-12 PD=6.7e-06 PS=6.7e-06 NRD=0.085 NRS=0.085 $X=33925 $Y=388550 $D=41
M63 3 1 VDDA VDDA pmos4 L=1e-05 W=5e-06 AD=4.25e-12 AS=4.25e-12 PD=6.7e-06 PS=6.7e-06 NRD=0.085 NRS=0.085 $X=33925 $Y=402650 $D=41
M64 3 1 VDDA VDDA pmos4 L=1e-05 W=5e-06 AD=4.25e-12 AS=4.25e-12 PD=6.7e-06 PS=6.7e-06 NRD=0.085 NRS=0.085 $X=46225 $Y=303950 $D=41
M65 3 1 VDDA VDDA pmos4 L=1e-05 W=5e-06 AD=4.25e-12 AS=4.25e-12 PD=6.7e-06 PS=6.7e-06 NRD=0.085 NRS=0.085 $X=46225 $Y=318050 $D=41
M66 3 1 VDDA VDDA pmos4 L=1e-05 W=5e-06 AD=4.25e-12 AS=4.25e-12 PD=6.7e-06 PS=6.7e-06 NRD=0.085 NRS=0.085 $X=46225 $Y=332150 $D=41
M67 2 1 VDDA VDDA pmos4 L=1e-05 W=5e-06 AD=4.25e-12 AS=4.25e-12 PD=6.7e-06 PS=6.7e-06 NRD=0.085 NRS=0.085 $X=46225 $Y=346250 $D=41
M68 2 1 VDDA VDDA pmos4 L=1e-05 W=5e-06 AD=4.25e-12 AS=4.25e-12 PD=6.7e-06 PS=6.7e-06 NRD=0.085 NRS=0.085 $X=46225 $Y=360350 $D=41
M69 3 1 VDDA VDDA pmos4 L=1e-05 W=5e-06 AD=4.25e-12 AS=4.25e-12 PD=6.7e-06 PS=6.7e-06 NRD=0.085 NRS=0.085 $X=46225 $Y=374450 $D=41
M70 3 1 VDDA VDDA pmos4 L=1e-05 W=5e-06 AD=4.25e-12 AS=4.25e-12 PD=6.7e-06 PS=6.7e-06 NRD=0.085 NRS=0.085 $X=46225 $Y=388550 $D=41
M71 3 1 VDDA VDDA pmos4 L=1e-05 W=5e-06 AD=4.25e-12 AS=4.25e-12 PD=6.7e-06 PS=6.7e-06 NRD=0.085 NRS=0.085 $X=46225 $Y=402650 $D=41
M72 3 1 VDDA VDDA pmos4 L=1e-05 W=5e-06 AD=4.25e-12 AS=4.25e-12 PD=6.7e-06 PS=6.7e-06 NRD=0.085 NRS=0.085 $X=58525 $Y=303950 $D=41
M73 3 1 VDDA VDDA pmos4 L=1e-05 W=5e-06 AD=4.25e-12 AS=4.25e-12 PD=6.7e-06 PS=6.7e-06 NRD=0.085 NRS=0.085 $X=58525 $Y=318050 $D=41
M74 3 1 VDDA VDDA pmos4 L=1e-05 W=5e-06 AD=4.25e-12 AS=4.25e-12 PD=6.7e-06 PS=6.7e-06 NRD=0.085 NRS=0.085 $X=58525 $Y=332150 $D=41
M75 2 1 VDDA VDDA pmos4 L=1e-05 W=5e-06 AD=4.25e-12 AS=4.25e-12 PD=6.7e-06 PS=6.7e-06 NRD=0.085 NRS=0.085 $X=58525 $Y=346250 $D=41
M76 2 1 VDDA VDDA pmos4 L=1e-05 W=5e-06 AD=4.25e-12 AS=4.25e-12 PD=6.7e-06 PS=6.7e-06 NRD=0.085 NRS=0.085 $X=58525 $Y=360350 $D=41
M77 3 1 VDDA VDDA pmos4 L=1e-05 W=5e-06 AD=4.25e-12 AS=4.25e-12 PD=6.7e-06 PS=6.7e-06 NRD=0.085 NRS=0.085 $X=58525 $Y=374450 $D=41
M78 3 1 VDDA VDDA pmos4 L=1e-05 W=5e-06 AD=4.25e-12 AS=4.25e-12 PD=6.7e-06 PS=6.7e-06 NRD=0.085 NRS=0.085 $X=58525 $Y=388550 $D=41
M79 3 1 VDDA VDDA pmos4 L=1e-05 W=5e-06 AD=4.25e-12 AS=4.25e-12 PD=6.7e-06 PS=6.7e-06 NRD=0.085 NRS=0.085 $X=58525 $Y=402650 $D=41
M80 3 1 VDDA VDDA pmos4 L=1e-05 W=5e-06 AD=4.25e-12 AS=4.25e-12 PD=6.7e-06 PS=6.7e-06 NRD=0.085 NRS=0.085 $X=70825 $Y=303950 $D=41
M81 3 1 VDDA VDDA pmos4 L=1e-05 W=5e-06 AD=4.25e-12 AS=4.25e-12 PD=6.7e-06 PS=6.7e-06 NRD=0.085 NRS=0.085 $X=70825 $Y=318050 $D=41
M82 2 1 VDDA VDDA pmos4 L=1e-05 W=5e-06 AD=4.25e-12 AS=4.25e-12 PD=6.7e-06 PS=6.7e-06 NRD=0.085 NRS=0.085 $X=70825 $Y=332150 $D=41
M83 2 1 VDDA VDDA pmos4 L=1e-05 W=5e-06 AD=4.25e-12 AS=4.25e-12 PD=6.7e-06 PS=6.7e-06 NRD=0.085 NRS=0.085 $X=70825 $Y=346250 $D=41
M84 2 1 VDDA VDDA pmos4 L=1e-05 W=5e-06 AD=4.25e-12 AS=4.25e-12 PD=6.7e-06 PS=6.7e-06 NRD=0.085 NRS=0.085 $X=70825 $Y=360350 $D=41
M85 2 1 VDDA VDDA pmos4 L=1e-05 W=5e-06 AD=4.25e-12 AS=4.25e-12 PD=6.7e-06 PS=6.7e-06 NRD=0.085 NRS=0.085 $X=70825 $Y=374450 $D=41
M86 3 1 VDDA VDDA pmos4 L=1e-05 W=5e-06 AD=4.25e-12 AS=4.25e-12 PD=6.7e-06 PS=6.7e-06 NRD=0.085 NRS=0.085 $X=70825 $Y=388550 $D=41
M87 3 1 VDDA VDDA pmos4 L=1e-05 W=5e-06 AD=4.25e-12 AS=4.25e-12 PD=6.7e-06 PS=6.7e-06 NRD=0.085 NRS=0.085 $X=70825 $Y=402650 $D=41
M88 3 1 VDDA VDDA pmos4 L=1e-05 W=5e-06 AD=4.25e-12 AS=4.25e-12 PD=6.7e-06 PS=6.7e-06 NRD=0.085 NRS=0.085 $X=83125 $Y=303950 $D=41
M89 2 1 VDDA VDDA pmos4 L=1e-05 W=5e-06 AD=4.25e-12 AS=4.25e-12 PD=6.7e-06 PS=6.7e-06 NRD=0.085 NRS=0.085 $X=83125 $Y=318050 $D=41
M90 2 1 VDDA VDDA pmos4 L=1e-05 W=5e-06 AD=4.25e-12 AS=4.25e-12 PD=6.7e-06 PS=6.7e-06 NRD=0.085 NRS=0.085 $X=83125 $Y=332150 $D=41
M91 1 1 VDDA VDDA pmos4 L=1e-05 W=5e-06 AD=4.25e-12 AS=4.25e-12 PD=6.7e-06 PS=6.7e-06 NRD=0.085 NRS=0.085 $X=83125 $Y=346250 $D=41
M92 1 1 VDDA VDDA pmos4 L=1e-05 W=5e-06 AD=4.25e-12 AS=4.25e-12 PD=6.7e-06 PS=6.7e-06 NRD=0.085 NRS=0.085 $X=83125 $Y=360350 $D=41
M93 2 1 VDDA VDDA pmos4 L=1e-05 W=5e-06 AD=4.25e-12 AS=4.25e-12 PD=6.7e-06 PS=6.7e-06 NRD=0.085 NRS=0.085 $X=83125 $Y=374450 $D=41
M94 2 1 VDDA VDDA pmos4 L=1e-05 W=5e-06 AD=4.25e-12 AS=4.25e-12 PD=6.7e-06 PS=6.7e-06 NRD=0.085 NRS=0.085 $X=83125 $Y=388550 $D=41
M95 3 1 VDDA VDDA pmos4 L=1e-05 W=5e-06 AD=4.25e-12 AS=4.25e-12 PD=6.7e-06 PS=6.7e-06 NRD=0.085 NRS=0.085 $X=83125 $Y=402650 $D=41
M96 3 1 VDDA VDDA pmos4 L=1e-05 W=5e-06 AD=4.25e-12 AS=4.25e-12 PD=6.7e-06 PS=6.7e-06 NRD=0.085 NRS=0.085 $X=95425 $Y=303950 $D=41
M97 3 1 VDDA VDDA pmos4 L=1e-05 W=5e-06 AD=4.25e-12 AS=4.25e-12 PD=6.7e-06 PS=6.7e-06 NRD=0.085 NRS=0.085 $X=95425 $Y=318050 $D=41
M98 2 1 VDDA VDDA pmos4 L=1e-05 W=5e-06 AD=4.25e-12 AS=4.25e-12 PD=6.7e-06 PS=6.7e-06 NRD=0.085 NRS=0.085 $X=95425 $Y=332150 $D=41
M99 2 1 VDDA VDDA pmos4 L=1e-05 W=5e-06 AD=4.25e-12 AS=4.25e-12 PD=6.7e-06 PS=6.7e-06 NRD=0.085 NRS=0.085 $X=95425 $Y=346250 $D=41
M100 2 1 VDDA VDDA pmos4 L=1e-05 W=5e-06 AD=4.25e-12 AS=4.25e-12 PD=6.7e-06 PS=6.7e-06 NRD=0.085 NRS=0.085 $X=95425 $Y=360350 $D=41
M101 2 1 VDDA VDDA pmos4 L=1e-05 W=5e-06 AD=4.25e-12 AS=4.25e-12 PD=6.7e-06 PS=6.7e-06 NRD=0.085 NRS=0.085 $X=95425 $Y=374450 $D=41
M102 3 1 VDDA VDDA pmos4 L=1e-05 W=5e-06 AD=4.25e-12 AS=4.25e-12 PD=6.7e-06 PS=6.7e-06 NRD=0.085 NRS=0.085 $X=95425 $Y=388550 $D=41
M103 3 1 VDDA VDDA pmos4 L=1e-05 W=5e-06 AD=4.25e-12 AS=4.25e-12 PD=6.7e-06 PS=6.7e-06 NRD=0.085 NRS=0.085 $X=95425 $Y=402650 $D=41
M104 3 1 VDDA VDDA pmos4 L=1e-05 W=5e-06 AD=4.25e-12 AS=4.25e-12 PD=6.7e-06 PS=6.7e-06 NRD=0.085 NRS=0.085 $X=107725 $Y=303950 $D=41
M105 3 1 VDDA VDDA pmos4 L=1e-05 W=5e-06 AD=4.25e-12 AS=4.25e-12 PD=6.7e-06 PS=6.7e-06 NRD=0.085 NRS=0.085 $X=107725 $Y=318050 $D=41
M106 3 1 VDDA VDDA pmos4 L=1e-05 W=5e-06 AD=4.25e-12 AS=4.25e-12 PD=6.7e-06 PS=6.7e-06 NRD=0.085 NRS=0.085 $X=107725 $Y=332150 $D=41
M107 2 1 VDDA VDDA pmos4 L=1e-05 W=5e-06 AD=4.25e-12 AS=4.25e-12 PD=6.7e-06 PS=6.7e-06 NRD=0.085 NRS=0.085 $X=107725 $Y=346250 $D=41
M108 2 1 VDDA VDDA pmos4 L=1e-05 W=5e-06 AD=4.25e-12 AS=4.25e-12 PD=6.7e-06 PS=6.7e-06 NRD=0.085 NRS=0.085 $X=107725 $Y=360350 $D=41
M109 3 1 VDDA VDDA pmos4 L=1e-05 W=5e-06 AD=4.25e-12 AS=4.25e-12 PD=6.7e-06 PS=6.7e-06 NRD=0.085 NRS=0.085 $X=107725 $Y=374450 $D=41
M110 3 1 VDDA VDDA pmos4 L=1e-05 W=5e-06 AD=4.25e-12 AS=4.25e-12 PD=6.7e-06 PS=6.7e-06 NRD=0.085 NRS=0.085 $X=107725 $Y=388550 $D=41
M111 3 1 VDDA VDDA pmos4 L=1e-05 W=5e-06 AD=4.25e-12 AS=4.25e-12 PD=6.7e-06 PS=6.7e-06 NRD=0.085 NRS=0.085 $X=107725 $Y=402650 $D=41
M112 3 1 VDDA VDDA pmos4 L=1e-05 W=5e-06 AD=4.25e-12 AS=4.25e-12 PD=6.7e-06 PS=6.7e-06 NRD=0.085 NRS=0.085 $X=120025 $Y=303950 $D=41
M113 3 1 VDDA VDDA pmos4 L=1e-05 W=5e-06 AD=4.25e-12 AS=4.25e-12 PD=6.7e-06 PS=6.7e-06 NRD=0.085 NRS=0.085 $X=120025 $Y=318050 $D=41
M114 3 1 VDDA VDDA pmos4 L=1e-05 W=5e-06 AD=4.25e-12 AS=4.25e-12 PD=6.7e-06 PS=6.7e-06 NRD=0.085 NRS=0.085 $X=120025 $Y=332150 $D=41
M115 2 1 VDDA VDDA pmos4 L=1e-05 W=5e-06 AD=4.25e-12 AS=4.25e-12 PD=6.7e-06 PS=6.7e-06 NRD=0.085 NRS=0.085 $X=120025 $Y=346250 $D=41
M116 2 1 VDDA VDDA pmos4 L=1e-05 W=5e-06 AD=4.25e-12 AS=4.25e-12 PD=6.7e-06 PS=6.7e-06 NRD=0.085 NRS=0.085 $X=120025 $Y=360350 $D=41
M117 3 1 VDDA VDDA pmos4 L=1e-05 W=5e-06 AD=4.25e-12 AS=4.25e-12 PD=6.7e-06 PS=6.7e-06 NRD=0.085 NRS=0.085 $X=120025 $Y=374450 $D=41
M118 3 1 VDDA VDDA pmos4 L=1e-05 W=5e-06 AD=4.25e-12 AS=4.25e-12 PD=6.7e-06 PS=6.7e-06 NRD=0.085 NRS=0.085 $X=120025 $Y=388550 $D=41
M119 3 1 VDDA VDDA pmos4 L=1e-05 W=5e-06 AD=4.25e-12 AS=4.25e-12 PD=6.7e-06 PS=6.7e-06 NRD=0.085 NRS=0.085 $X=120025 $Y=402650 $D=41
M120 2 13 5 2 pmos4 L=2e-06 W=1e-05 AD=8.5e-12 AS=8.5e-12 PD=1.17e-05 PS=1.17e-05 NRD=0.0425 NRS=0.0425 $X=125925 $Y=230125 $D=41
M121 2 14 6 2 pmos4 L=2e-06 W=1e-05 AD=8.5e-12 AS=8.5e-12 PD=1.17e-05 PS=1.17e-05 NRD=0.0425 NRS=0.0425 $X=125925 $Y=245875 $D=41
M122 3 1 VDDA VDDA pmos4 L=1e-05 W=5e-06 AD=4.25e-12 AS=4.25e-12 PD=6.7e-06 PS=6.7e-06 NRD=0.085 NRS=0.085 $X=132325 $Y=303950 $D=41
M123 3 1 VDDA VDDA pmos4 L=1e-05 W=5e-06 AD=4.25e-12 AS=4.25e-12 PD=6.7e-06 PS=6.7e-06 NRD=0.085 NRS=0.085 $X=132325 $Y=318050 $D=41
M124 3 1 VDDA VDDA pmos4 L=1e-05 W=5e-06 AD=4.25e-12 AS=4.25e-12 PD=6.7e-06 PS=6.7e-06 NRD=0.085 NRS=0.085 $X=132325 $Y=332150 $D=41
M125 3 1 VDDA VDDA pmos4 L=1e-05 W=5e-06 AD=4.25e-12 AS=4.25e-12 PD=6.7e-06 PS=6.7e-06 NRD=0.085 NRS=0.085 $X=132325 $Y=346250 $D=41
M126 3 1 VDDA VDDA pmos4 L=1e-05 W=5e-06 AD=4.25e-12 AS=4.25e-12 PD=6.7e-06 PS=6.7e-06 NRD=0.085 NRS=0.085 $X=132325 $Y=360350 $D=41
M127 3 1 VDDA VDDA pmos4 L=1e-05 W=5e-06 AD=4.25e-12 AS=4.25e-12 PD=6.7e-06 PS=6.7e-06 NRD=0.085 NRS=0.085 $X=132325 $Y=374450 $D=41
M128 3 1 VDDA VDDA pmos4 L=1e-05 W=5e-06 AD=4.25e-12 AS=4.25e-12 PD=6.7e-06 PS=6.7e-06 NRD=0.085 NRS=0.085 $X=132325 $Y=388550 $D=41
M129 3 1 VDDA VDDA pmos4 L=1e-05 W=5e-06 AD=4.25e-12 AS=4.25e-12 PD=6.7e-06 PS=6.7e-06 NRD=0.085 NRS=0.085 $X=132325 $Y=402650 $D=41
M130 2 13 5 2 pmos4 L=2e-06 W=1e-05 AD=8.5e-12 AS=8.5e-12 PD=1.17e-05 PS=1.17e-05 NRD=0.0425 NRS=0.0425 $X=160325 $Y=230125 $D=41
M131 2 14 6 2 pmos4 L=2e-06 W=1e-05 AD=8.5e-12 AS=8.5e-12 PD=1.17e-05 PS=1.17e-05 NRD=0.0425 NRS=0.0425 $X=160325 $Y=245875 $D=41
M132 2 13 5 2 pmos4 L=2e-06 W=1e-05 AD=8.5e-12 AS=8.5e-12 PD=1.17e-05 PS=1.17e-05 NRD=0.0425 NRS=0.0425 $X=177525 $Y=230125 $D=41
M133 2 14 6 2 pmos4 L=2e-06 W=1e-05 AD=8.5e-12 AS=8.5e-12 PD=1.17e-05 PS=1.17e-05 NRD=0.0425 NRS=0.0425 $X=177525 $Y=245875 $D=41
M134 12 9 8 12 pmos4 L=3.5e-07 W=1e-05 AD=8.5e-12 AS=8.5e-12 PD=1.17e-05 PS=1.17e-05 NRD=0.0425 NRS=0.0425 $X=195625 $Y=357300 $D=41
M135 12 3 10 12 pmos4 L=3.5e-07 W=1e-05 AD=8.5e-12 AS=8.5e-12 PD=1.17e-05 PS=1.17e-05 NRD=0.0425 NRS=0.0425 $X=195625 $Y=373450 $D=41
M136 12 3 10 12 pmos4 L=3.5e-07 W=1e-05 AD=8.5e-12 AS=8.5e-12 PD=1.17e-05 PS=1.17e-05 NRD=0.0425 NRS=0.0425 $X=198275 $Y=357300 $D=41
M137 12 9 8 12 pmos4 L=3.5e-07 W=1e-05 AD=8.5e-12 AS=8.5e-12 PD=1.17e-05 PS=1.17e-05 NRD=0.0425 NRS=0.0425 $X=198275 $Y=373450 $D=41
M138 18 18 VDDA VDDA pmos4 L=1e-05 W=5e-06 AD=4.25e-12 AS=4.25e-12 PD=6.7e-06 PS=6.7e-06 NRD=0.085 NRS=0.085 $X=206875 $Y=411350 $D=41
M139 12 18 VDDA VDDA pmos4 L=1e-05 W=5e-06 AD=4.25e-12 AS=4.25e-12 PD=6.7e-06 PS=6.7e-06 NRD=0.085 NRS=0.085 $X=206875 $Y=421650 $D=41
M140 7 18 VDDA VDDA pmos4 L=1e-05 W=5e-06 AD=4.25e-12 AS=4.25e-12 PD=6.7e-06 PS=6.7e-06 NRD=0.085 NRS=0.085 $X=219175 $Y=411350 $D=41
M141 9 18 VDDA VDDA pmos4 L=1e-05 W=5e-06 AD=4.25e-12 AS=4.25e-12 PD=6.7e-06 PS=6.7e-06 NRD=0.085 NRS=0.085 $X=219175 $Y=421650 $D=41
M142 9 18 VDDA VDDA pmos4 L=1e-05 W=5e-06 AD=4.25e-12 AS=4.25e-12 PD=6.7e-06 PS=6.7e-06 NRD=0.085 NRS=0.085 $X=231475 $Y=411350 $D=41
M143 7 18 VDDA VDDA pmos4 L=1e-05 W=5e-06 AD=4.25e-12 AS=4.25e-12 PD=6.7e-06 PS=6.7e-06 NRD=0.085 NRS=0.085 $X=231475 $Y=421650 $D=41
M144 12 18 VDDA VDDA pmos4 L=1e-05 W=5e-06 AD=4.25e-12 AS=4.25e-12 PD=6.7e-06 PS=6.7e-06 NRD=0.085 NRS=0.085 $X=243775 $Y=411350 $D=41
M145 18 18 VDDA VDDA pmos4 L=1e-05 W=5e-06 AD=4.25e-12 AS=4.25e-12 PD=6.7e-06 PS=6.7e-06 NRD=0.085 NRS=0.085 $X=243775 $Y=421650 $D=41
X146 V_ptat_inv 22 cpolyc_CDNS_7804135732819 $T=910250 268750 1 0 $X=908900 $Y=217750
X147 V_ptat_inv 22 cpolyc_CDNS_7804135732819 $T=910250 322100 1 0 $X=908900 $Y=271100
X148 V_ptat_inv 22 cpolyc_CDNS_7804135732819 $T=910250 375450 1 0 $X=908900 $Y=324450
X149 V_ptat_inv 22 cpolyc_CDNS_7804135732819 $T=910250 428800 1 0 $X=908900 $Y=377800
X150 V_ptat_inv 22 ICV_1 $T=690650 268750 1 0 $X=689300 $Y=217750
X151 V_ptat_inv 22 ICV_1 $T=690650 322100 1 0 $X=689300 $Y=271100
X152 V_ptat_inv 22 ICV_1 $T=690650 375450 1 0 $X=689300 $Y=324450
X153 V_ptat_inv 22 ICV_1 $T=690650 428800 1 0 $X=689300 $Y=377800
X154 V_ptat_inv 22 ICV_1 $T=800450 268750 1 0 $X=799100 $Y=217750
X155 V_ptat_inv 22 ICV_1 $T=800450 322100 1 0 $X=799100 $Y=271100
X156 V_ptat_inv 22 ICV_1 $T=800450 375450 1 0 $X=799100 $Y=324450
X157 V_ptat_inv 22 ICV_1 $T=800450 428800 1 0 $X=799100 $Y=377800
X198 3 6 cpolyc_CDNS_780413573287 $T=231950 305750 0 0 $X=230600 $Y=304400
X199 GNDA V_ptat_inv VDDA 7 22 vref 6_CA_Front_Layout $T=494550 210300 0 0 $X=493400 $Y=212098
X200 31 32 rpolyhc_CDNS_780413573280 $T=410925 225325 0 270 $X=406275 $Y=216075
X201 30 31 rpolyhc_CDNS_780413573280 $T=410925 234575 0 270 $X=406275 $Y=225325
X202 22 30 rpolyhc_CDNS_780413573280 $T=427225 240575 0 90 $X=406275 $Y=234575
X203 32 33 rpolyhc_CDNS_780413573280 $T=430525 222075 1 90 $X=425875 $Y=216075
X204 22 3 rpolyhc_CDNS_780413573280 $T=430525 234575 0 270 $X=425875 $Y=225325
X205 34 V_ptat_inv rpolyhc_CDNS_780413573280 $T=446825 240575 0 90 $X=425875 $Y=234575
X206 33 36 rpolyhc_CDNS_780413573280 $T=450125 225325 0 270 $X=445475 $Y=216075
X207 36 35 rpolyhc_CDNS_780413573280 $T=466425 231325 0 90 $X=445475 $Y=225325
X208 35 34 rpolyhc_CDNS_780413573280 $T=466425 240575 0 90 $X=445475 $Y=234575
X209 GNDA GNDA GNDA ICV_11 $T=327250 267200 0 0 $X=327250 $Y=267200
X210 GNDA 21 21 ICV_11 $T=327250 285900 0 0 $X=327250 $Y=285900
X211 GNDA 21 21 ICV_11 $T=327250 304600 0 0 $X=327250 $Y=304600
X212 GNDA 21 21 ICV_11 $T=327250 323300 0 0 $X=327250 $Y=323300
X213 GNDA 21 14 ICV_11 $T=327250 342000 0 0 $X=327250 $Y=342000
X214 GNDA 21 21 ICV_11 $T=327250 360700 0 0 $X=327250 $Y=360700
X215 GNDA 21 21 ICV_11 $T=327250 379400 0 0 $X=327250 $Y=379400
X216 GNDA 21 21 ICV_11 $T=327250 398100 0 0 $X=327250 $Y=398100
X217 GNDA GNDA GNDA ICV_11 $T=327250 416800 0 0 $X=327250 $Y=416800
X218 GNDA VDDA cvar_CDNS_7804135732820 $T=299875 306150 0 0 $X=297600 $Y=304600
X219 GNDA VDDA cvar_CDNS_7804135732822 $T=293275 375450 0 0 $X=291000 $Y=373900
X220 28 23 rpolyhc_CDNS_780413573281 $T=239825 219600 0 90 $X=204575 $Y=211850
X221 23 25 rpolyhc_CDNS_780413573281 $T=210325 240350 1 90 $X=204575 $Y=232600
X222 20 24 rpolyhc_CDNS_780413573281 $T=239825 261100 0 90 $X=204575 $Y=253350
X223 24 3 rpolyhc_CDNS_780413573281 $T=210325 281850 1 90 $X=204575 $Y=274100
X224 13 27 rpolyhc_CDNS_780413573281 $T=245325 219600 1 90 $X=239575 $Y=211850
X225 21 13 rpolyhc_CDNS_780413573281 $T=274825 251600 1 270 $X=239575 $Y=232600
X226 21 13 rpolyhc_CDNS_780413573281 $T=274825 272350 1 270 $X=239575 $Y=253350
X227 25 26 rpolyhc_CDNS_780413573281 $T=245325 281850 1 90 $X=239575 $Y=274100
X228 14 28 rpolyhc_CDNS_780413573281 $T=309825 230850 1 270 $X=274575 $Y=211850
X229 27 29 rpolyhc_CDNS_780413573281 $T=280325 240350 1 90 $X=274575 $Y=232600
X230 29 20 rpolyhc_CDNS_780413573281 $T=309825 272350 1 270 $X=274575 $Y=253350
X231 26 3 rpolyhc_CDNS_780413573281 $T=280325 281850 1 90 $X=274575 $Y=274100
X242 GNDA VDDA cvar_CDNS_7804135732823 $T=279350 376350 0 90 $X=230200 $Y=374075
X243 GNDA 10 10 nmos4_CDNS_7804135732815 $T=202875 314150 0 90 $X=190925 $Y=313750
X244 GNDA 8 10 nmos4_CDNS_7804135732815 $T=202875 326950 0 90 $X=190925 $Y=326550
X245 GNDA 8 10 nmos4_CDNS_7804135732815 $T=215675 314150 0 90 $X=203725 $Y=313750
X246 GNDA 10 10 nmos4_CDNS_7804135732815 $T=215675 326950 0 90 $X=203725 $Y=326550
X260 2 6 5 14 13 ICV_15 $T=163175 230125 0 90 $X=158275 $Y=228925
X261 2 5 6 13 14 ICV_15 $T=163175 245875 0 90 $X=158275 $Y=244675
X334 2 6 5 14 13 ICV_16 $T=94375 230125 0 90 $X=89475 $Y=228925
X335 2 5 6 13 14 ICV_16 $T=94375 245875 0 90 $X=89475 $Y=244675
X336 2 6 5 14 13 ICV_16 $T=128775 230125 0 90 $X=123875 $Y=228925
X337 2 5 6 13 14 ICV_16 $T=128775 245875 0 90 $X=123875 $Y=244675
X353 VDDA ICV_18 $T=20775 294850 0 270 $X=19575 $Y=288650
X354 VDDA ICV_18 $T=20775 308950 0 270 $X=19575 $Y=302750
X355 VDDA ICV_18 $T=20775 323050 0 270 $X=19575 $Y=316850
X356 VDDA ICV_18 $T=20775 337150 0 270 $X=19575 $Y=330950
X357 VDDA ICV_18 $T=20775 351250 0 270 $X=19575 $Y=345050
X358 VDDA ICV_18 $T=20775 365350 0 270 $X=19575 $Y=359150
X359 VDDA ICV_18 $T=20775 379450 0 270 $X=19575 $Y=373250
X360 VDDA ICV_18 $T=20775 393550 0 270 $X=19575 $Y=387350
X361 VDDA ICV_18 $T=20775 407650 0 270 $X=19575 $Y=401450
X362 VDDA ICV_18 $T=20775 421750 0 270 $X=19575 $Y=415550
X363 GNDA Ibias cvar_CDNS_7804135732821 $T=23900 210975 1 180 $X=-875 $Y=209425
.ENDS
***************************************
