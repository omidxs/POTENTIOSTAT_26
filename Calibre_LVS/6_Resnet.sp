* SPICE NETLIST
***************************************

.SUBCKT tsv80 TOP BOTTOM SUB
.ENDS
***************************************
.SUBCKT rx POS NEG
.ENDS
***************************************
.SUBCKT Q C B E S G
.ENDS
***************************************
.SUBCKT lddn D G S B
.ENDS
***************************************
.SUBCKT phd POS NEG P
.ENDS
***************************************
.SUBCKT sbd A C SUB
.ENDS
***************************************
.SUBCKT esddlv2 A C
.ENDS
***************************************
.SUBCKT esddlv A C SUB
.ENDS
***************************************
.SUBCKT lddp D G S B
.ENDS
***************************************
.SUBCKT probepad pad
.ENDS
***************************************
.SUBCKT L POS NEG SUB
.ENDS
***************************************
.SUBCKT L POS NEG MID SUB
.ENDS
***************************************
.SUBCKT hall A B C D S P1 P2
.ENDS
***************************************
.SUBCKT rpolyhc_CDNS_779830863830 1 2
** N=3 EP=2 IP=0 FDC=1
R0 1 2 L=0.00049995 W=8e-07 $[rpolyh] $X=-800 $Y=1550 $D=18
.ENDS
***************************************
.SUBCKT ICV_1 1 2 3 4
** N=5 EP=4 IP=6 FDC=2
X0 1 2 rpolyhc_CDNS_779830863830 $T=0 0 0 0 $X=-5350 $Y=-4650
X1 3 4 rpolyhc_CDNS_779830863830 $T=44150 19600 1 180 $X=-5350 $Y=14950
.ENDS
***************************************
.SUBCKT nmos4_CDNS_779830863832 1 2 3 4
** N=4 EP=4 IP=0 FDC=1
M0 2 3 1 4 nmos4 L=1e-06 W=5e-06 AD=4.25e-12 AS=4.25e-12 PD=6.7e-06 PS=6.7e-06 NRD=0.085 NRS=0.085 $X=0 $Y=850 $D=37
.ENDS
***************************************
.SUBCKT pmos4_CDNS_779830863831
** N=5 EP=0 IP=0 FDC=0
*.SEEDPROM
.ENDS
***************************************
.SUBCKT Inverter VDDA A Q GNDA
** N=4 EP=4 IP=0 FDC=3
D0 GNDA VDDA p_nwd AREA=17.2825 PJ=17.35 $X=550 $Y=3700 $D=87
M1 Q A GNDA GNDA nmos4 L=3.5e-07 W=4e-07 AD=5.7e-13 AS=5.7e-13 PD=2.8e-06 PS=2.8e-06 NRD=1.0625 NRS=1.0625 $X=3725 $Y=1550 $D=37
M2 Q A VDDA VDDA pmos4 L=3.5e-07 W=7e-07 AD=5.95e-13 AS=5.95e-13 PD=2.4e-06 PS=2.4e-06 NRD=0.607143 NRS=0.607143 $X=3725 $Y=4900 $D=41
.ENDS
***************************************
.SUBCKT 6_Resnet S<2> S<3> S<0> S<1> VDDA In Out GNDA
** N=27 EP=8 IP=93 FDC=41
R0 10 Out L=0.00015015 W=8e-07 $[rpolyh] $X=105550 $Y=104225 $D=18
D1 GNDA VDDA p_nwd AREA=31.24 PJ=23 $X=63725 $Y=98775 $D=87
D2 GNDA VDDA p_nwd AREA=30.14 PJ=22.5 $X=63725 $Y=111875 $D=87
D3 GNDA VDDA p_nwd AREA=30.14 PJ=22.5 $X=63725 $Y=126325 $D=87
D4 GNDA VDDA p_nwd AREA=29.15 PJ=22.05 $X=63725 $Y=139275 $D=87
D5 GNDA GNDA p_nwd AREA=17889.4 PJ=583.9 $X=87300 $Y=87750 $D=87
M6 In S<0> 10 GNDA nmos4 L=1e-06 W=5e-06 AD=2.5e-12 AS=4.25e-12 PD=1e-06 PS=6.7e-06 NRD=0.085 NRS=0.085 $X=69350 $Y=101850 $D=37
M7 10 S<0> In GNDA nmos4 L=1e-06 W=5e-06 AD=4.25e-12 AS=2.5e-12 PD=6.7e-06 PS=1e-06 NRD=0.085 NRS=0.085 $X=69350 $Y=103850 $D=37
M8 In 7 10 VDDA pmos4 L=1e-06 W=2e-06 AD=1.7e-12 AS=1.7e-12 PD=3.7e-06 PS=3.7e-06 NRD=0.2125 NRS=0.2125 $X=64925 $Y=102825 $D=41
M9 In 8 12 VDDA pmos4 L=1e-06 W=2e-06 AD=1.7e-12 AS=1.7e-12 PD=3.7e-06 PS=3.7e-06 NRD=0.2125 NRS=0.2125 $X=64925 $Y=115675 $D=41
M10 In 9 14 VDDA pmos4 L=1e-06 W=2e-06 AD=1.7e-12 AS=1.7e-12 PD=3.7e-06 PS=3.7e-06 NRD=0.2125 NRS=0.2125 $X=64925 $Y=130100 $D=41
M11 In 6 13 VDDA pmos4 L=1e-06 W=2e-06 AD=1.7e-12 AS=1.7e-12 PD=3.7e-06 PS=3.7e-06 NRD=0.2125 NRS=0.2125 $X=64925 $Y=142850 $D=41
X12 16 14 rpolyhc_CDNS_779830863830 $T=94175 149450 1 0 $X=88825 $Y=128500
X13 17 16 rpolyhc_CDNS_779830863830 $T=138325 169050 0 180 $X=88825 $Y=148100
X14 Out 17 rpolyhc_CDNS_779830863830 $T=187175 133150 1 180 $X=137675 $Y=128500
X15 18 13 rpolyhc_CDNS_779830863830 $T=187175 169050 0 180 $X=137675 $Y=148100
X16 19 22 rpolyhc_CDNS_779830863830 $T=191875 110250 1 0 $X=186525 $Y=89300
X17 21 19 rpolyhc_CDNS_779830863830 $T=236025 129850 0 180 $X=186525 $Y=108900
X18 20 21 rpolyhc_CDNS_779830863830 $T=191875 149450 1 0 $X=186525 $Y=128500
X19 23 18 rpolyhc_CDNS_779830863830 $T=236025 152750 1 180 $X=186525 $Y=148100
X20 24 26 rpolyhc_CDNS_779830863830 $T=240725 133150 0 0 $X=235375 $Y=128500
X21 26 23 rpolyhc_CDNS_779830863830 $T=284875 169050 0 180 $X=235375 $Y=148100
X22 Out 12 Out 20 ICV_1 $T=187175 93950 1 180 $X=137675 $Y=89300
X23 22 25 25 24 ICV_1 $T=240725 93950 0 0 $X=235375 $Y=89300
X24 12 In S<1> GNDA nmos4_CDNS_779830863832 $T=74350 114825 1 180 $X=68950 $Y=114575
X25 In 14 S<2> GNDA nmos4_CDNS_779830863832 $T=74425 131950 0 180 $X=69025 $Y=129000
X26 13 In S<3> GNDA nmos4_CDNS_779830863832 $T=69425 142025 0 0 $X=69025 $Y=141775
X32 VDDA S<0> 7 GNDA Inverter $T=60625 107275 1 270 $X=52725 $Y=100325
X33 VDDA S<1> 8 GNDA Inverter $T=60625 120425 1 270 $X=52725 $Y=113475
X34 VDDA S<2> 9 GNDA Inverter $T=60625 134450 1 270 $X=52725 $Y=127500
X35 VDDA S<3> 6 GNDA Inverter $T=60625 147200 1 270 $X=52725 $Y=140250
.ENDS
***************************************
