* SPICE NETLIST
***************************************

.SUBCKT tsv80 TOP BOTTOM SUB
.ENDS
***************************************
.SUBCKT rx POS NEG
.ENDS
***************************************
.SUBCKT Q C B E S G
.ENDS
***************************************
.SUBCKT lddn D G S B
.ENDS
***************************************
.SUBCKT phd POS NEG P
.ENDS
***************************************
.SUBCKT sbd A C SUB
.ENDS
***************************************
.SUBCKT esddlv2 A C
.ENDS
***************************************
.SUBCKT esddlv A C SUB
.ENDS
***************************************
.SUBCKT lddp D G S B
.ENDS
***************************************
.SUBCKT probepad pad
.ENDS
***************************************
.SUBCKT L POS NEG SUB
.ENDS
***************************************
.SUBCKT L POS NEG MID SUB
.ENDS
***************************************
.SUBCKT hall A B C D S P1 P2
.ENDS
***************************************
.SUBCKT cpolyc_CDNS_7804141697241 2 3
** N=3 EP=2 IP=0 FDC=1
C0 2 3 $[cpolya] $A=1728.34 $P=166.3 $X=1800 $Y=1000 $D=58
.ENDS
***************************************
.SUBCKT ICV_1 2 3
** N=3 EP=2 IP=6 FDC=2
X0 2 3 cpolyc_CDNS_7804141697241 $T=0 0 0 0 $X=-1350 $Y=-1350
X1 2 3 cpolyc_CDNS_7804141697241 $T=48050 0 0 0 $X=46700 $Y=-1350
.ENDS
***************************************
.SUBCKT rpolyhc_CDNS_7804141697238 1 2
** N=3 EP=2 IP=0 FDC=1
R0 1 2 L=0.00049995 W=8e-07 $[rpolyh] $X=-800 $Y=1550 $D=18
.ENDS
***************************************
.SUBCKT ICV_2 1 2 3 4
** N=5 EP=4 IP=6 FDC=2
X0 1 2 rpolyhc_CDNS_7804141697238 $T=0 0 0 0 $X=-6000 $Y=-4650
X1 3 4 rpolyhc_CDNS_7804141697238 $T=44150 19600 1 180 $X=-6000 $Y=14950
.ENDS
***************************************
.SUBCKT nmos4_CDNS_7804141697228 1 2 3 4
** N=4 EP=4 IP=0 FDC=1
M0 2 3 1 4 nmos4 L=1e-06 W=5e-06 AD=4.25e-12 AS=4.25e-12 PD=6.7e-06 PS=6.7e-06 NRD=0.085 NRS=0.085 $X=0 $Y=850 $D=37
.ENDS
***************************************
.SUBCKT pmos4_CDNS_7804141697230
** N=5 EP=0 IP=0 FDC=0
*.SEEDPROM
.ENDS
***************************************
.SUBCKT Inverter VDDA A Q GNDA
** N=4 EP=4 IP=0 FDC=3
D0 GNDA VDDA p_nwd AREA=17.2825 PJ=17.35 $X=550 $Y=3700 $D=87
M1 Q A GNDA GNDA nmos4 L=3.5e-07 W=4e-07 AD=5.7e-13 AS=5.7e-13 PD=2.8e-06 PS=2.8e-06 NRD=1.0625 NRS=1.0625 $X=3725 $Y=1550 $D=37
M2 Q A VDDA VDDA pmos4 L=3.5e-07 W=7e-07 AD=5.95e-13 AS=5.95e-13 PD=2.4e-06 PS=2.4e-06 NRD=0.607143 NRS=0.607143 $X=3725 $Y=4900 $D=41
.ENDS
***************************************
.SUBCKT 6_Resnet S<2> S<3> S<0> S<1> VDDA In Out GNDA
** N=27 EP=8 IP=93 FDC=41
R0 13 Out L=0.00015015 W=8e-07 $[rpolyh] $X=105925 $Y=104525 $D=18
D1 GNDA VDDA p_nwd AREA=31.24 PJ=23 $X=63725 $Y=98775 $D=87
D2 GNDA VDDA p_nwd AREA=30.14 PJ=22.5 $X=63725 $Y=111875 $D=87
D3 GNDA VDDA p_nwd AREA=30.14 PJ=22.5 $X=63725 $Y=126325 $D=87
D4 GNDA VDDA p_nwd AREA=29.15 PJ=22.05 $X=63725 $Y=139275 $D=87
D5 GNDA GNDA p_nwd AREA=18348.7 PJ=594.4 $X=84650 $Y=87750 $D=87
M6 In S<0> 13 GNDA nmos4 L=1e-06 W=5e-06 AD=2.5e-12 AS=4.25e-12 PD=1e-06 PS=6.7e-06 NRD=0.085 NRS=0.085 $X=69350 $Y=101850 $D=37
M7 13 S<0> In GNDA nmos4 L=1e-06 W=5e-06 AD=4.25e-12 AS=2.5e-12 PD=6.7e-06 PS=1e-06 NRD=0.085 NRS=0.085 $X=69350 $Y=103850 $D=37
M8 In 10 13 VDDA pmos4 L=1e-06 W=2e-06 AD=1.7e-12 AS=1.7e-12 PD=3.7e-06 PS=3.7e-06 NRD=0.2125 NRS=0.2125 $X=64925 $Y=102825 $D=41
M9 In 11 14 VDDA pmos4 L=1e-06 W=2e-06 AD=1.7e-12 AS=1.7e-12 PD=3.7e-06 PS=3.7e-06 NRD=0.2125 NRS=0.2125 $X=64925 $Y=115675 $D=41
M10 In 12 16 VDDA pmos4 L=1e-06 W=2e-06 AD=1.7e-12 AS=1.7e-12 PD=3.7e-06 PS=3.7e-06 NRD=0.2125 NRS=0.2125 $X=64925 $Y=130100 $D=41
M11 In 9 15 VDDA pmos4 L=1e-06 W=2e-06 AD=1.7e-12 AS=1.7e-12 PD=3.7e-06 PS=3.7e-06 NRD=0.2125 NRS=0.2125 $X=64925 $Y=142850 $D=41
X12 17 16 rpolyhc_CDNS_7804141697238 $T=92200 149450 1 0 $X=86200 $Y=128500
X13 18 17 rpolyhc_CDNS_7804141697238 $T=136350 169050 0 180 $X=86200 $Y=148100
X14 Out 18 rpolyhc_CDNS_7804141697238 $T=186500 133150 1 180 $X=136350 $Y=128500
X15 19 15 rpolyhc_CDNS_7804141697238 $T=186500 169050 0 180 $X=136350 $Y=148100
X16 20 23 rpolyhc_CDNS_7804141697238 $T=192500 110250 1 0 $X=186500 $Y=89300
X17 22 20 rpolyhc_CDNS_7804141697238 $T=236650 129850 0 180 $X=186500 $Y=108900
X18 21 22 rpolyhc_CDNS_7804141697238 $T=192500 149450 1 0 $X=186500 $Y=128500
X19 24 19 rpolyhc_CDNS_7804141697238 $T=236650 152750 1 180 $X=186500 $Y=148100
X20 25 27 rpolyhc_CDNS_7804141697238 $T=242650 133150 0 0 $X=236650 $Y=128500
X21 27 24 rpolyhc_CDNS_7804141697238 $T=286800 169050 0 180 $X=236650 $Y=148100
X22 Out 14 Out 21 ICV_2 $T=186500 93950 1 180 $X=136350 $Y=89300
X23 23 26 26 25 ICV_2 $T=242650 93950 0 0 $X=236650 $Y=89300
X24 14 In S<1> GNDA nmos4_CDNS_7804141697228 $T=74350 114825 1 180 $X=68950 $Y=114575
X25 In 16 S<2> GNDA nmos4_CDNS_7804141697228 $T=74425 131950 0 180 $X=69025 $Y=129000
X26 15 In S<3> GNDA nmos4_CDNS_7804141697228 $T=69425 142025 0 0 $X=69025 $Y=141775
X32 VDDA S<0> 10 GNDA Inverter $T=60625 107275 1 270 $X=52725 $Y=100325
X33 VDDA S<1> 11 GNDA Inverter $T=60625 120425 1 270 $X=52725 $Y=113475
X34 VDDA S<2> 12 GNDA Inverter $T=60625 134450 1 270 $X=52725 $Y=127500
X35 VDDA S<3> 9 GNDA Inverter $T=60625 147200 1 270 $X=52725 $Y=140250
.ENDS
***************************************
.SUBCKT cpolyc_CDNS_7804141697234 2 3
** N=3 EP=2 IP=0 FDC=1
C0 2 3 $[cpolya] $A=2886.23 $P=214.9 $X=1800 $Y=1000 $D=58
.ENDS
***************************************
.SUBCKT P1_C_CDNS_78041416972178
** N=1 EP=0 IP=0 FDC=0
.ENDS
***************************************
.SUBCKT nmos4_CDNS_780414169729
** N=3 EP=0 IP=0 FDC=0
.ENDS
***************************************
.SUBCKT PD_C_CDNS_78041416972175
** N=1 EP=0 IP=0 FDC=0
.ENDS
***************************************
.SUBCKT P1_C_CDNS_78041416972167
** N=3 EP=0 IP=0 FDC=0
.ENDS
***************************************
.SUBCKT ND_C_CDNS_78041416972168
** N=2 EP=0 IP=0 FDC=0
.ENDS
***************************************
.SUBCKT P1_C_CDNS_7804141697221
** N=2 EP=0 IP=0 FDC=0
.ENDS
***************************************
.SUBCKT ICV_3
** N=2 EP=0 IP=4 FDC=0
.ENDS
***************************************
.SUBCKT ICV_4
** N=2 EP=0 IP=4 FDC=0
.ENDS
***************************************
.SUBCKT pmos4_CDNS_7804141697212
** N=5 EP=0 IP=0 FDC=0
.ENDS
***************************************
.SUBCKT ICV_5
** N=8 EP=0 IP=10 FDC=0
.ENDS
***************************************
.SUBCKT ICV_6 3 4 5 9 10 13
** N=13 EP=6 IP=16 FDC=2
M0 4 9 3 13 pmos4 L=4e-06 W=1e-05 AD=8.5e-12 AS=8.5e-12 PD=1.17e-05 PS=1.17e-05 NRD=0.0425 NRS=0.0425 $X=0 $Y=7150 $D=41
M1 5 10 3 13 pmos4 L=4e-06 W=1e-05 AD=8.5e-12 AS=8.5e-12 PD=1.17e-05 PS=1.17e-05 NRD=0.0425 NRS=0.0425 $X=0 $Y=13450 $D=41
.ENDS
***************************************
.SUBCKT pmos4_CDNS_7804141697236
** N=4 EP=0 IP=0 FDC=0
.ENDS
***************************************
.SUBCKT ICV_7
** N=6 EP=0 IP=8 FDC=0
.ENDS
***************************************
.SUBCKT ICV_8
** N=8 EP=0 IP=12 FDC=0
.ENDS
***************************************
.SUBCKT nmos4_CDNS_7804141697211
** N=4 EP=0 IP=0 FDC=0
.ENDS
***************************************
.SUBCKT ICV_9
** N=6 EP=0 IP=8 FDC=0
.ENDS
***************************************
.SUBCKT cvar_CDNS_7804141697221 1 2
** N=2 EP=2 IP=0 FDC=2
M0 2 1 2 1 cvar w=0.0003432 l=6.5e-07 cols=13 rows=4 $X=0 $Y=0 $D=62
D1 1 2 p_nwd AREA=723.45 PJ=109.1 $X=-300 $Y=-300 $D=87
.ENDS
***************************************
.SUBCKT ICV_10 1
** N=6 EP=1 IP=16 FDC=1
M0 1 1 1 1 pmos4 L=1e-05 W=1e-06 AD=8.5e-13 AS=8.5e-13 PD=2.7e-06 PS=2.7e-06 NRD=0.425 NRS=0.425 $X=0 $Y=850 $D=42
.ENDS
***************************************
.SUBCKT P1_C_CDNS_78041416972154
** N=2 EP=0 IP=0 FDC=0
.ENDS
***************************************
.SUBCKT nmos4_CDNS_780414169728 1 2 3 4
** N=4 EP=4 IP=0 FDC=4
M0 2 3 1 4 nmos4 L=4e-06 W=1e-06 AD=5e-13 AS=8.5e-13 PD=1e-06 PS=2.7e-06 NRD=0.425 NRS=0.425 $X=0 $Y=850 $D=37
M1 1 3 2 4 nmos4 L=4e-06 W=1e-06 AD=5e-13 AS=5e-13 PD=1e-06 PS=1e-06 NRD=0.425 NRS=0.425 $X=0 $Y=5850 $D=37
M2 2 3 1 4 nmos4 L=4e-06 W=1e-06 AD=5e-13 AS=5e-13 PD=1e-06 PS=1e-06 NRD=0.425 NRS=0.425 $X=0 $Y=10850 $D=37
M3 1 3 2 4 nmos4 L=4e-06 W=1e-06 AD=8.5e-13 AS=5e-13 PD=2.7e-06 PS=1e-06 NRD=0.425 NRS=0.425 $X=0 $Y=15850 $D=37
.ENDS
***************************************
.SUBCKT 6_TIA_Front_Layout Vout VDDA Ibias GNDA Vin- Vin+
** N=13 EP=6 IP=646 FDC=160
R0 11 13 L=3.00901e-05 W=2e-06 $[rpolyh] $X=231300 $Y=43950 $D=17
D1 GNDA VDDA p_nwd AREA=5780.76 PJ=322.9 $X=76650 $Y=12700 $D=87
D2 GNDA VDDA p_nwd AREA=20225.4 PJ=587.6 $X=700 $Y=68200 $D=87
D3 GNDA GNDA p_nwd AREA=14562.5 PJ=527 $X=188050 $Y=61950 $D=87
M4 12 12 12 GNDA nmos4 L=4e-06 W=1e-06 AD=8.5e-13 AS=8.5e-13 PD=2.7e-06 PS=2.7e-06 NRD=0.425 NRS=0.425 $X=43525 $Y=52250 $D=38
M5 12 12 12 GNDA nmos4 L=4e-06 W=1e-06 AD=8.5e-13 AS=8.5e-13 PD=2.7e-06 PS=2.7e-06 NRD=0.425 NRS=0.425 $X=72775 $Y=52250 $D=38
M6 GNDA GNDA GNDA GNDA nmos4 L=2e-05 W=5e-06 AD=4.25e-12 AS=4.25e-12 PD=6.7e-06 PS=6.7e-06 NRD=0.085 NRS=0.085 $X=191650 $Y=11725 $D=38
M7 GNDA GNDA GNDA GNDA nmos4 L=2e-05 W=5e-06 AD=4.25e-12 AS=4.25e-12 PD=6.7e-06 PS=6.7e-06 NRD=0.085 NRS=0.085 $X=191650 $Y=30475 $D=38
M8 9 12 GNDA GNDA nmos4 L=4e-06 W=1e-06 AD=8.5e-13 AS=8.5e-13 PD=2.7e-06 PS=2.7e-06 NRD=0.425 NRS=0.425 $X=45775 $Y=52250 $D=37
M9 12 12 GNDA GNDA nmos4 L=4e-06 W=1e-06 AD=8.5e-13 AS=8.5e-13 PD=2.7e-06 PS=2.7e-06 NRD=0.425 NRS=0.425 $X=48025 $Y=52250 $D=37
M10 9 12 GNDA GNDA nmos4 L=4e-06 W=1e-06 AD=8.5e-13 AS=8.5e-13 PD=2.7e-06 PS=2.7e-06 NRD=0.425 NRS=0.425 $X=50275 $Y=52250 $D=37
M11 9 12 GNDA GNDA nmos4 L=4e-06 W=1e-06 AD=8.5e-13 AS=8.5e-13 PD=2.7e-06 PS=2.7e-06 NRD=0.425 NRS=0.425 $X=52525 $Y=52250 $D=37
M12 12 12 GNDA GNDA nmos4 L=4e-06 W=1e-06 AD=8.5e-13 AS=8.5e-13 PD=2.7e-06 PS=2.7e-06 NRD=0.425 NRS=0.425 $X=54775 $Y=52250 $D=37
M13 9 12 GNDA GNDA nmos4 L=4e-06 W=1e-06 AD=8.5e-13 AS=8.5e-13 PD=2.7e-06 PS=2.7e-06 NRD=0.425 NRS=0.425 $X=57025 $Y=52250 $D=37
M14 9 12 GNDA GNDA nmos4 L=4e-06 W=1e-06 AD=8.5e-13 AS=8.5e-13 PD=2.7e-06 PS=2.7e-06 NRD=0.425 NRS=0.425 $X=59275 $Y=52250 $D=37
M15 12 12 GNDA GNDA nmos4 L=4e-06 W=1e-06 AD=8.5e-13 AS=8.5e-13 PD=2.7e-06 PS=2.7e-06 NRD=0.425 NRS=0.425 $X=61525 $Y=52250 $D=37
M16 9 12 GNDA GNDA nmos4 L=4e-06 W=1e-06 AD=8.5e-13 AS=8.5e-13 PD=2.7e-06 PS=2.7e-06 NRD=0.425 NRS=0.425 $X=63775 $Y=52250 $D=37
M17 9 12 GNDA GNDA nmos4 L=4e-06 W=1e-06 AD=8.5e-13 AS=8.5e-13 PD=2.7e-06 PS=2.7e-06 NRD=0.425 NRS=0.425 $X=66025 $Y=52250 $D=37
M18 12 12 GNDA GNDA nmos4 L=4e-06 W=1e-06 AD=8.5e-13 AS=8.5e-13 PD=2.7e-06 PS=2.7e-06 NRD=0.425 NRS=0.425 $X=68275 $Y=52250 $D=37
M19 9 12 GNDA GNDA nmos4 L=4e-06 W=1e-06 AD=8.5e-13 AS=8.5e-13 PD=2.7e-06 PS=2.7e-06 NRD=0.425 NRS=0.425 $X=70525 $Y=52250 $D=37
M20 Vout 11 GNDA GNDA nmos4 L=2e-06 W=1e-05 AD=5e-12 AS=8.5e-12 PD=1e-06 PS=1.17e-05 NRD=0.0425 NRS=0.0425 $X=191050 $Y=41500 $D=37
M21 GNDA 10 10 GNDA nmos4 L=2e-05 W=5e-06 AD=4.25e-12 AS=4.25e-12 PD=6.7e-06 PS=6.7e-06 NRD=0.085 NRS=0.085 $X=191650 $Y=17975 $D=37
M22 GNDA 10 11 GNDA nmos4 L=2e-05 W=5e-06 AD=4.25e-12 AS=4.25e-12 PD=6.7e-06 PS=6.7e-06 NRD=0.085 NRS=0.085 $X=191650 $Y=24225 $D=37
M23 GNDA 11 Vout GNDA nmos4 L=2e-06 W=1e-05 AD=5e-12 AS=5e-12 PD=1e-06 PS=1e-06 NRD=0.0425 NRS=0.0425 $X=194050 $Y=41500 $D=37
M24 Vout 11 GNDA GNDA nmos4 L=2e-06 W=1e-05 AD=5e-12 AS=5e-12 PD=1e-06 PS=1e-06 NRD=0.0425 NRS=0.0425 $X=197050 $Y=41500 $D=37
M25 GNDA 11 Vout GNDA nmos4 L=2e-06 W=1e-05 AD=5e-12 AS=5e-12 PD=1e-06 PS=1e-06 NRD=0.0425 NRS=0.0425 $X=200050 $Y=41500 $D=37
M26 Vout 11 GNDA GNDA nmos4 L=2e-06 W=1e-05 AD=5e-12 AS=5e-12 PD=1e-06 PS=1e-06 NRD=0.0425 NRS=0.0425 $X=203050 $Y=41500 $D=37
M27 GNDA 11 Vout GNDA nmos4 L=2e-06 W=1e-05 AD=5e-12 AS=5e-12 PD=1e-06 PS=1e-06 NRD=0.0425 NRS=0.0425 $X=206050 $Y=41500 $D=37
M28 Vout 11 GNDA GNDA nmos4 L=2e-06 W=1e-05 AD=5e-12 AS=5e-12 PD=1e-06 PS=1e-06 NRD=0.0425 NRS=0.0425 $X=209050 $Y=41500 $D=37
M29 GNDA 11 Vout GNDA nmos4 L=2e-06 W=1e-05 AD=5e-12 AS=5e-12 PD=1e-06 PS=1e-06 NRD=0.0425 NRS=0.0425 $X=212050 $Y=41500 $D=37
M30 Vout 11 GNDA GNDA nmos4 L=2e-06 W=1e-05 AD=5e-12 AS=5e-12 PD=1e-06 PS=1e-06 NRD=0.0425 NRS=0.0425 $X=215050 $Y=41500 $D=37
M31 GNDA 11 Vout GNDA nmos4 L=2e-06 W=1e-05 AD=8.5e-12 AS=5e-12 PD=1.17e-05 PS=1e-06 NRD=0.0425 NRS=0.0425 $X=218050 $Y=41500 $D=37
M32 VDDA VDDA VDDA VDDA pmos4 L=1e-05 W=1e-06 AD=8.5e-13 AS=8.5e-13 PD=2.7e-06 PS=2.7e-06 NRD=0.425 NRS=0.425 $X=32200 $Y=88550 $D=42
M33 VDDA VDDA VDDA VDDA pmos4 L=1e-05 W=1e-06 AD=8.5e-13 AS=8.5e-13 PD=2.7e-06 PS=2.7e-06 NRD=0.425 NRS=0.425 $X=32200 $Y=156950 $D=42
M34 VDDA VDDA VDDA VDDA pmos4 L=1e-05 W=1e-06 AD=8.5e-13 AS=8.5e-13 PD=2.7e-06 PS=2.7e-06 NRD=0.425 NRS=0.425 $X=44500 $Y=88550 $D=42
M35 VDDA VDDA VDDA VDDA pmos4 L=1e-05 W=1e-06 AD=8.5e-13 AS=8.5e-13 PD=2.7e-06 PS=2.7e-06 NRD=0.425 NRS=0.425 $X=44500 $Y=156950 $D=42
M36 VDDA VDDA VDDA VDDA pmos4 L=1e-05 W=1e-06 AD=8.5e-13 AS=8.5e-13 PD=2.7e-06 PS=2.7e-06 NRD=0.425 NRS=0.425 $X=56800 $Y=88550 $D=42
M37 VDDA VDDA VDDA VDDA pmos4 L=1e-05 W=1e-06 AD=8.5e-13 AS=8.5e-13 PD=2.7e-06 PS=2.7e-06 NRD=0.425 NRS=0.425 $X=56800 $Y=156950 $D=42
M38 VDDA VDDA VDDA VDDA pmos4 L=1e-05 W=1e-06 AD=8.5e-13 AS=8.5e-13 PD=2.7e-06 PS=2.7e-06 NRD=0.425 NRS=0.425 $X=69100 $Y=88550 $D=42
M39 VDDA VDDA VDDA VDDA pmos4 L=1e-05 W=1e-06 AD=8.5e-13 AS=8.5e-13 PD=2.7e-06 PS=2.7e-06 NRD=0.425 NRS=0.425 $X=69100 $Y=156950 $D=42
M40 VDDA VDDA VDDA VDDA pmos4 L=1e-05 W=1e-06 AD=8.5e-13 AS=8.5e-13 PD=2.7e-06 PS=2.7e-06 NRD=0.425 NRS=0.425 $X=81400 $Y=88550 $D=42
M41 VDDA VDDA VDDA VDDA pmos4 L=1e-05 W=1e-06 AD=8.5e-13 AS=8.5e-13 PD=2.7e-06 PS=2.7e-06 NRD=0.425 NRS=0.425 $X=81400 $Y=156950 $D=42
M42 VDDA VDDA VDDA VDDA pmos4 L=1e-05 W=1e-06 AD=8.5e-13 AS=8.5e-13 PD=2.7e-06 PS=2.7e-06 NRD=0.425 NRS=0.425 $X=93700 $Y=88550 $D=42
M43 VDDA VDDA VDDA VDDA pmos4 L=1e-05 W=1e-06 AD=8.5e-13 AS=8.5e-13 PD=2.7e-06 PS=2.7e-06 NRD=0.425 NRS=0.425 $X=93700 $Y=156950 $D=42
M44 VDDA VDDA VDDA VDDA pmos4 L=4e-06 W=1e-05 AD=8.5e-12 AS=8.5e-12 PD=1.17e-05 PS=1.17e-05 NRD=0.0425 NRS=0.0425 $X=93925 $Y=25100 $D=42
M45 VDDA VDDA VDDA VDDA pmos4 L=4e-06 W=1e-05 AD=8.5e-12 AS=8.5e-12 PD=1.17e-05 PS=1.17e-05 NRD=0.0425 NRS=0.0425 $X=93925 $Y=43900 $D=42
M46 VDDA VDDA VDDA VDDA pmos4 L=1e-05 W=1e-06 AD=8.5e-13 AS=8.5e-13 PD=2.7e-06 PS=2.7e-06 NRD=0.425 NRS=0.425 $X=106000 $Y=88550 $D=42
M47 VDDA VDDA VDDA VDDA pmos4 L=1e-05 W=1e-06 AD=8.5e-13 AS=8.5e-13 PD=2.7e-06 PS=2.7e-06 NRD=0.425 NRS=0.425 $X=106000 $Y=156950 $D=42
M48 VDDA VDDA VDDA VDDA pmos4 L=1e-05 W=1e-06 AD=8.5e-13 AS=8.5e-13 PD=2.7e-06 PS=2.7e-06 NRD=0.425 NRS=0.425 $X=118300 $Y=88550 $D=42
M49 VDDA VDDA VDDA VDDA pmos4 L=1e-05 W=1e-06 AD=8.5e-13 AS=8.5e-13 PD=2.7e-06 PS=2.7e-06 NRD=0.425 NRS=0.425 $X=118300 $Y=156950 $D=42
M50 VDDA VDDA VDDA VDDA pmos4 L=1e-05 W=1e-06 AD=8.5e-13 AS=8.5e-13 PD=2.7e-06 PS=2.7e-06 NRD=0.425 NRS=0.425 $X=130600 $Y=88550 $D=42
M51 VDDA VDDA VDDA VDDA pmos4 L=1e-05 W=1e-06 AD=8.5e-13 AS=8.5e-13 PD=2.7e-06 PS=2.7e-06 NRD=0.425 NRS=0.425 $X=130600 $Y=156950 $D=42
M52 VDDA VDDA VDDA VDDA pmos4 L=1e-05 W=1e-06 AD=8.5e-13 AS=8.5e-13 PD=2.7e-06 PS=2.7e-06 NRD=0.425 NRS=0.425 $X=142900 $Y=88550 $D=42
M53 VDDA VDDA VDDA VDDA pmos4 L=1e-05 W=1e-06 AD=8.5e-13 AS=8.5e-13 PD=2.7e-06 PS=2.7e-06 NRD=0.425 NRS=0.425 $X=142900 $Y=156950 $D=42
M54 VDDA VDDA VDDA VDDA pmos4 L=1e-05 W=1e-06 AD=8.5e-13 AS=8.5e-13 PD=2.7e-06 PS=2.7e-06 NRD=0.425 NRS=0.425 $X=155200 $Y=88550 $D=42
M55 VDDA VDDA VDDA VDDA pmos4 L=1e-05 W=1e-06 AD=8.5e-13 AS=8.5e-13 PD=2.7e-06 PS=2.7e-06 NRD=0.425 NRS=0.425 $X=155200 $Y=99950 $D=42
M56 VDDA VDDA VDDA VDDA pmos4 L=1e-05 W=1e-06 AD=8.5e-13 AS=8.5e-13 PD=2.7e-06 PS=2.7e-06 NRD=0.425 NRS=0.425 $X=155200 $Y=111350 $D=42
M57 VDDA VDDA VDDA VDDA pmos4 L=1e-05 W=1e-06 AD=8.5e-13 AS=8.5e-13 PD=2.7e-06 PS=2.7e-06 NRD=0.425 NRS=0.425 $X=155200 $Y=122750 $D=42
M58 VDDA VDDA VDDA VDDA pmos4 L=1e-05 W=1e-06 AD=8.5e-13 AS=8.5e-13 PD=2.7e-06 PS=2.7e-06 NRD=0.425 NRS=0.425 $X=155200 $Y=134150 $D=42
M59 VDDA VDDA VDDA VDDA pmos4 L=1e-05 W=1e-06 AD=8.5e-13 AS=8.5e-13 PD=2.7e-06 PS=2.7e-06 NRD=0.425 NRS=0.425 $X=155200 $Y=145550 $D=42
M60 VDDA VDDA VDDA VDDA pmos4 L=1e-05 W=1e-06 AD=8.5e-13 AS=8.5e-13 PD=2.7e-06 PS=2.7e-06 NRD=0.425 NRS=0.425 $X=155200 $Y=156950 $D=42
M61 VDDA VDDA VDDA VDDA pmos4 L=4e-06 W=1e-05 AD=8.5e-12 AS=8.5e-12 PD=1.17e-05 PS=1.17e-05 NRD=0.0425 NRS=0.0425 $X=163225 $Y=25100 $D=42
M62 VDDA VDDA VDDA VDDA pmos4 L=4e-06 W=1e-05 AD=8.5e-12 AS=8.5e-12 PD=1.17e-05 PS=1.17e-05 NRD=0.0425 NRS=0.0425 $X=163225 $Y=43900 $D=42
M63 Vout 7 VDDA VDDA pmos4 L=1e-05 W=1e-06 AD=8.5e-13 AS=8.5e-13 PD=2.7e-06 PS=2.7e-06 NRD=0.425 NRS=0.425 $X=32200 $Y=99950 $D=41
M64 Vout 7 VDDA VDDA pmos4 L=1e-05 W=1e-06 AD=8.5e-13 AS=8.5e-13 PD=2.7e-06 PS=2.7e-06 NRD=0.425 NRS=0.425 $X=32200 $Y=111350 $D=41
M65 Vout 7 VDDA VDDA pmos4 L=1e-05 W=1e-06 AD=8.5e-13 AS=8.5e-13 PD=2.7e-06 PS=2.7e-06 NRD=0.425 NRS=0.425 $X=32200 $Y=122750 $D=41
M66 Vout 7 VDDA VDDA pmos4 L=1e-05 W=1e-06 AD=8.5e-13 AS=8.5e-13 PD=2.7e-06 PS=2.7e-06 NRD=0.425 NRS=0.425 $X=32200 $Y=134150 $D=41
M67 Vout 7 VDDA VDDA pmos4 L=1e-05 W=1e-06 AD=8.5e-13 AS=8.5e-13 PD=2.7e-06 PS=2.7e-06 NRD=0.425 NRS=0.425 $X=32200 $Y=145550 $D=41
M68 Vout 7 VDDA VDDA pmos4 L=1e-05 W=1e-06 AD=8.5e-13 AS=8.5e-13 PD=2.7e-06 PS=2.7e-06 NRD=0.425 NRS=0.425 $X=44500 $Y=99950 $D=41
M69 Vout 7 VDDA VDDA pmos4 L=1e-05 W=1e-06 AD=8.5e-13 AS=8.5e-13 PD=2.7e-06 PS=2.7e-06 NRD=0.425 NRS=0.425 $X=44500 $Y=111350 $D=41
M70 Vout 7 VDDA VDDA pmos4 L=1e-05 W=1e-06 AD=8.5e-13 AS=8.5e-13 PD=2.7e-06 PS=2.7e-06 NRD=0.425 NRS=0.425 $X=44500 $Y=122750 $D=41
M71 Vout 7 VDDA VDDA pmos4 L=1e-05 W=1e-06 AD=8.5e-13 AS=8.5e-13 PD=2.7e-06 PS=2.7e-06 NRD=0.425 NRS=0.425 $X=44500 $Y=134150 $D=41
M72 Vout 7 VDDA VDDA pmos4 L=1e-05 W=1e-06 AD=8.5e-13 AS=8.5e-13 PD=2.7e-06 PS=2.7e-06 NRD=0.425 NRS=0.425 $X=44500 $Y=145550 $D=41
M73 Vout 7 VDDA VDDA pmos4 L=1e-05 W=1e-06 AD=8.5e-13 AS=8.5e-13 PD=2.7e-06 PS=2.7e-06 NRD=0.425 NRS=0.425 $X=56800 $Y=99950 $D=41
M74 Vout 7 VDDA VDDA pmos4 L=1e-05 W=1e-06 AD=8.5e-13 AS=8.5e-13 PD=2.7e-06 PS=2.7e-06 NRD=0.425 NRS=0.425 $X=56800 $Y=111350 $D=41
M75 8 7 VDDA VDDA pmos4 L=1e-05 W=1e-06 AD=8.5e-13 AS=8.5e-13 PD=2.7e-06 PS=2.7e-06 NRD=0.425 NRS=0.425 $X=56800 $Y=122750 $D=41
M76 Vout 7 VDDA VDDA pmos4 L=1e-05 W=1e-06 AD=8.5e-13 AS=8.5e-13 PD=2.7e-06 PS=2.7e-06 NRD=0.425 NRS=0.425 $X=56800 $Y=134150 $D=41
M77 Vout 7 VDDA VDDA pmos4 L=1e-05 W=1e-06 AD=8.5e-13 AS=8.5e-13 PD=2.7e-06 PS=2.7e-06 NRD=0.425 NRS=0.425 $X=56800 $Y=145550 $D=41
M78 Vout 7 VDDA VDDA pmos4 L=1e-05 W=1e-06 AD=8.5e-13 AS=8.5e-13 PD=2.7e-06 PS=2.7e-06 NRD=0.425 NRS=0.425 $X=69100 $Y=99950 $D=41
M79 Vout 7 VDDA VDDA pmos4 L=1e-05 W=1e-06 AD=8.5e-13 AS=8.5e-13 PD=2.7e-06 PS=2.7e-06 NRD=0.425 NRS=0.425 $X=69100 $Y=111350 $D=41
M80 8 7 VDDA VDDA pmos4 L=1e-05 W=1e-06 AD=8.5e-13 AS=8.5e-13 PD=2.7e-06 PS=2.7e-06 NRD=0.425 NRS=0.425 $X=69100 $Y=122750 $D=41
M81 Vout 7 VDDA VDDA pmos4 L=1e-05 W=1e-06 AD=8.5e-13 AS=8.5e-13 PD=2.7e-06 PS=2.7e-06 NRD=0.425 NRS=0.425 $X=69100 $Y=134150 $D=41
M82 Vout 7 VDDA VDDA pmos4 L=1e-05 W=1e-06 AD=8.5e-13 AS=8.5e-13 PD=2.7e-06 PS=2.7e-06 NRD=0.425 NRS=0.425 $X=69100 $Y=145550 $D=41
M83 Vout 7 VDDA VDDA pmos4 L=1e-05 W=1e-06 AD=8.5e-13 AS=8.5e-13 PD=2.7e-06 PS=2.7e-06 NRD=0.425 NRS=0.425 $X=81400 $Y=99950 $D=41
M84 8 7 VDDA VDDA pmos4 L=1e-05 W=1e-06 AD=8.5e-13 AS=8.5e-13 PD=2.7e-06 PS=2.7e-06 NRD=0.425 NRS=0.425 $X=81400 $Y=111350 $D=41
M85 7 7 VDDA VDDA pmos4 L=1e-05 W=1e-06 AD=8.5e-13 AS=8.5e-13 PD=2.7e-06 PS=2.7e-06 NRD=0.425 NRS=0.425 $X=81400 $Y=122750 $D=41
M86 8 7 VDDA VDDA pmos4 L=1e-05 W=1e-06 AD=8.5e-13 AS=8.5e-13 PD=2.7e-06 PS=2.7e-06 NRD=0.425 NRS=0.425 $X=81400 $Y=134150 $D=41
M87 Vout 7 VDDA VDDA pmos4 L=1e-05 W=1e-06 AD=8.5e-13 AS=8.5e-13 PD=2.7e-06 PS=2.7e-06 NRD=0.425 NRS=0.425 $X=81400 $Y=145550 $D=41
M88 Vout 7 VDDA VDDA pmos4 L=1e-05 W=1e-06 AD=8.5e-13 AS=8.5e-13 PD=2.7e-06 PS=2.7e-06 NRD=0.425 NRS=0.425 $X=93700 $Y=99950 $D=41
M89 8 7 VDDA VDDA pmos4 L=1e-05 W=1e-06 AD=8.5e-13 AS=8.5e-13 PD=2.7e-06 PS=2.7e-06 NRD=0.425 NRS=0.425 $X=93700 $Y=111350 $D=41
M90 7 7 VDDA VDDA pmos4 L=1e-05 W=1e-06 AD=8.5e-13 AS=8.5e-13 PD=2.7e-06 PS=2.7e-06 NRD=0.425 NRS=0.425 $X=93700 $Y=122750 $D=41
M91 8 7 VDDA VDDA pmos4 L=1e-05 W=1e-06 AD=8.5e-13 AS=8.5e-13 PD=2.7e-06 PS=2.7e-06 NRD=0.425 NRS=0.425 $X=93700 $Y=134150 $D=41
M92 Vout 7 VDDA VDDA pmos4 L=1e-05 W=1e-06 AD=8.5e-13 AS=8.5e-13 PD=2.7e-06 PS=2.7e-06 NRD=0.425 NRS=0.425 $X=93700 $Y=145550 $D=41
M93 Vout 7 VDDA VDDA pmos4 L=1e-05 W=1e-06 AD=8.5e-13 AS=8.5e-13 PD=2.7e-06 PS=2.7e-06 NRD=0.425 NRS=0.425 $X=106000 $Y=99950 $D=41
M94 Vout 7 VDDA VDDA pmos4 L=1e-05 W=1e-06 AD=8.5e-13 AS=8.5e-13 PD=2.7e-06 PS=2.7e-06 NRD=0.425 NRS=0.425 $X=106000 $Y=111350 $D=41
M95 8 7 VDDA VDDA pmos4 L=1e-05 W=1e-06 AD=8.5e-13 AS=8.5e-13 PD=2.7e-06 PS=2.7e-06 NRD=0.425 NRS=0.425 $X=106000 $Y=122750 $D=41
M96 Vout 7 VDDA VDDA pmos4 L=1e-05 W=1e-06 AD=8.5e-13 AS=8.5e-13 PD=2.7e-06 PS=2.7e-06 NRD=0.425 NRS=0.425 $X=106000 $Y=134150 $D=41
M97 Vout 7 VDDA VDDA pmos4 L=1e-05 W=1e-06 AD=8.5e-13 AS=8.5e-13 PD=2.7e-06 PS=2.7e-06 NRD=0.425 NRS=0.425 $X=106000 $Y=145550 $D=41
M98 11 Vin+ 8 VDDA pmos4 L=4e-06 W=1e-05 AD=8.5e-12 AS=8.5e-12 PD=1.17e-05 PS=1.17e-05 NRD=0.0425 NRS=0.0425 $X=112825 $Y=25100 $D=41
M99 10 Vin- 8 VDDA pmos4 L=4e-06 W=1e-05 AD=8.5e-12 AS=8.5e-12 PD=1.17e-05 PS=1.17e-05 NRD=0.0425 NRS=0.0425 $X=112825 $Y=43900 $D=41
M100 Vout 7 VDDA VDDA pmos4 L=1e-05 W=1e-06 AD=8.5e-13 AS=8.5e-13 PD=2.7e-06 PS=2.7e-06 NRD=0.425 NRS=0.425 $X=118300 $Y=99950 $D=41
M101 Vout 7 VDDA VDDA pmos4 L=1e-05 W=1e-06 AD=8.5e-13 AS=8.5e-13 PD=2.7e-06 PS=2.7e-06 NRD=0.425 NRS=0.425 $X=118300 $Y=111350 $D=41
M102 8 7 VDDA VDDA pmos4 L=1e-05 W=1e-06 AD=8.5e-13 AS=8.5e-13 PD=2.7e-06 PS=2.7e-06 NRD=0.425 NRS=0.425 $X=118300 $Y=122750 $D=41
M103 Vout 7 VDDA VDDA pmos4 L=1e-05 W=1e-06 AD=8.5e-13 AS=8.5e-13 PD=2.7e-06 PS=2.7e-06 NRD=0.425 NRS=0.425 $X=118300 $Y=134150 $D=41
M104 Vout 7 VDDA VDDA pmos4 L=1e-05 W=1e-06 AD=8.5e-13 AS=8.5e-13 PD=2.7e-06 PS=2.7e-06 NRD=0.425 NRS=0.425 $X=118300 $Y=145550 $D=41
M105 10 Vin- 8 VDDA pmos4 L=4e-06 W=1e-05 AD=8.5e-12 AS=8.5e-12 PD=1.17e-05 PS=1.17e-05 NRD=0.0425 NRS=0.0425 $X=119125 $Y=25100 $D=41
M106 11 Vin+ 8 VDDA pmos4 L=4e-06 W=1e-05 AD=8.5e-12 AS=8.5e-12 PD=1.17e-05 PS=1.17e-05 NRD=0.0425 NRS=0.0425 $X=119125 $Y=43900 $D=41
M107 Vout 7 VDDA VDDA pmos4 L=1e-05 W=1e-06 AD=8.5e-13 AS=8.5e-13 PD=2.7e-06 PS=2.7e-06 NRD=0.425 NRS=0.425 $X=130600 $Y=99950 $D=41
M108 Vout 7 VDDA VDDA pmos4 L=1e-05 W=1e-06 AD=8.5e-13 AS=8.5e-13 PD=2.7e-06 PS=2.7e-06 NRD=0.425 NRS=0.425 $X=130600 $Y=111350 $D=41
M109 Vout 7 VDDA VDDA pmos4 L=1e-05 W=1e-06 AD=8.5e-13 AS=8.5e-13 PD=2.7e-06 PS=2.7e-06 NRD=0.425 NRS=0.425 $X=130600 $Y=122750 $D=41
M110 Vout 7 VDDA VDDA pmos4 L=1e-05 W=1e-06 AD=8.5e-13 AS=8.5e-13 PD=2.7e-06 PS=2.7e-06 NRD=0.425 NRS=0.425 $X=130600 $Y=134150 $D=41
M111 Vout 7 VDDA VDDA pmos4 L=1e-05 W=1e-06 AD=8.5e-13 AS=8.5e-13 PD=2.7e-06 PS=2.7e-06 NRD=0.425 NRS=0.425 $X=130600 $Y=145550 $D=41
M112 11 Vin+ 8 VDDA pmos4 L=4e-06 W=1e-05 AD=8.5e-12 AS=8.5e-12 PD=1.17e-05 PS=1.17e-05 NRD=0.0425 NRS=0.0425 $X=138025 $Y=25100 $D=41
M113 10 Vin- 8 VDDA pmos4 L=4e-06 W=1e-05 AD=8.5e-12 AS=8.5e-12 PD=1.17e-05 PS=1.17e-05 NRD=0.0425 NRS=0.0425 $X=138025 $Y=43900 $D=41
M114 Vout 7 VDDA VDDA pmos4 L=1e-05 W=1e-06 AD=8.5e-13 AS=8.5e-13 PD=2.7e-06 PS=2.7e-06 NRD=0.425 NRS=0.425 $X=142900 $Y=99950 $D=41
M115 Vout 7 VDDA VDDA pmos4 L=1e-05 W=1e-06 AD=8.5e-13 AS=8.5e-13 PD=2.7e-06 PS=2.7e-06 NRD=0.425 NRS=0.425 $X=142900 $Y=111350 $D=41
M116 Vout 7 VDDA VDDA pmos4 L=1e-05 W=1e-06 AD=8.5e-13 AS=8.5e-13 PD=2.7e-06 PS=2.7e-06 NRD=0.425 NRS=0.425 $X=142900 $Y=122750 $D=41
M117 Vout 7 VDDA VDDA pmos4 L=1e-05 W=1e-06 AD=8.5e-13 AS=8.5e-13 PD=2.7e-06 PS=2.7e-06 NRD=0.425 NRS=0.425 $X=142900 $Y=134150 $D=41
M118 Vout 7 VDDA VDDA pmos4 L=1e-05 W=1e-06 AD=8.5e-13 AS=8.5e-13 PD=2.7e-06 PS=2.7e-06 NRD=0.425 NRS=0.425 $X=142900 $Y=145550 $D=41
M119 10 Vin- 8 VDDA pmos4 L=4e-06 W=1e-05 AD=8.5e-12 AS=8.5e-12 PD=1.17e-05 PS=1.17e-05 NRD=0.0425 NRS=0.0425 $X=144325 $Y=25100 $D=41
M120 11 Vin+ 8 VDDA pmos4 L=4e-06 W=1e-05 AD=8.5e-12 AS=8.5e-12 PD=1.17e-05 PS=1.17e-05 NRD=0.0425 NRS=0.0425 $X=144325 $Y=43900 $D=41
X121 Vout 13 cpolyc_CDNS_7804141697234 $T=189400 63300 0 0 $X=188050 $Y=61950
X122 Vout 13 cpolyc_CDNS_7804141697234 $T=189400 121950 0 0 $X=188050 $Y=120600
X123 Vout 13 cpolyc_CDNS_7804141697234 $T=249600 63300 0 0 $X=248250 $Y=61950
X124 Vout 13 cpolyc_CDNS_7804141697234 $T=249600 121950 0 0 $X=248250 $Y=120600
X292 8 11 10 Vin+ Vin- VDDA ICV_6 $T=93075 35100 0 270 $X=91875 $Y=23900
X293 8 10 11 Vin- Vin+ VDDA ICV_6 $T=93075 53900 0 270 $X=91875 $Y=42700
X294 8 11 10 Vin+ Vin- VDDA ICV_6 $T=118275 35100 0 270 $X=117075 $Y=23900
X295 8 10 11 Vin- Vin+ VDDA ICV_6 $T=118275 53900 0 270 $X=117075 $Y=42700
X296 8 11 10 Vin+ Vin- VDDA ICV_6 $T=143475 35100 0 270 $X=142275 $Y=23900
X297 8 10 11 Vin- Vin+ VDDA ICV_6 $T=143475 53900 0 270 $X=142275 $Y=42700
X312 GNDA Ibias cvar_CDNS_7804141697221 $T=3350 13950 1 90 $X=1800 $Y=11675
X313 GNDA 12 cvar_CDNS_7804141697221 $T=48450 13975 0 0 $X=46175 $Y=12425
X314 VDDA ICV_10 $T=19050 89550 0 270 $X=17850 $Y=87350
X315 VDDA ICV_10 $T=19050 100950 0 270 $X=17850 $Y=98750
X316 VDDA ICV_10 $T=19050 112350 0 270 $X=17850 $Y=110150
X317 VDDA ICV_10 $T=19050 123750 0 270 $X=17850 $Y=121550
X318 VDDA ICV_10 $T=19050 135150 0 270 $X=17850 $Y=132950
X319 VDDA ICV_10 $T=19050 146550 0 270 $X=17850 $Y=144350
X320 VDDA ICV_10 $T=19050 157950 0 270 $X=17850 $Y=155750
X323 9 7 Ibias GNDA nmos4_CDNS_780414169728 $T=29250 44700 0 90 $X=8300 $Y=43900
X324 12 Ibias Ibias GNDA nmos4_CDNS_780414169728 $T=29250 53700 0 90 $X=8300 $Y=52900
X325 9 7 Ibias GNDA nmos4_CDNS_780414169728 $T=29250 61900 1 270 $X=8300 $Y=60100
.ENDS
***************************************
.SUBCKT nmos4_CDNS_7804141697232 1 2 3 4
** N=4 EP=4 IP=0 FDC=2
M0 2 3 1 4 nmos4 L=1e-06 W=1e-05 AD=5e-12 AS=8.5e-12 PD=1e-06 PS=1.17e-05 NRD=0.0425 NRS=0.0425 $X=0 $Y=850 $D=37
M1 1 3 2 4 nmos4 L=1e-06 W=1e-05 AD=8.5e-12 AS=5e-12 PD=1.17e-05 PS=1e-06 NRD=0.0425 NRS=0.0425 $X=0 $Y=2850 $D=37
.ENDS
***************************************
.SUBCKT pmos4_CDNS_7804141697233 1 2 3 5
** N=5 EP=4 IP=0 FDC=4
M0 2 3 1 5 pmos4 L=1e-06 W=1e-05 AD=5e-12 AS=8.5e-12 PD=1e-06 PS=1.17e-05 NRD=0.0425 NRS=0.0425 $X=0 $Y=850 $D=41
M1 1 3 2 5 pmos4 L=1e-06 W=1e-05 AD=5e-12 AS=5e-12 PD=1e-06 PS=1e-06 NRD=0.0425 NRS=0.0425 $X=0 $Y=2850 $D=41
M2 2 3 1 5 pmos4 L=1e-06 W=1e-05 AD=5e-12 AS=5e-12 PD=1e-06 PS=1e-06 NRD=0.0425 NRS=0.0425 $X=0 $Y=4850 $D=41
M3 1 3 2 5 pmos4 L=1e-06 W=1e-05 AD=8.5e-12 AS=5e-12 PD=1.17e-05 PS=1e-06 NRD=0.0425 NRS=0.0425 $X=0 $Y=6850 $D=41
.ENDS
***************************************
.SUBCKT 7_MUX21 EN VDDA A1 Out A0 GNDA
** N=7 EP=6 IP=22 FDC=16
D0 GNDA VDDA p_nwd AREA=369.675 PJ=78.7 $X=21400 $Y=4200 $D=87
X1 VDDA EN 3 GNDA Inverter $T=2150 8200 0 0 $X=2700 $Y=8225
X2 A0 Out 3 GNDA nmos4_CDNS_7804141697232 $T=9950 16950 0 270 $X=9700 $Y=6250
X3 Out A1 EN GNDA nmos4_CDNS_7804141697232 $T=15350 6950 1 90 $X=15100 $Y=6250
X4 Out A1 3 VDDA pmos4_CDNS_7804141697233 $T=24150 6950 1 90 $X=22950 $Y=5750
X5 A0 Out EN VDDA pmos4_CDNS_7804141697233 $T=33800 16950 0 270 $X=32600 $Y=5750
.ENDS
***************************************
.SUBCKT P1_C_CDNS_78041416972123
** N=3 EP=0 IP=0 FDC=0
.ENDS
***************************************
.SUBCKT pmos4_CDNS_7804141697231
** N=5 EP=0 IP=0 FDC=0
.ENDS
***************************************
.SUBCKT ICV_11
** N=7 EP=0 IP=10 FDC=0
.ENDS
***************************************
.SUBCKT ICV_12 3 4 5 8
** N=9 EP=4 IP=14 FDC=2
M0 4 8 3 3 pmos4 L=1e-05 W=3e-06 AD=2.55e-12 AS=2.55e-12 PD=4.7e-06 PS=4.7e-06 NRD=0.141667 NRS=0.141667 $X=4250 $Y=850 $D=41
M1 5 8 3 3 pmos4 L=1e-05 W=3e-06 AD=2.55e-12 AS=2.55e-12 PD=4.7e-06 PS=4.7e-06 NRD=0.141667 NRS=0.141667 $X=8500 $Y=850 $D=41
.ENDS
***************************************
.SUBCKT ICV_13 3 4 5 6 7 8 11
** N=12 EP=7 IP=18 FDC=6
M0 6 11 3 3 pmos4 L=1e-05 W=3e-06 AD=2.55e-12 AS=2.55e-12 PD=4.7e-06 PS=4.7e-06 NRD=0.141667 NRS=0.141667 $X=12750 $Y=850 $D=41
M1 6 11 3 3 pmos4 L=1e-05 W=3e-06 AD=2.55e-12 AS=2.55e-12 PD=4.7e-06 PS=4.7e-06 NRD=0.141667 NRS=0.141667 $X=17000 $Y=850 $D=41
X2 3 4 5 11 ICV_12 $T=0 0 0 0 $X=-1200 $Y=-1200
X3 3 7 8 11 ICV_12 $T=17000 0 0 0 $X=15800 $Y=-1200
.ENDS
***************************************
.SUBCKT ICV_14 3 4 5 6 7 8 11
** N=12 EP=7 IP=24 FDC=14
M0 6 11 3 3 pmos4 L=1e-05 W=3e-06 AD=2.55e-12 AS=2.55e-12 PD=4.7e-06 PS=4.7e-06 NRD=0.141667 NRS=0.141667 $X=29750 $Y=850 $D=41
M1 6 11 3 3 pmos4 L=1e-05 W=3e-06 AD=2.55e-12 AS=2.55e-12 PD=4.7e-06 PS=4.7e-06 NRD=0.141667 NRS=0.141667 $X=34000 $Y=850 $D=41
X2 3 4 5 5 6 6 11 ICV_13 $T=0 0 0 0 $X=-1200 $Y=-1200
X3 3 6 6 7 7 8 11 ICV_13 $T=34000 0 0 0 $X=32800 $Y=-1200
.ENDS
***************************************
.SUBCKT pmos4_CDNS_7804141697225 1 2 3 5
** N=5 EP=4 IP=0 FDC=2
M0 2 3 1 5 pmos4 L=1e-05 W=3e-06 AD=1.5e-12 AS=2.55e-12 PD=1e-06 PS=4.7e-06 NRD=0.141667 NRS=0.141667 $X=0 $Y=850 $D=41
M1 1 3 2 5 pmos4 L=1e-05 W=3e-06 AD=2.55e-12 AS=1.5e-12 PD=4.7e-06 PS=1e-06 NRD=0.141667 NRS=0.141667 $X=0 $Y=11850 $D=41
.ENDS
***************************************
.SUBCKT 7_Calibration_current VDDA Calib_curr curr S<0> S<3> S<2> S<1> GNDA
** N=24 EP=8 IP=199 FDC=153
D0 GNDA VDDA p_nwd AREA=1384.43 PJ=149.7 $X=47050 $Y=47200 $D=87
D1 GNDA VDDA p_nwd AREA=34.54 PJ=24.5 $X=99250 $Y=66450 $D=87
D2 GNDA VDDA p_nwd AREA=33.66 PJ=24.1 $X=117350 $Y=66450 $D=87
D3 GNDA VDDA p_nwd AREA=34.65 PJ=24.55 $X=136175 $Y=66450 $D=87
D4 GNDA VDDA p_nwd AREA=36.74 PJ=25.5 $X=153450 $Y=66450 $D=87
D5 GNDA VDDA p_nwd AREA=16842 PJ=541.1 $X=6850 $Y=82650 $D=87
M6 11 11 11 GNDA nmos4 L=4e-06 W=1e-06 AD=8.5e-13 AS=8.5e-13 PD=2.7e-06 PS=2.7e-06 NRD=0.425 NRS=0.425 $X=14350 $Y=51400 $D=38
M7 11 11 11 GNDA nmos4 L=4e-06 W=1e-06 AD=8.5e-13 AS=8.5e-13 PD=2.7e-06 PS=2.7e-06 NRD=0.425 NRS=0.425 $X=30100 $Y=51400 $D=38
M8 11 11 GNDA GNDA nmos4 L=4e-06 W=1e-06 AD=8.5e-13 AS=8.5e-13 PD=2.7e-06 PS=2.7e-06 NRD=0.425 NRS=0.425 $X=16600 $Y=51400 $D=37
M9 10 11 GNDA GNDA nmos4 L=4e-06 W=1e-06 AD=8.5e-13 AS=8.5e-13 PD=2.7e-06 PS=2.7e-06 NRD=0.425 NRS=0.425 $X=18850 $Y=51400 $D=37
M10 11 11 GNDA GNDA nmos4 L=4e-06 W=1e-06 AD=8.5e-13 AS=8.5e-13 PD=2.7e-06 PS=2.7e-06 NRD=0.425 NRS=0.425 $X=21100 $Y=51400 $D=37
M11 11 11 GNDA GNDA nmos4 L=4e-06 W=1e-06 AD=8.5e-13 AS=8.5e-13 PD=2.7e-06 PS=2.7e-06 NRD=0.425 NRS=0.425 $X=23350 $Y=51400 $D=37
M12 10 11 GNDA GNDA nmos4 L=4e-06 W=1e-06 AD=8.5e-13 AS=8.5e-13 PD=2.7e-06 PS=2.7e-06 NRD=0.425 NRS=0.425 $X=25600 $Y=51400 $D=37
M13 11 11 GNDA GNDA nmos4 L=4e-06 W=1e-06 AD=8.5e-13 AS=8.5e-13 PD=2.7e-06 PS=2.7e-06 NRD=0.425 NRS=0.425 $X=27850 $Y=51400 $D=37
M14 12 S<0> Calib_curr GNDA nmos4 L=1e-06 W=5e-06 AD=2.5e-12 AS=4.25e-12 PD=1e-06 PS=6.7e-06 NRD=0.085 NRS=0.085 $X=100300 $Y=72700 $D=37
M15 Calib_curr S<0> 12 GNDA nmos4 L=1e-06 W=5e-06 AD=4.25e-12 AS=2.5e-12 PD=6.7e-06 PS=1e-06 NRD=0.085 NRS=0.085 $X=102300 $Y=72700 $D=37
M16 6 6 6 VDDA pmos4 L=1e-05 W=3e-06 AD=2.55e-12 AS=2.55e-12 PD=4.7e-06 PS=4.7e-06 NRD=0.141667 NRS=0.141667 $X=26200 $Y=102825 $D=42
M17 6 6 6 VDDA pmos4 L=1e-05 W=3e-06 AD=2.55e-12 AS=2.55e-12 PD=4.7e-06 PS=4.7e-06 NRD=0.141667 NRS=0.141667 $X=26200 $Y=126025 $D=42
M18 6 6 6 VDDA pmos4 L=1e-05 W=3e-06 AD=2.55e-12 AS=2.55e-12 PD=4.7e-06 PS=4.7e-06 NRD=0.141667 NRS=0.141667 $X=26200 $Y=149575 $D=42
M19 6 6 6 VDDA pmos4 L=1e-05 W=3e-06 AD=2.55e-12 AS=2.55e-12 PD=4.7e-06 PS=4.7e-06 NRD=0.141667 NRS=0.141667 $X=157950 $Y=102825 $D=42
M20 6 6 6 VDDA pmos4 L=1e-05 W=3e-06 AD=2.55e-12 AS=2.55e-12 PD=4.7e-06 PS=4.7e-06 NRD=0.141667 NRS=0.141667 $X=157950 $Y=126025 $D=42
M21 6 6 6 VDDA pmos4 L=1e-05 W=3e-06 AD=2.55e-12 AS=2.55e-12 PD=4.7e-06 PS=4.7e-06 NRD=0.141667 NRS=0.141667 $X=157950 $Y=149575 $D=42
M22 3 6 VDDA VDDA pmos4 L=1e-05 W=3e-06 AD=2.55e-12 AS=2.55e-12 PD=4.7e-06 PS=4.7e-06 NRD=0.141667 NRS=0.141667 $X=89950 $Y=102825 $D=41
M23 6 6 VDDA VDDA pmos4 L=1e-05 W=3e-06 AD=2.55e-12 AS=2.55e-12 PD=4.7e-06 PS=4.7e-06 NRD=0.141667 NRS=0.141667 $X=89950 $Y=126025 $D=41
M24 VDDA 6 3 VDDA pmos4 L=1e-05 W=3e-06 AD=2.55e-12 AS=2.55e-12 PD=4.7e-06 PS=4.7e-06 NRD=0.141667 NRS=0.141667 $X=89950 $Y=149575 $D=41
M25 3 6 VDDA VDDA pmos4 L=1e-05 W=3e-06 AD=2.55e-12 AS=2.55e-12 PD=4.7e-06 PS=4.7e-06 NRD=0.141667 NRS=0.141667 $X=94200 $Y=102825 $D=41
M26 6 6 VDDA VDDA pmos4 L=1e-05 W=3e-06 AD=2.55e-12 AS=2.55e-12 PD=4.7e-06 PS=4.7e-06 NRD=0.141667 NRS=0.141667 $X=94200 $Y=126025 $D=41
M27 VDDA 6 3 VDDA pmos4 L=1e-05 W=3e-06 AD=2.55e-12 AS=2.55e-12 PD=4.7e-06 PS=4.7e-06 NRD=0.141667 NRS=0.141667 $X=94200 $Y=149575 $D=41
M28 Calib_curr 16 12 VDDA pmos4 L=1e-06 W=2e-06 AD=1.7e-12 AS=1.7e-12 PD=3.7e-06 PS=3.7e-06 NRD=0.2125 NRS=0.2125 $X=101300 $Y=67650 $D=41
M29 13 18 Calib_curr VDDA pmos4 L=1e-06 W=2e-06 AD=1.7e-12 AS=1.7e-12 PD=3.7e-06 PS=3.7e-06 NRD=0.2125 NRS=0.2125 $X=119400 $Y=67650 $D=41
M30 14 20 Calib_curr VDDA pmos4 L=1e-06 W=2e-06 AD=1.7e-12 AS=1.7e-12 PD=3.7e-06 PS=3.7e-06 NRD=0.2125 NRS=0.2125 $X=138225 $Y=67650 $D=41
M31 15 22 Calib_curr VDDA pmos4 L=1e-06 W=2e-06 AD=1.7e-12 AS=1.7e-12 PD=3.7e-06 PS=3.7e-06 NRD=0.2125 NRS=0.2125 $X=155500 $Y=67650 $D=41
X32 Calib_curr 13 S<3> GNDA nmos4_CDNS_7804141697228 $T=118550 77350 0 270 $X=118300 $Y=71950
X33 Calib_curr 14 S<2> GNDA nmos4_CDNS_7804141697228 $T=137375 77350 0 270 $X=137125 $Y=71950
X34 Calib_curr 15 S<1> GNDA nmos4_CDNS_7804141697228 $T=154650 77350 0 270 $X=154400 $Y=71950
X39 VDDA S<0> 16 GNDA Inverter $T=91450 67550 0 0 $X=92000 $Y=67575
X40 VDDA S<3> 18 GNDA Inverter $T=108850 67550 0 0 $X=109400 $Y=67575
X41 VDDA S<2> 20 GNDA Inverter $T=128600 67550 0 0 $X=129150 $Y=67575
X42 VDDA S<1> 22 GNDA Inverter $T=145200 67550 0 0 $X=145750 $Y=67575
X47 11 curr curr GNDA nmos4_CDNS_780414169728 $T=19250 69850 0 270 $X=19000 $Y=68050
X48 10 7 curr GNDA nmos4_CDNS_780414169728 $T=19250 73450 0 270 $X=19000 $Y=71650
X49 11 curr curr GNDA nmos4_CDNS_780414169728 $T=19250 77050 0 270 $X=19000 $Y=75250
X56 VDDA 3 3 3 3 3 6 ICV_14 $T=26200 101975 0 0 $X=25000 $Y=100775
X57 VDDA 5 5 5 4 2 6 ICV_14 $T=26200 125175 0 0 $X=25000 $Y=123975
X58 VDDA 3 3 3 3 3 6 ICV_14 $T=26200 160425 1 0 $X=25000 $Y=147525
X59 VDDA 3 3 3 3 3 6 ICV_14 $T=94200 101975 0 0 $X=93000 $Y=100775
X60 VDDA 2 4 5 5 5 6 ICV_14 $T=94200 125175 0 0 $X=93000 $Y=123975
X61 VDDA 3 3 3 3 3 6 ICV_14 $T=94200 160425 1 0 $X=93000 $Y=147525
X62 5 15 7 VDDA pmos4_CDNS_7804141697225 $T=52375 75250 1 0 $X=51175 $Y=51350
X63 4 14 7 VDDA pmos4_CDNS_7804141697225 $T=59325 75250 1 0 $X=58125 $Y=51350
X64 6 7 7 VDDA pmos4_CDNS_7804141697225 $T=66275 75250 1 0 $X=65075 $Y=51350
X65 2 13 7 VDDA pmos4_CDNS_7804141697225 $T=73225 75250 1 0 $X=72025 $Y=51350
X66 3 12 7 VDDA pmos4_CDNS_7804141697225 $T=80175 75250 1 0 $X=78975 $Y=51350
.ENDS
***************************************
.SUBCKT P1_C_CDNS_7804141697232
** N=2 EP=0 IP=0 FDC=0
.ENDS
***************************************
.SUBCKT ND_C_CDNS_7804141697295
** N=2 EP=0 IP=0 FDC=0
.ENDS
***************************************
.SUBCKT cpolyc_CDNS_780414169727 2 3
** N=3 EP=2 IP=0 FDC=1
C0 2 3 $[cpolya] $A=3466.12 $P=235.5 $X=1800 $Y=1000 $D=58
.ENDS
***************************************
.SUBCKT P1_C_CDNS_7804141697288
** N=2 EP=0 IP=0 FDC=0
.ENDS
***************************************
.SUBCKT P1_C_CDNS_7804141697290
** N=1 EP=0 IP=0 FDC=0
.ENDS
***************************************
.SUBCKT ICV_15 1 2 3 4
** N=4 EP=4 IP=8 FDC=2
M0 2 4 1 1 nmos4 L=4e-06 W=1e-06 AD=8.5e-13 AS=8.5e-13 PD=2.7e-06 PS=2.7e-06 NRD=0.425 NRS=0.425 $X=0 $Y=-5450 $D=37
M1 3 4 1 1 nmos4 L=4e-06 W=1e-06 AD=8.5e-13 AS=8.5e-13 PD=2.7e-06 PS=2.7e-06 NRD=0.425 NRS=0.425 $X=0 $Y=850 $D=37
.ENDS
***************************************
.SUBCKT ICV_16 1 2 3 4 5
** N=6 EP=5 IP=26 FDC=8
M0 1 1 1 1 pmos4 L=4e-06 W=1e-05 AD=8.5e-12 AS=8.5e-12 PD=1.17e-05 PS=1.17e-05 NRD=0.0425 NRS=0.0425 $X=0 $Y=850 $D=42
M1 2 4 1 1 pmos4 L=4e-06 W=1e-05 AD=8.5e-12 AS=8.5e-12 PD=1.17e-05 PS=1.17e-05 NRD=0.0425 NRS=0.0425 $X=0 $Y=19750 $D=41
M2 3 5 1 1 pmos4 L=4e-06 W=1e-05 AD=8.5e-12 AS=8.5e-12 PD=1.17e-05 PS=1.17e-05 NRD=0.0425 NRS=0.0425 $X=0 $Y=26050 $D=41
M3 2 4 1 1 pmos4 L=4e-06 W=1e-05 AD=8.5e-12 AS=8.5e-12 PD=1.17e-05 PS=1.17e-05 NRD=0.0425 NRS=0.0425 $X=0 $Y=44950 $D=41
X4 1 2 3 4 5 1 ICV_6 $T=0 0 0 0 $X=-1200 $Y=-1200
X5 1 2 3 4 5 1 ICV_6 $T=0 25200 0 0 $X=-1200 $Y=24000
.ENDS
***************************************
.SUBCKT pmos4_CDNS_7804141697213
** N=4 EP=0 IP=0 FDC=0
.ENDS
***************************************
.SUBCKT ICV_17
** N=6 EP=0 IP=8 FDC=0
.ENDS
***************************************
.SUBCKT ICV_18
** N=9 EP=0 IP=12 FDC=0
.ENDS
***************************************
.SUBCKT ICV_19 1
** N=8 EP=1 IP=27 FDC=2
M0 1 1 1 1 pmos4 L=1e-05 W=2e-06 AD=1.7e-12 AS=1.7e-12 PD=3.7e-06 PS=3.7e-06 NRD=0.2125 NRS=0.2125 $X=0 $Y=850 $D=42
M1 1 1 1 1 pmos4 L=1e-05 W=2e-06 AD=1.7e-12 AS=1.7e-12 PD=3.7e-06 PS=3.7e-06 NRD=0.2125 NRS=0.2125 $X=0 $Y=136150 $D=42
.ENDS
***************************************
.SUBCKT 6_CA_Front_Layout GNDA Vout VDDA Ibias Vin- Vin+
** N=13 EP=6 IP=363 FDC=152
R0 5 11 L=9.01902e-05 W=2e-06 $[rpolyh] $X=125725 $Y=12550 $D=17
M1 Ibias GNDA Ibias GNDA cvar w=0.0002112 l=6.5e-07 cols=16 rows=2 $X=29925 $Y=26950 $D=62
D2 GNDA Ibias p_nwd AREA=426.58 PJ=86.2 $X=29625 $Y=26650 $D=87
D3 GNDA 8 p_nwd AREA=5058.12 PJ=304.9 $X=7150 $Y=45100 $D=87
D4 GNDA GNDA p_nwd AREA=5519.48 PJ=302.1 $X=121050 $Y=6900 $D=87
D5 GNDA VDDA p_nwd AREA=23782.7 PJ=626.3 $X=2150 $Y=97000 $D=87
M6 GNDA GNDA GNDA GNDA nmos4 L=2e-05 W=5e-06 AD=4.25e-12 AS=4.25e-12 PD=6.7e-06 PS=6.7e-06 NRD=0.085 NRS=0.085 $X=61350 $Y=19875 $D=38
M7 GNDA GNDA GNDA GNDA nmos4 L=2e-05 W=5e-06 AD=4.25e-12 AS=4.25e-12 PD=6.7e-06 PS=6.7e-06 NRD=0.085 NRS=0.085 $X=80100 $Y=19875 $D=38
M8 5 6 GNDA GNDA nmos4 L=2e-05 W=5e-06 AD=4.25e-12 AS=4.25e-12 PD=6.7e-06 PS=6.7e-06 NRD=0.085 NRS=0.085 $X=67600 $Y=19875 $D=37
M9 6 6 GNDA GNDA nmos4 L=2e-05 W=5e-06 AD=4.25e-12 AS=4.25e-12 PD=6.7e-06 PS=6.7e-06 NRD=0.085 NRS=0.085 $X=73850 $Y=19875 $D=37
M10 GNDA 5 Vout GNDA nmos4 L=4e-06 W=2e-05 AD=1e-11 AS=1.7e-11 PD=1e-06 PS=2.17e-05 NRD=0.02125 NRS=0.02125 $X=91450 $Y=14975 $D=37
M11 Vout 5 GNDA GNDA nmos4 L=4e-06 W=2e-05 AD=1e-11 AS=1e-11 PD=1e-06 PS=1e-06 NRD=0.02125 NRS=0.02125 $X=96450 $Y=14975 $D=37
M12 GNDA 5 Vout GNDA nmos4 L=4e-06 W=2e-05 AD=1e-11 AS=1e-11 PD=1e-06 PS=1e-06 NRD=0.02125 NRS=0.02125 $X=101450 $Y=14975 $D=37
M13 Vout 5 GNDA GNDA nmos4 L=4e-06 W=2e-05 AD=1e-11 AS=1e-11 PD=1e-06 PS=1e-06 NRD=0.02125 NRS=0.02125 $X=106450 $Y=14975 $D=37
M14 GNDA 5 Vout GNDA nmos4 L=4e-06 W=2e-05 AD=1.7e-11 AS=1e-11 PD=2.17e-05 PS=1e-06 NRD=0.02125 NRS=0.02125 $X=111450 $Y=14975 $D=37
M15 VDDA VDDA VDDA VDDA pmos4 L=1e-05 W=2e-06 AD=1.7e-12 AS=1.7e-12 PD=3.7e-06 PS=3.7e-06 NRD=0.2125 NRS=0.2125 $X=33625 $Y=117350 $D=42
M16 VDDA VDDA VDDA VDDA pmos4 L=1e-05 W=2e-06 AD=1.7e-12 AS=1.7e-12 PD=3.7e-06 PS=3.7e-06 NRD=0.2125 NRS=0.2125 $X=33625 $Y=204150 $D=42
M17 VDDA VDDA VDDA VDDA pmos4 L=1e-05 W=2e-06 AD=1.7e-12 AS=1.7e-12 PD=3.7e-06 PS=3.7e-06 NRD=0.2125 NRS=0.2125 $X=45925 $Y=117350 $D=42
M18 VDDA VDDA VDDA VDDA pmos4 L=1e-05 W=2e-06 AD=1.7e-12 AS=1.7e-12 PD=3.7e-06 PS=3.7e-06 NRD=0.2125 NRS=0.2125 $X=45925 $Y=204150 $D=42
M19 VDDA VDDA VDDA VDDA pmos4 L=1e-05 W=2e-06 AD=1.7e-12 AS=1.7e-12 PD=3.7e-06 PS=3.7e-06 NRD=0.2125 NRS=0.2125 $X=58225 $Y=117350 $D=42
M20 VDDA VDDA VDDA VDDA pmos4 L=1e-05 W=2e-06 AD=1.7e-12 AS=1.7e-12 PD=3.7e-06 PS=3.7e-06 NRD=0.2125 NRS=0.2125 $X=58225 $Y=204150 $D=42
M21 VDDA VDDA VDDA VDDA pmos4 L=1e-05 W=2e-06 AD=1.7e-12 AS=1.7e-12 PD=3.7e-06 PS=3.7e-06 NRD=0.2125 NRS=0.2125 $X=70525 $Y=117350 $D=42
M22 VDDA VDDA VDDA VDDA pmos4 L=1e-05 W=2e-06 AD=1.7e-12 AS=1.7e-12 PD=3.7e-06 PS=3.7e-06 NRD=0.2125 NRS=0.2125 $X=70525 $Y=204150 $D=42
M23 VDDA VDDA VDDA VDDA pmos4 L=1e-05 W=2e-06 AD=1.7e-12 AS=1.7e-12 PD=3.7e-06 PS=3.7e-06 NRD=0.2125 NRS=0.2125 $X=82825 $Y=117350 $D=42
M24 VDDA VDDA VDDA VDDA pmos4 L=1e-05 W=2e-06 AD=1.7e-12 AS=1.7e-12 PD=3.7e-06 PS=3.7e-06 NRD=0.2125 NRS=0.2125 $X=82825 $Y=204150 $D=42
M25 8 8 8 8 pmos4 L=4e-06 W=1e-05 AD=8.5e-12 AS=8.5e-12 PD=1.17e-05 PS=1.17e-05 NRD=0.0425 NRS=0.0425 $X=91625 $Y=56425 $D=42
M26 8 8 8 8 pmos4 L=4e-06 W=1e-05 AD=8.5e-12 AS=8.5e-12 PD=1.17e-05 PS=1.17e-05 NRD=0.0425 NRS=0.0425 $X=91625 $Y=72575 $D=42
M27 VDDA VDDA VDDA VDDA pmos4 L=1e-05 W=2e-06 AD=1.7e-12 AS=1.7e-12 PD=3.7e-06 PS=3.7e-06 NRD=0.2125 NRS=0.2125 $X=95125 $Y=117350 $D=42
M28 VDDA VDDA VDDA VDDA pmos4 L=1e-05 W=2e-06 AD=1.7e-12 AS=1.7e-12 PD=3.7e-06 PS=3.7e-06 NRD=0.2125 NRS=0.2125 $X=95125 $Y=204150 $D=42
M29 VDDA VDDA VDDA VDDA pmos4 L=1e-05 W=2e-06 AD=1.7e-12 AS=1.7e-12 PD=3.7e-06 PS=3.7e-06 NRD=0.2125 NRS=0.2125 $X=107425 $Y=117350 $D=42
M30 VDDA VDDA VDDA VDDA pmos4 L=1e-05 W=2e-06 AD=1.7e-12 AS=1.7e-12 PD=3.7e-06 PS=3.7e-06 NRD=0.2125 NRS=0.2125 $X=107425 $Y=204150 $D=42
M31 VDDA VDDA VDDA VDDA pmos4 L=1e-05 W=2e-06 AD=1.7e-12 AS=1.7e-12 PD=3.7e-06 PS=3.7e-06 NRD=0.2125 NRS=0.2125 $X=119725 $Y=117350 $D=42
M32 VDDA VDDA VDDA VDDA pmos4 L=1e-05 W=2e-06 AD=1.7e-12 AS=1.7e-12 PD=3.7e-06 PS=3.7e-06 NRD=0.2125 NRS=0.2125 $X=119725 $Y=204150 $D=42
M33 VDDA VDDA VDDA VDDA pmos4 L=1e-05 W=2e-06 AD=1.7e-12 AS=1.7e-12 PD=3.7e-06 PS=3.7e-06 NRD=0.2125 NRS=0.2125 $X=132025 $Y=117350 $D=42
M34 VDDA VDDA VDDA VDDA pmos4 L=1e-05 W=2e-06 AD=1.7e-12 AS=1.7e-12 PD=3.7e-06 PS=3.7e-06 NRD=0.2125 NRS=0.2125 $X=132025 $Y=204150 $D=42
M35 VDDA VDDA VDDA VDDA pmos4 L=1e-05 W=2e-06 AD=1.7e-12 AS=1.7e-12 PD=3.7e-06 PS=3.7e-06 NRD=0.2125 NRS=0.2125 $X=144325 $Y=117350 $D=42
M36 VDDA VDDA VDDA VDDA pmos4 L=1e-05 W=2e-06 AD=1.7e-12 AS=1.7e-12 PD=3.7e-06 PS=3.7e-06 NRD=0.2125 NRS=0.2125 $X=144325 $Y=204150 $D=42
M37 Vout 2 VDDA VDDA pmos4 L=1e-05 W=2e-06 AD=1.7e-12 AS=1.7e-12 PD=3.7e-06 PS=3.7e-06 NRD=0.2125 NRS=0.2125 $X=33625 $Y=129750 $D=41
M38 Vout 2 VDDA VDDA pmos4 L=1e-05 W=2e-06 AD=1.7e-12 AS=1.7e-12 PD=3.7e-06 PS=3.7e-06 NRD=0.2125 NRS=0.2125 $X=33625 $Y=142150 $D=41
M39 Vout 2 VDDA VDDA pmos4 L=1e-05 W=2e-06 AD=1.7e-12 AS=1.7e-12 PD=3.7e-06 PS=3.7e-06 NRD=0.2125 NRS=0.2125 $X=33625 $Y=154550 $D=41
M40 Vout 2 VDDA VDDA pmos4 L=1e-05 W=2e-06 AD=1.7e-12 AS=1.7e-12 PD=3.7e-06 PS=3.7e-06 NRD=0.2125 NRS=0.2125 $X=33625 $Y=166950 $D=41
M41 Vout 2 VDDA VDDA pmos4 L=1e-05 W=2e-06 AD=1.7e-12 AS=1.7e-12 PD=3.7e-06 PS=3.7e-06 NRD=0.2125 NRS=0.2125 $X=33625 $Y=179350 $D=41
M42 Vout 2 VDDA VDDA pmos4 L=1e-05 W=2e-06 AD=1.7e-12 AS=1.7e-12 PD=3.7e-06 PS=3.7e-06 NRD=0.2125 NRS=0.2125 $X=33625 $Y=191750 $D=41
M43 Vout 2 VDDA VDDA pmos4 L=1e-05 W=2e-06 AD=1.7e-12 AS=1.7e-12 PD=3.7e-06 PS=3.7e-06 NRD=0.2125 NRS=0.2125 $X=45925 $Y=129750 $D=41
M44 Vout 2 VDDA VDDA pmos4 L=1e-05 W=2e-06 AD=1.7e-12 AS=1.7e-12 PD=3.7e-06 PS=3.7e-06 NRD=0.2125 NRS=0.2125 $X=45925 $Y=142150 $D=41
M45 Vout 2 VDDA VDDA pmos4 L=1e-05 W=2e-06 AD=1.7e-12 AS=1.7e-12 PD=3.7e-06 PS=3.7e-06 NRD=0.2125 NRS=0.2125 $X=45925 $Y=154550 $D=41
M46 Vout 2 VDDA VDDA pmos4 L=1e-05 W=2e-06 AD=1.7e-12 AS=1.7e-12 PD=3.7e-06 PS=3.7e-06 NRD=0.2125 NRS=0.2125 $X=45925 $Y=166950 $D=41
M47 Vout 2 VDDA VDDA pmos4 L=1e-05 W=2e-06 AD=1.7e-12 AS=1.7e-12 PD=3.7e-06 PS=3.7e-06 NRD=0.2125 NRS=0.2125 $X=45925 $Y=179350 $D=41
M48 Vout 2 VDDA VDDA pmos4 L=1e-05 W=2e-06 AD=1.7e-12 AS=1.7e-12 PD=3.7e-06 PS=3.7e-06 NRD=0.2125 NRS=0.2125 $X=45925 $Y=191750 $D=41
M49 Vout 2 VDDA VDDA pmos4 L=1e-05 W=2e-06 AD=1.7e-12 AS=1.7e-12 PD=3.7e-06 PS=3.7e-06 NRD=0.2125 NRS=0.2125 $X=58225 $Y=129750 $D=41
M50 Vout 2 VDDA VDDA pmos4 L=1e-05 W=2e-06 AD=1.7e-12 AS=1.7e-12 PD=3.7e-06 PS=3.7e-06 NRD=0.2125 NRS=0.2125 $X=58225 $Y=142150 $D=41
M51 Vout 2 VDDA VDDA pmos4 L=1e-05 W=2e-06 AD=1.7e-12 AS=1.7e-12 PD=3.7e-06 PS=3.7e-06 NRD=0.2125 NRS=0.2125 $X=58225 $Y=154550 $D=41
M52 Vout 2 VDDA VDDA pmos4 L=1e-05 W=2e-06 AD=1.7e-12 AS=1.7e-12 PD=3.7e-06 PS=3.7e-06 NRD=0.2125 NRS=0.2125 $X=58225 $Y=166950 $D=41
M53 Vout 2 VDDA VDDA pmos4 L=1e-05 W=2e-06 AD=1.7e-12 AS=1.7e-12 PD=3.7e-06 PS=3.7e-06 NRD=0.2125 NRS=0.2125 $X=58225 $Y=179350 $D=41
M54 Vout 2 VDDA VDDA pmos4 L=1e-05 W=2e-06 AD=1.7e-12 AS=1.7e-12 PD=3.7e-06 PS=3.7e-06 NRD=0.2125 NRS=0.2125 $X=58225 $Y=191750 $D=41
M55 Vout 2 VDDA VDDA pmos4 L=1e-05 W=2e-06 AD=1.7e-12 AS=1.7e-12 PD=3.7e-06 PS=3.7e-06 NRD=0.2125 NRS=0.2125 $X=70525 $Y=129750 $D=41
M56 Vout 2 VDDA VDDA pmos4 L=1e-05 W=2e-06 AD=1.7e-12 AS=1.7e-12 PD=3.7e-06 PS=3.7e-06 NRD=0.2125 NRS=0.2125 $X=70525 $Y=142150 $D=41
M57 8 2 VDDA VDDA pmos4 L=1e-05 W=2e-06 AD=1.7e-12 AS=1.7e-12 PD=3.7e-06 PS=3.7e-06 NRD=0.2125 NRS=0.2125 $X=70525 $Y=154550 $D=41
M58 Vout 2 VDDA VDDA pmos4 L=1e-05 W=2e-06 AD=1.7e-12 AS=1.7e-12 PD=3.7e-06 PS=3.7e-06 NRD=0.2125 NRS=0.2125 $X=70525 $Y=166950 $D=41
M59 Vout 2 VDDA VDDA pmos4 L=1e-05 W=2e-06 AD=1.7e-12 AS=1.7e-12 PD=3.7e-06 PS=3.7e-06 NRD=0.2125 NRS=0.2125 $X=70525 $Y=179350 $D=41
M60 Vout 2 VDDA VDDA pmos4 L=1e-05 W=2e-06 AD=1.7e-12 AS=1.7e-12 PD=3.7e-06 PS=3.7e-06 NRD=0.2125 NRS=0.2125 $X=70525 $Y=191750 $D=41
M61 6 Vin- 8 8 pmos4 L=4e-06 W=1e-05 AD=8.5e-12 AS=8.5e-12 PD=1.17e-05 PS=1.17e-05 NRD=0.0425 NRS=0.0425 $X=72725 $Y=56425 $D=41
M62 5 Vin+ 8 8 pmos4 L=4e-06 W=1e-05 AD=8.5e-12 AS=8.5e-12 PD=1.17e-05 PS=1.17e-05 NRD=0.0425 NRS=0.0425 $X=72725 $Y=72575 $D=41
M63 Vout 2 VDDA VDDA pmos4 L=1e-05 W=2e-06 AD=1.7e-12 AS=1.7e-12 PD=3.7e-06 PS=3.7e-06 NRD=0.2125 NRS=0.2125 $X=82825 $Y=129750 $D=41
M64 8 2 VDDA VDDA pmos4 L=1e-05 W=2e-06 AD=1.7e-12 AS=1.7e-12 PD=3.7e-06 PS=3.7e-06 NRD=0.2125 NRS=0.2125 $X=82825 $Y=142150 $D=41
M65 2 2 VDDA VDDA pmos4 L=1e-05 W=2e-06 AD=1.7e-12 AS=1.7e-12 PD=3.7e-06 PS=3.7e-06 NRD=0.2125 NRS=0.2125 $X=82825 $Y=154550 $D=41
M66 8 2 VDDA VDDA pmos4 L=1e-05 W=2e-06 AD=1.7e-12 AS=1.7e-12 PD=3.7e-06 PS=3.7e-06 NRD=0.2125 NRS=0.2125 $X=82825 $Y=166950 $D=41
M67 8 2 VDDA VDDA pmos4 L=1e-05 W=2e-06 AD=1.7e-12 AS=1.7e-12 PD=3.7e-06 PS=3.7e-06 NRD=0.2125 NRS=0.2125 $X=82825 $Y=179350 $D=41
M68 Vout 2 VDDA VDDA pmos4 L=1e-05 W=2e-06 AD=1.7e-12 AS=1.7e-12 PD=3.7e-06 PS=3.7e-06 NRD=0.2125 NRS=0.2125 $X=82825 $Y=191750 $D=41
M69 Vout 2 VDDA VDDA pmos4 L=1e-05 W=2e-06 AD=1.7e-12 AS=1.7e-12 PD=3.7e-06 PS=3.7e-06 NRD=0.2125 NRS=0.2125 $X=95125 $Y=129750 $D=41
M70 8 2 VDDA VDDA pmos4 L=1e-05 W=2e-06 AD=1.7e-12 AS=1.7e-12 PD=3.7e-06 PS=3.7e-06 NRD=0.2125 NRS=0.2125 $X=95125 $Y=142150 $D=41
M71 8 2 VDDA VDDA pmos4 L=1e-05 W=2e-06 AD=1.7e-12 AS=1.7e-12 PD=3.7e-06 PS=3.7e-06 NRD=0.2125 NRS=0.2125 $X=95125 $Y=154550 $D=41
M72 2 2 VDDA VDDA pmos4 L=1e-05 W=2e-06 AD=1.7e-12 AS=1.7e-12 PD=3.7e-06 PS=3.7e-06 NRD=0.2125 NRS=0.2125 $X=95125 $Y=166950 $D=41
M73 8 2 VDDA VDDA pmos4 L=1e-05 W=2e-06 AD=1.7e-12 AS=1.7e-12 PD=3.7e-06 PS=3.7e-06 NRD=0.2125 NRS=0.2125 $X=95125 $Y=179350 $D=41
M74 Vout 2 VDDA VDDA pmos4 L=1e-05 W=2e-06 AD=1.7e-12 AS=1.7e-12 PD=3.7e-06 PS=3.7e-06 NRD=0.2125 NRS=0.2125 $X=95125 $Y=191750 $D=41
M75 Vout 2 VDDA VDDA pmos4 L=1e-05 W=2e-06 AD=1.7e-12 AS=1.7e-12 PD=3.7e-06 PS=3.7e-06 NRD=0.2125 NRS=0.2125 $X=107425 $Y=129750 $D=41
M76 Vout 2 VDDA VDDA pmos4 L=1e-05 W=2e-06 AD=1.7e-12 AS=1.7e-12 PD=3.7e-06 PS=3.7e-06 NRD=0.2125 NRS=0.2125 $X=107425 $Y=142150 $D=41
M77 Vout 2 VDDA VDDA pmos4 L=1e-05 W=2e-06 AD=1.7e-12 AS=1.7e-12 PD=3.7e-06 PS=3.7e-06 NRD=0.2125 NRS=0.2125 $X=107425 $Y=154550 $D=41
M78 8 2 VDDA VDDA pmos4 L=1e-05 W=2e-06 AD=1.7e-12 AS=1.7e-12 PD=3.7e-06 PS=3.7e-06 NRD=0.2125 NRS=0.2125 $X=107425 $Y=166950 $D=41
M79 Vout 2 VDDA VDDA pmos4 L=1e-05 W=2e-06 AD=1.7e-12 AS=1.7e-12 PD=3.7e-06 PS=3.7e-06 NRD=0.2125 NRS=0.2125 $X=107425 $Y=179350 $D=41
M80 Vout 2 VDDA VDDA pmos4 L=1e-05 W=2e-06 AD=1.7e-12 AS=1.7e-12 PD=3.7e-06 PS=3.7e-06 NRD=0.2125 NRS=0.2125 $X=107425 $Y=191750 $D=41
M81 Vout 2 VDDA VDDA pmos4 L=1e-05 W=2e-06 AD=1.7e-12 AS=1.7e-12 PD=3.7e-06 PS=3.7e-06 NRD=0.2125 NRS=0.2125 $X=119725 $Y=129750 $D=41
M82 Vout 2 VDDA VDDA pmos4 L=1e-05 W=2e-06 AD=1.7e-12 AS=1.7e-12 PD=3.7e-06 PS=3.7e-06 NRD=0.2125 NRS=0.2125 $X=119725 $Y=142150 $D=41
M83 Vout 2 VDDA VDDA pmos4 L=1e-05 W=2e-06 AD=1.7e-12 AS=1.7e-12 PD=3.7e-06 PS=3.7e-06 NRD=0.2125 NRS=0.2125 $X=119725 $Y=154550 $D=41
M84 Vout 2 VDDA VDDA pmos4 L=1e-05 W=2e-06 AD=1.7e-12 AS=1.7e-12 PD=3.7e-06 PS=3.7e-06 NRD=0.2125 NRS=0.2125 $X=119725 $Y=166950 $D=41
M85 Vout 2 VDDA VDDA pmos4 L=1e-05 W=2e-06 AD=1.7e-12 AS=1.7e-12 PD=3.7e-06 PS=3.7e-06 NRD=0.2125 NRS=0.2125 $X=119725 $Y=179350 $D=41
M86 Vout 2 VDDA VDDA pmos4 L=1e-05 W=2e-06 AD=1.7e-12 AS=1.7e-12 PD=3.7e-06 PS=3.7e-06 NRD=0.2125 NRS=0.2125 $X=119725 $Y=191750 $D=41
M87 Vout 2 VDDA VDDA pmos4 L=1e-05 W=2e-06 AD=1.7e-12 AS=1.7e-12 PD=3.7e-06 PS=3.7e-06 NRD=0.2125 NRS=0.2125 $X=132025 $Y=129750 $D=41
M88 Vout 2 VDDA VDDA pmos4 L=1e-05 W=2e-06 AD=1.7e-12 AS=1.7e-12 PD=3.7e-06 PS=3.7e-06 NRD=0.2125 NRS=0.2125 $X=132025 $Y=142150 $D=41
M89 Vout 2 VDDA VDDA pmos4 L=1e-05 W=2e-06 AD=1.7e-12 AS=1.7e-12 PD=3.7e-06 PS=3.7e-06 NRD=0.2125 NRS=0.2125 $X=132025 $Y=154550 $D=41
M90 Vout 2 VDDA VDDA pmos4 L=1e-05 W=2e-06 AD=1.7e-12 AS=1.7e-12 PD=3.7e-06 PS=3.7e-06 NRD=0.2125 NRS=0.2125 $X=132025 $Y=166950 $D=41
M91 Vout 2 VDDA VDDA pmos4 L=1e-05 W=2e-06 AD=1.7e-12 AS=1.7e-12 PD=3.7e-06 PS=3.7e-06 NRD=0.2125 NRS=0.2125 $X=132025 $Y=179350 $D=41
M92 Vout 2 VDDA VDDA pmos4 L=1e-05 W=2e-06 AD=1.7e-12 AS=1.7e-12 PD=3.7e-06 PS=3.7e-06 NRD=0.2125 NRS=0.2125 $X=132025 $Y=191750 $D=41
M93 Vout 2 VDDA VDDA pmos4 L=1e-05 W=2e-06 AD=1.7e-12 AS=1.7e-12 PD=3.7e-06 PS=3.7e-06 NRD=0.2125 NRS=0.2125 $X=144325 $Y=129750 $D=41
M94 Vout 2 VDDA VDDA pmos4 L=1e-05 W=2e-06 AD=1.7e-12 AS=1.7e-12 PD=3.7e-06 PS=3.7e-06 NRD=0.2125 NRS=0.2125 $X=144325 $Y=142150 $D=41
M95 Vout 2 VDDA VDDA pmos4 L=1e-05 W=2e-06 AD=1.7e-12 AS=1.7e-12 PD=3.7e-06 PS=3.7e-06 NRD=0.2125 NRS=0.2125 $X=144325 $Y=154550 $D=41
M96 Vout 2 VDDA VDDA pmos4 L=1e-05 W=2e-06 AD=1.7e-12 AS=1.7e-12 PD=3.7e-06 PS=3.7e-06 NRD=0.2125 NRS=0.2125 $X=144325 $Y=166950 $D=41
M97 Vout 2 VDDA VDDA pmos4 L=1e-05 W=2e-06 AD=1.7e-12 AS=1.7e-12 PD=3.7e-06 PS=3.7e-06 NRD=0.2125 NRS=0.2125 $X=144325 $Y=179350 $D=41
M98 Vout 2 VDDA VDDA pmos4 L=1e-05 W=2e-06 AD=1.7e-12 AS=1.7e-12 PD=3.7e-06 PS=3.7e-06 NRD=0.2125 NRS=0.2125 $X=144325 $Y=191750 $D=41
X139 8 5 6 Vin+ Vin- 8 ICV_6 $T=71875 66425 0 270 $X=70675 $Y=55225
X140 8 6 5 Vin- Vin+ 8 ICV_6 $T=71875 82575 0 270 $X=70675 $Y=71375
X141 9 Ibias Ibias GNDA nmos4_CDNS_780414169728 $T=4175 32450 1 90 $X=3925 $Y=31650
X142 1 2 Ibias GNDA nmos4_CDNS_780414169728 $T=4175 39750 0 270 $X=3925 $Y=37950
X213 Vout 11 cpolyc_CDNS_780414169727 $T=123200 92600 0 270 $X=121850 $Y=29200
X220 GNDA 9 1 9 ICV_15 $T=15375 13250 0 90 $X=9425 $Y=12850
X221 GNDA 1 9 9 ICV_15 $T=15375 18150 0 90 $X=9425 $Y=17750
X222 GNDA 9 1 9 ICV_15 $T=27975 13250 0 90 $X=22025 $Y=12850
X223 GNDA 1 9 9 ICV_15 $T=27975 18150 0 90 $X=22025 $Y=17750
X224 8 5 6 Vin+ Vin- ICV_16 $T=21475 66425 0 270 $X=20275 $Y=55225
X225 8 6 5 Vin- Vin+ ICV_16 $T=21475 82575 0 270 $X=20275 $Y=71375
X226 VDDA ICV_19 $T=20475 117350 1 90 $X=19275 $Y=116150
X227 VDDA ICV_19 $T=20475 129750 1 90 $X=19275 $Y=128550
X228 VDDA ICV_19 $T=20475 142150 1 90 $X=19275 $Y=140950
X229 VDDA ICV_19 $T=20475 154550 1 90 $X=19275 $Y=153350
X230 VDDA ICV_19 $T=20475 166950 1 90 $X=19275 $Y=165750
X231 VDDA ICV_19 $T=20475 179350 1 90 $X=19275 $Y=178150
X232 VDDA ICV_19 $T=20475 191750 1 90 $X=19275 $Y=190550
X233 VDDA ICV_19 $T=20475 204150 1 90 $X=19275 $Y=202950
.ENDS
***************************************
.SUBCKT 8_CA_TIA_Front_calib VDDA CE RE EN_100mV v1500 V_EC S<0> S<3> S<2> Calib_EN S<1> WE Ibias9 TIA_in Vref Vout Ibias8 Calib_cur GNDA
** N=21 EP=19 IP=60 FDC=552
R0 GNDA GNDA L=5e-06 W=8e-07 $[rpolyh] $X=774075 $Y=129600 $D=18
D1 GNDA GNDA p_nwd AREA=25169.9 PJ=728.4 $X=761775 $Y=21250 $D=87
X2 Vout TIA_in cpolyc_CDNS_7804141697241 $T=959475 26750 0 0 $X=958125 $Y=25400
X3 Vout TIA_in cpolyc_CDNS_7804141697241 $T=959475 73250 0 0 $X=958125 $Y=71900
X4 Vout TIA_in ICV_1 $T=767275 26750 0 0 $X=765925 $Y=25400
X5 Vout TIA_in ICV_1 $T=767275 73250 0 0 $X=765925 $Y=71900
X6 Vout TIA_in ICV_1 $T=863375 26750 0 0 $X=862025 $Y=25400
X7 Vout TIA_in ICV_1 $T=863375 73250 0 0 $X=862025 $Y=71900
X8 S<2> S<3> S<0> S<1> VDDA TIA_in Vout GNDA 6_Resnet $T=716250 66000 0 0 $X=766125 $Y=141898
X9 GNDA Calib_cur cvar_CDNS_7804141697221 $T=255125 24450 1 180 $X=230350 $Y=22900
X10 Vout VDDA Ibias9 GNDA TIA_in Vref 6_TIA_Front_Layout $T=427675 63900 0 0 $X=426225 $Y=65550
X11 EN_100mV VDDA v1500 21 V_EC GNDA 7_MUX21 $T=237275 220800 0 0 $X=237700 $Y=221550
X12 Calib_EN VDDA 20 TIA_in WE GNDA 7_MUX21 $T=359275 220675 0 0 $X=359700 $Y=221425
X13 VDDA 20 Calib_cur S<0> S<3> S<2> S<1> GNDA 7_Calibration_current $T=222350 24000 0 0 $X=227250 $Y=60898
X14 GNDA CE VDDA Ibias8 RE 21 6_CA_Front_Layout $T=196375 17300 1 180 $X=8600 $Y=19098
.ENDS
***************************************
.SUBCKT cpolyc_CDNS_7804141697219 2 3
** N=3 EP=2 IP=0 FDC=1
C0 2 3 $[cpolya] $A=2306.26 $P=192.1 $X=1800 $Y=1000 $D=58
.ENDS
***************************************
.SUBCKT ICV_20 2 3
** N=3 EP=2 IP=6 FDC=2
X0 2 3 cpolyc_CDNS_7804141697219 $T=0 0 0 0 $X=-1350 $Y=-1350
X1 2 3 cpolyc_CDNS_7804141697219 $T=54900 0 0 0 $X=53550 $Y=-1350
.ENDS
***************************************
.SUBCKT rpolyhc_CDNS_780414169720 1 2
** N=3 EP=2 IP=0 FDC=1
R0 1 2 L=5.005e-05 W=8e-07 $[rpolyh] $X=-800 $Y=1550 $D=18
.ENDS
***************************************
.SUBCKT vert10_4 1 2
** N=2 EP=2 IP=0 FDC=1
Q0 2 2 1 pnpvert10 AREA=1e-12 $X=1400 $Y=1400 $D=33
.ENDS
***************************************
.SUBCKT ICV_21 1 2 3
** N=3 EP=3 IP=4 FDC=2
X0 1 2 vert10_4 $T=0 0 0 0 $X=0 $Y=0
X1 3 2 vert10_4 $T=16900 0 0 0 $X=16900 $Y=0
.ENDS
***************************************
.SUBCKT ICV_22 1 2 3
** N=3 EP=3 IP=6 FDC=4
X0 2 1 3 ICV_21 $T=0 0 0 0 $X=0 $Y=0
X1 3 1 3 ICV_21 $T=33800 0 0 0 $X=33800 $Y=0
.ENDS
***************************************
.SUBCKT ICV_23 1 2 3
** N=3 EP=3 IP=8 FDC=9
X0 1 1 vert10_4 $T=135200 0 0 0 $X=135200 $Y=0
X1 1 1 2 ICV_22 $T=0 0 0 0 $X=0 $Y=0
X2 1 3 2 ICV_22 $T=67600 0 0 0 $X=67600 $Y=0
.ENDS
***************************************
.SUBCKT cvar_CDNS_7804141697220 1 2
** N=2 EP=2 IP=0 FDC=2
M0 2 1 2 1 cvar w=0.0004752 l=6.5e-07 cols=9 rows=8 $X=0 $Y=0 $D=62
D1 1 2 p_nwd AREA=1043.29 PJ=161.5 $X=-300 $Y=-300 $D=87
.ENDS
***************************************
.SUBCKT cvar_CDNS_7804141697222 1 2
** N=2 EP=2 IP=0 FDC=2
M0 2 1 2 1 cvar w=0.0006864 l=6.5e-07 cols=13 rows=8 $X=0 $Y=0 $D=62
D1 1 2 p_nwd AREA=1469.65 PJ=174.7 $X=-300 $Y=-300 $D=87
.ENDS
***************************************
.SUBCKT rpolyhc_CDNS_780414169721 1 2
** N=3 EP=2 IP=0 FDC=1
R0 1 2 L=0.00015005 W=2e-06 $[rpolyh] $X=-2000 $Y=2750 $D=18
.ENDS
***************************************
.SUBCKT P1_C_CDNS_7804141697271
** N=2 EP=0 IP=0 FDC=0
.ENDS
***************************************
.SUBCKT P1_C_CDNS_780414169727
** N=3 EP=0 IP=0 FDC=0
.ENDS
***************************************
.SUBCKT pmos4_CDNS_7804141697218
** N=4 EP=0 IP=0 FDC=0
.ENDS
***************************************
.SUBCKT ICV_24
** N=6 EP=0 IP=8 FDC=0
.ENDS
***************************************
.SUBCKT cvar_CDNS_7804141697223 1 2
** N=2 EP=2 IP=0 FDC=2
M0 2 1 2 1 cvar w=0.0003564 l=6.5e-07 cols=9 rows=6 $X=0 $Y=0 $D=62
D1 1 2 p_nwd AREA=778.43 PJ=128.7 $X=-300 $Y=-300 $D=87
.ENDS
***************************************
.SUBCKT nmos4_CDNS_7804141697215 1 2 3
** N=3 EP=3 IP=0 FDC=1
M0 2 3 1 1 nmos4 L=1e-05 W=1e-05 AD=8.5e-12 AS=8.5e-12 PD=1.17e-05 PS=1.17e-05 NRD=0.0425 NRS=0.0425 $X=0 $Y=850 $D=37
.ENDS
***************************************
.SUBCKT pmos4_CDNS_7804141697217
** N=4 EP=0 IP=0 FDC=0
.ENDS
***************************************
.SUBCKT ICV_25
** N=8 EP=0 IP=12 FDC=0
.ENDS
***************************************
.SUBCKT nmos4_CDNS_780414169725
** N=4 EP=0 IP=0 FDC=0
.ENDS
***************************************
.SUBCKT pmos4_CDNS_7804141697216
** N=4 EP=0 IP=0 FDC=0
.ENDS
***************************************
.SUBCKT ICV_26
** N=6 EP=0 IP=8 FDC=0
.ENDS
***************************************
.SUBCKT ICV_27 1 2 3 5 6
** N=8 EP=5 IP=12 FDC=3
M0 2 5 1 1 pmos4 L=2e-06 W=1e-05 AD=8.5e-12 AS=8.5e-12 PD=1.17e-05 PS=1.17e-05 NRD=0.0425 NRS=0.0425 $X=0 $Y=-12050 $D=41
M1 3 6 1 1 pmos4 L=2e-06 W=1e-05 AD=8.5e-12 AS=8.5e-12 PD=1.17e-05 PS=1.17e-05 NRD=0.0425 NRS=0.0425 $X=0 $Y=-7750 $D=41
M2 2 5 1 1 pmos4 L=2e-06 W=1e-05 AD=8.5e-12 AS=8.5e-12 PD=1.17e-05 PS=1.17e-05 NRD=0.0425 NRS=0.0425 $X=0 $Y=-3450 $D=41
.ENDS
***************************************
.SUBCKT P1_C_CDNS_7804141697224
** N=3 EP=0 IP=0 FDC=0
.ENDS
***************************************
.SUBCKT ICV_28 1 2 3 5 6
** N=8 EP=5 IP=16 FDC=7
M0 3 6 1 1 pmos4 L=2e-06 W=1e-05 AD=8.5e-12 AS=8.5e-12 PD=1.17e-05 PS=1.17e-05 NRD=0.0425 NRS=0.0425 $X=0 $Y=-16350 $D=41
X1 1 2 3 5 6 ICV_27 $T=0 -17200 0 0 $X=-1200 $Y=-31300
X2 1 2 3 5 6 ICV_27 $T=0 0 0 0 $X=-1200 $Y=-14100
.ENDS
***************************************
.SUBCKT P1_C_CDNS_7804141697235
** N=2 EP=0 IP=0 FDC=0
.ENDS
***************************************
.SUBCKT nmos4_CDNS_780414169722
** N=4 EP=0 IP=0 FDC=0
.ENDS
***************************************
.SUBCKT ICV_29
** N=6 EP=0 IP=8 FDC=0
.ENDS
***************************************
.SUBCKT ND_C_CDNS_7804141697267
** N=2 EP=0 IP=0 FDC=0
.ENDS
***************************************
.SUBCKT ICV_30 1
** N=7 EP=1 IP=26 FDC=2
M0 1 1 1 1 pmos4 L=1e-05 W=5e-06 AD=4.25e-12 AS=4.25e-12 PD=6.7e-06 PS=6.7e-06 NRD=0.085 NRS=0.085 $X=0 $Y=850 $D=42
M1 1 1 1 1 pmos4 L=1e-05 W=5e-06 AD=4.25e-12 AS=4.25e-12 PD=6.7e-06 PS=6.7e-06 NRD=0.085 NRS=0.085 $X=0 $Y=123850 $D=42
.ENDS
***************************************
.SUBCKT 7_PTAT_Layout 1 VDDA GNDA 4 V_ptat_inv vref Ibias
** N=36 EP=7 IP=723 FDC=487
R0 GNDA GNDA L=5e-06 W=8e-07 $[rpolyh] $X=724325 $Y=435825 $D=18
D1 GNDA 9 p_nwd AREA=5489.96 PJ=326.3 $X=79825 $Y=219275 $D=87
D2 GNDA VDDA p_nwd AREA=29240.8 PJ=684 $X=2425 $Y=271500 $D=87
D3 GNDA 16 p_nwd AREA=1335.79 PJ=147.1 $X=180775 $Y=349950 $D=87
D4 GNDA GNDA p_nwd AREA=14782.1 PJ=544.4 $X=203025 $Y=210300 $D=87
D5 GNDA VDDA p_nwd AREA=4481.05 PJ=291.75 $X=179375 $Y=397025 $D=87
D6 GNDA GNDA p_nwd AREA=2501.19 PJ=209.45 $X=404725 $Y=214525 $D=87
D7 GNDA GNDA p_nwd AREA=58283.2 PJ=999.7 $X=689300 $Y=217750 $D=87
M8 Ibias Ibias Ibias GNDA nmos4 L=1e-05 W=5e-06 AD=4.25e-12 AS=4.25e-12 PD=6.7e-06 PS=6.7e-06 NRD=0.085 NRS=0.085 $X=8450 $Y=248900 $D=38
M9 10 10 10 GNDA nmos4 L=2e-05 W=1e-05 AD=8.5e-12 AS=8.5e-12 PD=1.17e-05 PS=1.17e-05 NRD=0.0425 NRS=0.0425 $X=31000 $Y=211750 $D=38
M10 Ibias Ibias Ibias GNDA nmos4 L=1e-05 W=5e-06 AD=4.25e-12 AS=4.25e-12 PD=6.7e-06 PS=6.7e-06 NRD=0.085 NRS=0.085 $X=64700 $Y=248900 $D=38
M11 10 10 10 GNDA nmos4 L=2e-05 W=1e-05 AD=8.5e-12 AS=8.5e-12 PD=1.17e-05 PS=1.17e-05 NRD=0.0425 NRS=0.0425 $X=64750 $Y=211750 $D=38
M12 8 Ibias GNDA GNDA nmos4 L=1e-05 W=5e-06 AD=4.25e-12 AS=4.25e-12 PD=6.7e-06 PS=6.7e-06 NRD=0.085 NRS=0.085 $X=14700 $Y=248900 $D=37
M13 Ibias Ibias GNDA GNDA nmos4 L=1e-05 W=5e-06 AD=4.25e-12 AS=4.25e-12 PD=6.7e-06 PS=6.7e-06 NRD=0.085 NRS=0.085 $X=20950 $Y=248900 $D=37
M14 18 Ibias GNDA GNDA nmos4 L=1e-05 W=5e-06 AD=4.25e-12 AS=4.25e-12 PD=6.7e-06 PS=6.7e-06 NRD=0.085 NRS=0.085 $X=27200 $Y=248900 $D=37
M15 8 Ibias GNDA GNDA nmos4 L=1e-05 W=5e-06 AD=4.25e-12 AS=4.25e-12 PD=6.7e-06 PS=6.7e-06 NRD=0.085 NRS=0.085 $X=33450 $Y=248900 $D=37
M16 8 Ibias GNDA GNDA nmos4 L=1e-05 W=5e-06 AD=4.25e-12 AS=4.25e-12 PD=6.7e-06 PS=6.7e-06 NRD=0.085 NRS=0.085 $X=39700 $Y=248900 $D=37
M17 11 10 GNDA GNDA nmos4 L=2e-05 W=1e-05 AD=8.5e-12 AS=8.5e-12 PD=1.17e-05 PS=1.17e-05 NRD=0.0425 NRS=0.0425 $X=42250 $Y=211750 $D=37
M18 18 Ibias GNDA GNDA nmos4 L=1e-05 W=5e-06 AD=4.25e-12 AS=4.25e-12 PD=6.7e-06 PS=6.7e-06 NRD=0.085 NRS=0.085 $X=45950 $Y=248900 $D=37
M19 Ibias Ibias GNDA GNDA nmos4 L=1e-05 W=5e-06 AD=4.25e-12 AS=4.25e-12 PD=6.7e-06 PS=6.7e-06 NRD=0.085 NRS=0.085 $X=52200 $Y=248900 $D=37
M20 10 10 GNDA GNDA nmos4 L=2e-05 W=1e-05 AD=8.5e-12 AS=8.5e-12 PD=1.17e-05 PS=1.17e-05 NRD=0.0425 NRS=0.0425 $X=53500 $Y=211750 $D=37
M21 8 Ibias GNDA GNDA nmos4 L=1e-05 W=5e-06 AD=4.25e-12 AS=4.25e-12 PD=6.7e-06 PS=6.7e-06 NRD=0.085 NRS=0.085 $X=58450 $Y=248900 $D=37
M22 1 13 19 GNDA nmos4 L=1e-05 W=5e-06 AD=4.25e-12 AS=4.25e-12 PD=6.7e-06 PS=6.7e-06 NRD=0.085 NRS=0.085 $X=182150 $Y=288300 $D=37
M23 19 11 GNDA GNDA nmos4 L=1e-06 W=5e-06 AD=2.5e-12 AS=4.25e-12 PD=1e-06 PS=6.7e-06 NRD=0.085 NRS=0.085 $X=188550 $Y=275750 $D=37
M24 GNDA 11 19 GNDA nmos4 L=1e-06 W=5e-06 AD=4.25e-12 AS=2.5e-12 PD=6.7e-06 PS=1e-06 NRD=0.085 NRS=0.085 $X=190550 $Y=275750 $D=37
M25 14 14 GNDA GNDA nmos4 L=1e-05 W=5e-07 AD=5.9e-13 AS=5.9e-13 PD=2.7e-06 PS=2.7e-06 NRD=0.85 NRS=0.85 $X=224800 $Y=364600 $D=37
M26 VDDA VDDA VDDA VDDA pmos4 L=1e-05 W=5e-06 AD=4.25e-12 AS=4.25e-12 PD=6.7e-06 PS=6.7e-06 NRD=0.085 NRS=0.085 $X=33925 $Y=289850 $D=42
M27 VDDA VDDA VDDA VDDA pmos4 L=1e-05 W=5e-06 AD=4.25e-12 AS=4.25e-12 PD=6.7e-06 PS=6.7e-06 NRD=0.085 NRS=0.085 $X=33925 $Y=416750 $D=42
M28 VDDA VDDA VDDA VDDA pmos4 L=1e-05 W=5e-06 AD=4.25e-12 AS=4.25e-12 PD=6.7e-06 PS=6.7e-06 NRD=0.085 NRS=0.085 $X=46225 $Y=289850 $D=42
M29 VDDA VDDA VDDA VDDA pmos4 L=1e-05 W=5e-06 AD=4.25e-12 AS=4.25e-12 PD=6.7e-06 PS=6.7e-06 NRD=0.085 NRS=0.085 $X=46225 $Y=416750 $D=42
M30 VDDA VDDA VDDA VDDA pmos4 L=1e-05 W=5e-06 AD=4.25e-12 AS=4.25e-12 PD=6.7e-06 PS=6.7e-06 NRD=0.085 NRS=0.085 $X=58525 $Y=289850 $D=42
M31 VDDA VDDA VDDA VDDA pmos4 L=1e-05 W=5e-06 AD=4.25e-12 AS=4.25e-12 PD=6.7e-06 PS=6.7e-06 NRD=0.085 NRS=0.085 $X=58525 $Y=416750 $D=42
M32 VDDA VDDA VDDA VDDA pmos4 L=1e-05 W=5e-06 AD=4.25e-12 AS=4.25e-12 PD=6.7e-06 PS=6.7e-06 NRD=0.085 NRS=0.085 $X=70825 $Y=289850 $D=42
M33 VDDA VDDA VDDA VDDA pmos4 L=1e-05 W=5e-06 AD=4.25e-12 AS=4.25e-12 PD=6.7e-06 PS=6.7e-06 NRD=0.085 NRS=0.085 $X=70825 $Y=416750 $D=42
M34 VDDA VDDA VDDA VDDA pmos4 L=1e-05 W=5e-06 AD=4.25e-12 AS=4.25e-12 PD=6.7e-06 PS=6.7e-06 NRD=0.085 NRS=0.085 $X=83125 $Y=289850 $D=42
M35 VDDA VDDA VDDA VDDA pmos4 L=1e-05 W=5e-06 AD=4.25e-12 AS=4.25e-12 PD=6.7e-06 PS=6.7e-06 NRD=0.085 NRS=0.085 $X=83125 $Y=416750 $D=42
M36 9 9 9 9 pmos4 L=2e-06 W=1e-05 AD=8.5e-12 AS=8.5e-12 PD=1.17e-05 PS=1.17e-05 NRD=0.0425 NRS=0.0425 $X=91525 $Y=230125 $D=42
M37 9 9 9 9 pmos4 L=2e-06 W=1e-05 AD=8.5e-12 AS=8.5e-12 PD=1.17e-05 PS=1.17e-05 NRD=0.0425 NRS=0.0425 $X=91525 $Y=245875 $D=42
M38 VDDA VDDA VDDA VDDA pmos4 L=1e-05 W=5e-06 AD=4.25e-12 AS=4.25e-12 PD=6.7e-06 PS=6.7e-06 NRD=0.085 NRS=0.085 $X=95425 $Y=289850 $D=42
M39 VDDA VDDA VDDA VDDA pmos4 L=1e-05 W=5e-06 AD=4.25e-12 AS=4.25e-12 PD=6.7e-06 PS=6.7e-06 NRD=0.085 NRS=0.085 $X=95425 $Y=416750 $D=42
M40 VDDA VDDA VDDA VDDA pmos4 L=1e-05 W=5e-06 AD=4.25e-12 AS=4.25e-12 PD=6.7e-06 PS=6.7e-06 NRD=0.085 NRS=0.085 $X=107725 $Y=289850 $D=42
M41 VDDA VDDA VDDA VDDA pmos4 L=1e-05 W=5e-06 AD=4.25e-12 AS=4.25e-12 PD=6.7e-06 PS=6.7e-06 NRD=0.085 NRS=0.085 $X=107725 $Y=416750 $D=42
M42 VDDA VDDA VDDA VDDA pmos4 L=1e-05 W=5e-06 AD=4.25e-12 AS=4.25e-12 PD=6.7e-06 PS=6.7e-06 NRD=0.085 NRS=0.085 $X=120025 $Y=289850 $D=42
M43 VDDA VDDA VDDA VDDA pmos4 L=1e-05 W=5e-06 AD=4.25e-12 AS=4.25e-12 PD=6.7e-06 PS=6.7e-06 NRD=0.085 NRS=0.085 $X=120025 $Y=416750 $D=42
M44 VDDA VDDA VDDA VDDA pmos4 L=1e-05 W=5e-06 AD=4.25e-12 AS=4.25e-12 PD=6.7e-06 PS=6.7e-06 NRD=0.085 NRS=0.085 $X=132325 $Y=289850 $D=42
M45 VDDA VDDA VDDA VDDA pmos4 L=1e-05 W=5e-06 AD=4.25e-12 AS=4.25e-12 PD=6.7e-06 PS=6.7e-06 NRD=0.085 NRS=0.085 $X=132325 $Y=416750 $D=42
M46 9 9 9 9 pmos4 L=2e-06 W=1e-05 AD=8.5e-12 AS=8.5e-12 PD=1.17e-05 PS=1.17e-05 NRD=0.0425 NRS=0.0425 $X=181825 $Y=230125 $D=42
M47 9 9 9 9 pmos4 L=2e-06 W=1e-05 AD=8.5e-12 AS=8.5e-12 PD=1.17e-05 PS=1.17e-05 NRD=0.0425 NRS=0.0425 $X=181825 $Y=245875 $D=42
M48 16 16 16 16 pmos4 L=3.5e-07 W=1e-05 AD=8.5e-12 AS=8.5e-12 PD=1.17e-05 PS=1.17e-05 NRD=0.0425 NRS=0.0425 $X=192975 $Y=357300 $D=42
M49 16 16 16 16 pmos4 L=3.5e-07 W=1e-05 AD=8.5e-12 AS=8.5e-12 PD=1.17e-05 PS=1.17e-05 NRD=0.0425 NRS=0.0425 $X=192975 $Y=373450 $D=42
M50 VDDA VDDA VDDA VDDA pmos4 L=1e-05 W=5e-06 AD=4.25e-12 AS=4.25e-12 PD=6.7e-06 PS=6.7e-06 NRD=0.085 NRS=0.085 $X=194575 $Y=411350 $D=42
M51 VDDA VDDA VDDA VDDA pmos4 L=1e-05 W=5e-06 AD=4.25e-12 AS=4.25e-12 PD=6.7e-06 PS=6.7e-06 NRD=0.085 NRS=0.085 $X=194575 $Y=421650 $D=42
M52 16 16 16 16 pmos4 L=3.5e-07 W=1e-05 AD=8.5e-12 AS=8.5e-12 PD=1.17e-05 PS=1.17e-05 NRD=0.0425 NRS=0.0425 $X=200925 $Y=357300 $D=42
M53 16 16 16 16 pmos4 L=3.5e-07 W=1e-05 AD=8.5e-12 AS=8.5e-12 PD=1.17e-05 PS=1.17e-05 NRD=0.0425 NRS=0.0425 $X=200925 $Y=373450 $D=42
M54 VDDA VDDA VDDA VDDA pmos4 L=1e-05 W=5e-06 AD=4.25e-12 AS=4.25e-12 PD=6.7e-06 PS=6.7e-06 NRD=0.085 NRS=0.085 $X=256075 $Y=411350 $D=42
M55 VDDA VDDA VDDA VDDA pmos4 L=1e-05 W=5e-06 AD=4.25e-12 AS=4.25e-12 PD=6.7e-06 PS=6.7e-06 NRD=0.085 NRS=0.085 $X=256075 $Y=421650 $D=42
M56 1 8 VDDA VDDA pmos4 L=1e-05 W=5e-06 AD=4.25e-12 AS=4.25e-12 PD=6.7e-06 PS=6.7e-06 NRD=0.085 NRS=0.085 $X=33925 $Y=303950 $D=41
M57 1 8 VDDA VDDA pmos4 L=1e-05 W=5e-06 AD=4.25e-12 AS=4.25e-12 PD=6.7e-06 PS=6.7e-06 NRD=0.085 NRS=0.085 $X=33925 $Y=318050 $D=41
M58 1 8 VDDA VDDA pmos4 L=1e-05 W=5e-06 AD=4.25e-12 AS=4.25e-12 PD=6.7e-06 PS=6.7e-06 NRD=0.085 NRS=0.085 $X=33925 $Y=332150 $D=41
M59 1 8 VDDA VDDA pmos4 L=1e-05 W=5e-06 AD=4.25e-12 AS=4.25e-12 PD=6.7e-06 PS=6.7e-06 NRD=0.085 NRS=0.085 $X=33925 $Y=346250 $D=41
M60 1 8 VDDA VDDA pmos4 L=1e-05 W=5e-06 AD=4.25e-12 AS=4.25e-12 PD=6.7e-06 PS=6.7e-06 NRD=0.085 NRS=0.085 $X=33925 $Y=360350 $D=41
M61 1 8 VDDA VDDA pmos4 L=1e-05 W=5e-06 AD=4.25e-12 AS=4.25e-12 PD=6.7e-06 PS=6.7e-06 NRD=0.085 NRS=0.085 $X=33925 $Y=374450 $D=41
M62 1 8 VDDA VDDA pmos4 L=1e-05 W=5e-06 AD=4.25e-12 AS=4.25e-12 PD=6.7e-06 PS=6.7e-06 NRD=0.085 NRS=0.085 $X=33925 $Y=388550 $D=41
M63 1 8 VDDA VDDA pmos4 L=1e-05 W=5e-06 AD=4.25e-12 AS=4.25e-12 PD=6.7e-06 PS=6.7e-06 NRD=0.085 NRS=0.085 $X=33925 $Y=402650 $D=41
M64 1 8 VDDA VDDA pmos4 L=1e-05 W=5e-06 AD=4.25e-12 AS=4.25e-12 PD=6.7e-06 PS=6.7e-06 NRD=0.085 NRS=0.085 $X=46225 $Y=303950 $D=41
M65 1 8 VDDA VDDA pmos4 L=1e-05 W=5e-06 AD=4.25e-12 AS=4.25e-12 PD=6.7e-06 PS=6.7e-06 NRD=0.085 NRS=0.085 $X=46225 $Y=318050 $D=41
M66 1 8 VDDA VDDA pmos4 L=1e-05 W=5e-06 AD=4.25e-12 AS=4.25e-12 PD=6.7e-06 PS=6.7e-06 NRD=0.085 NRS=0.085 $X=46225 $Y=332150 $D=41
M67 9 8 VDDA VDDA pmos4 L=1e-05 W=5e-06 AD=4.25e-12 AS=4.25e-12 PD=6.7e-06 PS=6.7e-06 NRD=0.085 NRS=0.085 $X=46225 $Y=346250 $D=41
M68 9 8 VDDA VDDA pmos4 L=1e-05 W=5e-06 AD=4.25e-12 AS=4.25e-12 PD=6.7e-06 PS=6.7e-06 NRD=0.085 NRS=0.085 $X=46225 $Y=360350 $D=41
M69 1 8 VDDA VDDA pmos4 L=1e-05 W=5e-06 AD=4.25e-12 AS=4.25e-12 PD=6.7e-06 PS=6.7e-06 NRD=0.085 NRS=0.085 $X=46225 $Y=374450 $D=41
M70 1 8 VDDA VDDA pmos4 L=1e-05 W=5e-06 AD=4.25e-12 AS=4.25e-12 PD=6.7e-06 PS=6.7e-06 NRD=0.085 NRS=0.085 $X=46225 $Y=388550 $D=41
M71 1 8 VDDA VDDA pmos4 L=1e-05 W=5e-06 AD=4.25e-12 AS=4.25e-12 PD=6.7e-06 PS=6.7e-06 NRD=0.085 NRS=0.085 $X=46225 $Y=402650 $D=41
M72 1 8 VDDA VDDA pmos4 L=1e-05 W=5e-06 AD=4.25e-12 AS=4.25e-12 PD=6.7e-06 PS=6.7e-06 NRD=0.085 NRS=0.085 $X=58525 $Y=303950 $D=41
M73 1 8 VDDA VDDA pmos4 L=1e-05 W=5e-06 AD=4.25e-12 AS=4.25e-12 PD=6.7e-06 PS=6.7e-06 NRD=0.085 NRS=0.085 $X=58525 $Y=318050 $D=41
M74 1 8 VDDA VDDA pmos4 L=1e-05 W=5e-06 AD=4.25e-12 AS=4.25e-12 PD=6.7e-06 PS=6.7e-06 NRD=0.085 NRS=0.085 $X=58525 $Y=332150 $D=41
M75 9 8 VDDA VDDA pmos4 L=1e-05 W=5e-06 AD=4.25e-12 AS=4.25e-12 PD=6.7e-06 PS=6.7e-06 NRD=0.085 NRS=0.085 $X=58525 $Y=346250 $D=41
M76 9 8 VDDA VDDA pmos4 L=1e-05 W=5e-06 AD=4.25e-12 AS=4.25e-12 PD=6.7e-06 PS=6.7e-06 NRD=0.085 NRS=0.085 $X=58525 $Y=360350 $D=41
M77 1 8 VDDA VDDA pmos4 L=1e-05 W=5e-06 AD=4.25e-12 AS=4.25e-12 PD=6.7e-06 PS=6.7e-06 NRD=0.085 NRS=0.085 $X=58525 $Y=374450 $D=41
M78 1 8 VDDA VDDA pmos4 L=1e-05 W=5e-06 AD=4.25e-12 AS=4.25e-12 PD=6.7e-06 PS=6.7e-06 NRD=0.085 NRS=0.085 $X=58525 $Y=388550 $D=41
M79 1 8 VDDA VDDA pmos4 L=1e-05 W=5e-06 AD=4.25e-12 AS=4.25e-12 PD=6.7e-06 PS=6.7e-06 NRD=0.085 NRS=0.085 $X=58525 $Y=402650 $D=41
M80 1 8 VDDA VDDA pmos4 L=1e-05 W=5e-06 AD=4.25e-12 AS=4.25e-12 PD=6.7e-06 PS=6.7e-06 NRD=0.085 NRS=0.085 $X=70825 $Y=303950 $D=41
M81 1 8 VDDA VDDA pmos4 L=1e-05 W=5e-06 AD=4.25e-12 AS=4.25e-12 PD=6.7e-06 PS=6.7e-06 NRD=0.085 NRS=0.085 $X=70825 $Y=318050 $D=41
M82 9 8 VDDA VDDA pmos4 L=1e-05 W=5e-06 AD=4.25e-12 AS=4.25e-12 PD=6.7e-06 PS=6.7e-06 NRD=0.085 NRS=0.085 $X=70825 $Y=332150 $D=41
M83 9 8 VDDA VDDA pmos4 L=1e-05 W=5e-06 AD=4.25e-12 AS=4.25e-12 PD=6.7e-06 PS=6.7e-06 NRD=0.085 NRS=0.085 $X=70825 $Y=346250 $D=41
M84 9 8 VDDA VDDA pmos4 L=1e-05 W=5e-06 AD=4.25e-12 AS=4.25e-12 PD=6.7e-06 PS=6.7e-06 NRD=0.085 NRS=0.085 $X=70825 $Y=360350 $D=41
M85 9 8 VDDA VDDA pmos4 L=1e-05 W=5e-06 AD=4.25e-12 AS=4.25e-12 PD=6.7e-06 PS=6.7e-06 NRD=0.085 NRS=0.085 $X=70825 $Y=374450 $D=41
M86 1 8 VDDA VDDA pmos4 L=1e-05 W=5e-06 AD=4.25e-12 AS=4.25e-12 PD=6.7e-06 PS=6.7e-06 NRD=0.085 NRS=0.085 $X=70825 $Y=388550 $D=41
M87 1 8 VDDA VDDA pmos4 L=1e-05 W=5e-06 AD=4.25e-12 AS=4.25e-12 PD=6.7e-06 PS=6.7e-06 NRD=0.085 NRS=0.085 $X=70825 $Y=402650 $D=41
M88 1 8 VDDA VDDA pmos4 L=1e-05 W=5e-06 AD=4.25e-12 AS=4.25e-12 PD=6.7e-06 PS=6.7e-06 NRD=0.085 NRS=0.085 $X=83125 $Y=303950 $D=41
M89 9 8 VDDA VDDA pmos4 L=1e-05 W=5e-06 AD=4.25e-12 AS=4.25e-12 PD=6.7e-06 PS=6.7e-06 NRD=0.085 NRS=0.085 $X=83125 $Y=318050 $D=41
M90 9 8 VDDA VDDA pmos4 L=1e-05 W=5e-06 AD=4.25e-12 AS=4.25e-12 PD=6.7e-06 PS=6.7e-06 NRD=0.085 NRS=0.085 $X=83125 $Y=332150 $D=41
M91 8 8 VDDA VDDA pmos4 L=1e-05 W=5e-06 AD=4.25e-12 AS=4.25e-12 PD=6.7e-06 PS=6.7e-06 NRD=0.085 NRS=0.085 $X=83125 $Y=346250 $D=41
M92 8 8 VDDA VDDA pmos4 L=1e-05 W=5e-06 AD=4.25e-12 AS=4.25e-12 PD=6.7e-06 PS=6.7e-06 NRD=0.085 NRS=0.085 $X=83125 $Y=360350 $D=41
M93 9 8 VDDA VDDA pmos4 L=1e-05 W=5e-06 AD=4.25e-12 AS=4.25e-12 PD=6.7e-06 PS=6.7e-06 NRD=0.085 NRS=0.085 $X=83125 $Y=374450 $D=41
M94 9 8 VDDA VDDA pmos4 L=1e-05 W=5e-06 AD=4.25e-12 AS=4.25e-12 PD=6.7e-06 PS=6.7e-06 NRD=0.085 NRS=0.085 $X=83125 $Y=388550 $D=41
M95 1 8 VDDA VDDA pmos4 L=1e-05 W=5e-06 AD=4.25e-12 AS=4.25e-12 PD=6.7e-06 PS=6.7e-06 NRD=0.085 NRS=0.085 $X=83125 $Y=402650 $D=41
M96 1 8 VDDA VDDA pmos4 L=1e-05 W=5e-06 AD=4.25e-12 AS=4.25e-12 PD=6.7e-06 PS=6.7e-06 NRD=0.085 NRS=0.085 $X=95425 $Y=303950 $D=41
M97 1 8 VDDA VDDA pmos4 L=1e-05 W=5e-06 AD=4.25e-12 AS=4.25e-12 PD=6.7e-06 PS=6.7e-06 NRD=0.085 NRS=0.085 $X=95425 $Y=318050 $D=41
M98 9 8 VDDA VDDA pmos4 L=1e-05 W=5e-06 AD=4.25e-12 AS=4.25e-12 PD=6.7e-06 PS=6.7e-06 NRD=0.085 NRS=0.085 $X=95425 $Y=332150 $D=41
M99 9 8 VDDA VDDA pmos4 L=1e-05 W=5e-06 AD=4.25e-12 AS=4.25e-12 PD=6.7e-06 PS=6.7e-06 NRD=0.085 NRS=0.085 $X=95425 $Y=346250 $D=41
M100 9 8 VDDA VDDA pmos4 L=1e-05 W=5e-06 AD=4.25e-12 AS=4.25e-12 PD=6.7e-06 PS=6.7e-06 NRD=0.085 NRS=0.085 $X=95425 $Y=360350 $D=41
M101 9 8 VDDA VDDA pmos4 L=1e-05 W=5e-06 AD=4.25e-12 AS=4.25e-12 PD=6.7e-06 PS=6.7e-06 NRD=0.085 NRS=0.085 $X=95425 $Y=374450 $D=41
M102 1 8 VDDA VDDA pmos4 L=1e-05 W=5e-06 AD=4.25e-12 AS=4.25e-12 PD=6.7e-06 PS=6.7e-06 NRD=0.085 NRS=0.085 $X=95425 $Y=388550 $D=41
M103 1 8 VDDA VDDA pmos4 L=1e-05 W=5e-06 AD=4.25e-12 AS=4.25e-12 PD=6.7e-06 PS=6.7e-06 NRD=0.085 NRS=0.085 $X=95425 $Y=402650 $D=41
M104 1 8 VDDA VDDA pmos4 L=1e-05 W=5e-06 AD=4.25e-12 AS=4.25e-12 PD=6.7e-06 PS=6.7e-06 NRD=0.085 NRS=0.085 $X=107725 $Y=303950 $D=41
M105 1 8 VDDA VDDA pmos4 L=1e-05 W=5e-06 AD=4.25e-12 AS=4.25e-12 PD=6.7e-06 PS=6.7e-06 NRD=0.085 NRS=0.085 $X=107725 $Y=318050 $D=41
M106 1 8 VDDA VDDA pmos4 L=1e-05 W=5e-06 AD=4.25e-12 AS=4.25e-12 PD=6.7e-06 PS=6.7e-06 NRD=0.085 NRS=0.085 $X=107725 $Y=332150 $D=41
M107 9 8 VDDA VDDA pmos4 L=1e-05 W=5e-06 AD=4.25e-12 AS=4.25e-12 PD=6.7e-06 PS=6.7e-06 NRD=0.085 NRS=0.085 $X=107725 $Y=346250 $D=41
M108 9 8 VDDA VDDA pmos4 L=1e-05 W=5e-06 AD=4.25e-12 AS=4.25e-12 PD=6.7e-06 PS=6.7e-06 NRD=0.085 NRS=0.085 $X=107725 $Y=360350 $D=41
M109 1 8 VDDA VDDA pmos4 L=1e-05 W=5e-06 AD=4.25e-12 AS=4.25e-12 PD=6.7e-06 PS=6.7e-06 NRD=0.085 NRS=0.085 $X=107725 $Y=374450 $D=41
M110 1 8 VDDA VDDA pmos4 L=1e-05 W=5e-06 AD=4.25e-12 AS=4.25e-12 PD=6.7e-06 PS=6.7e-06 NRD=0.085 NRS=0.085 $X=107725 $Y=388550 $D=41
M111 1 8 VDDA VDDA pmos4 L=1e-05 W=5e-06 AD=4.25e-12 AS=4.25e-12 PD=6.7e-06 PS=6.7e-06 NRD=0.085 NRS=0.085 $X=107725 $Y=402650 $D=41
M112 1 8 VDDA VDDA pmos4 L=1e-05 W=5e-06 AD=4.25e-12 AS=4.25e-12 PD=6.7e-06 PS=6.7e-06 NRD=0.085 NRS=0.085 $X=120025 $Y=303950 $D=41
M113 1 8 VDDA VDDA pmos4 L=1e-05 W=5e-06 AD=4.25e-12 AS=4.25e-12 PD=6.7e-06 PS=6.7e-06 NRD=0.085 NRS=0.085 $X=120025 $Y=318050 $D=41
M114 1 8 VDDA VDDA pmos4 L=1e-05 W=5e-06 AD=4.25e-12 AS=4.25e-12 PD=6.7e-06 PS=6.7e-06 NRD=0.085 NRS=0.085 $X=120025 $Y=332150 $D=41
M115 9 8 VDDA VDDA pmos4 L=1e-05 W=5e-06 AD=4.25e-12 AS=4.25e-12 PD=6.7e-06 PS=6.7e-06 NRD=0.085 NRS=0.085 $X=120025 $Y=346250 $D=41
M116 9 8 VDDA VDDA pmos4 L=1e-05 W=5e-06 AD=4.25e-12 AS=4.25e-12 PD=6.7e-06 PS=6.7e-06 NRD=0.085 NRS=0.085 $X=120025 $Y=360350 $D=41
M117 1 8 VDDA VDDA pmos4 L=1e-05 W=5e-06 AD=4.25e-12 AS=4.25e-12 PD=6.7e-06 PS=6.7e-06 NRD=0.085 NRS=0.085 $X=120025 $Y=374450 $D=41
M118 1 8 VDDA VDDA pmos4 L=1e-05 W=5e-06 AD=4.25e-12 AS=4.25e-12 PD=6.7e-06 PS=6.7e-06 NRD=0.085 NRS=0.085 $X=120025 $Y=388550 $D=41
M119 1 8 VDDA VDDA pmos4 L=1e-05 W=5e-06 AD=4.25e-12 AS=4.25e-12 PD=6.7e-06 PS=6.7e-06 NRD=0.085 NRS=0.085 $X=120025 $Y=402650 $D=41
M120 9 17 10 9 pmos4 L=2e-06 W=1e-05 AD=8.5e-12 AS=8.5e-12 PD=1.17e-05 PS=1.17e-05 NRD=0.0425 NRS=0.0425 $X=125925 $Y=230125 $D=41
M121 9 4 11 9 pmos4 L=2e-06 W=1e-05 AD=8.5e-12 AS=8.5e-12 PD=1.17e-05 PS=1.17e-05 NRD=0.0425 NRS=0.0425 $X=125925 $Y=245875 $D=41
M122 1 8 VDDA VDDA pmos4 L=1e-05 W=5e-06 AD=4.25e-12 AS=4.25e-12 PD=6.7e-06 PS=6.7e-06 NRD=0.085 NRS=0.085 $X=132325 $Y=303950 $D=41
M123 1 8 VDDA VDDA pmos4 L=1e-05 W=5e-06 AD=4.25e-12 AS=4.25e-12 PD=6.7e-06 PS=6.7e-06 NRD=0.085 NRS=0.085 $X=132325 $Y=318050 $D=41
M124 1 8 VDDA VDDA pmos4 L=1e-05 W=5e-06 AD=4.25e-12 AS=4.25e-12 PD=6.7e-06 PS=6.7e-06 NRD=0.085 NRS=0.085 $X=132325 $Y=332150 $D=41
M125 1 8 VDDA VDDA pmos4 L=1e-05 W=5e-06 AD=4.25e-12 AS=4.25e-12 PD=6.7e-06 PS=6.7e-06 NRD=0.085 NRS=0.085 $X=132325 $Y=346250 $D=41
M126 1 8 VDDA VDDA pmos4 L=1e-05 W=5e-06 AD=4.25e-12 AS=4.25e-12 PD=6.7e-06 PS=6.7e-06 NRD=0.085 NRS=0.085 $X=132325 $Y=360350 $D=41
M127 1 8 VDDA VDDA pmos4 L=1e-05 W=5e-06 AD=4.25e-12 AS=4.25e-12 PD=6.7e-06 PS=6.7e-06 NRD=0.085 NRS=0.085 $X=132325 $Y=374450 $D=41
M128 1 8 VDDA VDDA pmos4 L=1e-05 W=5e-06 AD=4.25e-12 AS=4.25e-12 PD=6.7e-06 PS=6.7e-06 NRD=0.085 NRS=0.085 $X=132325 $Y=388550 $D=41
M129 1 8 VDDA VDDA pmos4 L=1e-05 W=5e-06 AD=4.25e-12 AS=4.25e-12 PD=6.7e-06 PS=6.7e-06 NRD=0.085 NRS=0.085 $X=132325 $Y=402650 $D=41
M130 9 17 10 9 pmos4 L=2e-06 W=1e-05 AD=8.5e-12 AS=8.5e-12 PD=1.17e-05 PS=1.17e-05 NRD=0.0425 NRS=0.0425 $X=160325 $Y=230125 $D=41
M131 9 4 11 9 pmos4 L=2e-06 W=1e-05 AD=8.5e-12 AS=8.5e-12 PD=1.17e-05 PS=1.17e-05 NRD=0.0425 NRS=0.0425 $X=160325 $Y=245875 $D=41
M132 9 17 10 9 pmos4 L=2e-06 W=1e-05 AD=8.5e-12 AS=8.5e-12 PD=1.17e-05 PS=1.17e-05 NRD=0.0425 NRS=0.0425 $X=177525 $Y=230125 $D=41
M133 9 4 11 9 pmos4 L=2e-06 W=1e-05 AD=8.5e-12 AS=8.5e-12 PD=1.17e-05 PS=1.17e-05 NRD=0.0425 NRS=0.0425 $X=177525 $Y=245875 $D=41
M134 16 14 13 16 pmos4 L=3.5e-07 W=1e-05 AD=8.5e-12 AS=8.5e-12 PD=1.17e-05 PS=1.17e-05 NRD=0.0425 NRS=0.0425 $X=195625 $Y=357300 $D=41
M135 16 1 15 16 pmos4 L=3.5e-07 W=1e-05 AD=8.5e-12 AS=8.5e-12 PD=1.17e-05 PS=1.17e-05 NRD=0.0425 NRS=0.0425 $X=195625 $Y=373450 $D=41
M136 16 1 15 16 pmos4 L=3.5e-07 W=1e-05 AD=8.5e-12 AS=8.5e-12 PD=1.17e-05 PS=1.17e-05 NRD=0.0425 NRS=0.0425 $X=198275 $Y=357300 $D=41
M137 16 14 13 16 pmos4 L=3.5e-07 W=1e-05 AD=8.5e-12 AS=8.5e-12 PD=1.17e-05 PS=1.17e-05 NRD=0.0425 NRS=0.0425 $X=198275 $Y=373450 $D=41
M138 18 18 VDDA VDDA pmos4 L=1e-05 W=5e-06 AD=4.25e-12 AS=4.25e-12 PD=6.7e-06 PS=6.7e-06 NRD=0.085 NRS=0.085 $X=206875 $Y=411350 $D=41
M139 16 18 VDDA VDDA pmos4 L=1e-05 W=5e-06 AD=4.25e-12 AS=4.25e-12 PD=6.7e-06 PS=6.7e-06 NRD=0.085 NRS=0.085 $X=206875 $Y=421650 $D=41
M140 12 18 VDDA VDDA pmos4 L=1e-05 W=5e-06 AD=4.25e-12 AS=4.25e-12 PD=6.7e-06 PS=6.7e-06 NRD=0.085 NRS=0.085 $X=219175 $Y=411350 $D=41
M141 14 18 VDDA VDDA pmos4 L=1e-05 W=5e-06 AD=4.25e-12 AS=4.25e-12 PD=6.7e-06 PS=6.7e-06 NRD=0.085 NRS=0.085 $X=219175 $Y=421650 $D=41
M142 14 18 VDDA VDDA pmos4 L=1e-05 W=5e-06 AD=4.25e-12 AS=4.25e-12 PD=6.7e-06 PS=6.7e-06 NRD=0.085 NRS=0.085 $X=231475 $Y=411350 $D=41
M143 12 18 VDDA VDDA pmos4 L=1e-05 W=5e-06 AD=4.25e-12 AS=4.25e-12 PD=6.7e-06 PS=6.7e-06 NRD=0.085 NRS=0.085 $X=231475 $Y=421650 $D=41
M144 16 18 VDDA VDDA pmos4 L=1e-05 W=5e-06 AD=4.25e-12 AS=4.25e-12 PD=6.7e-06 PS=6.7e-06 NRD=0.085 NRS=0.085 $X=243775 $Y=411350 $D=41
M145 18 18 VDDA VDDA pmos4 L=1e-05 W=5e-06 AD=4.25e-12 AS=4.25e-12 PD=6.7e-06 PS=6.7e-06 NRD=0.085 NRS=0.085 $X=243775 $Y=421650 $D=41
X184 GNDA Ibias cvar_CDNS_7804141697221 $T=23900 210975 1 180 $X=-875 $Y=209425
X187 1 11 cpolyc_CDNS_780414169727 $T=231950 305750 0 0 $X=230600 $Y=304400
X188 GNDA V_ptat_inv VDDA 12 22 vref 6_CA_Front_Layout $T=494550 210300 0 0 $X=493400 $Y=212098
X189 V_ptat_inv 22 cpolyc_CDNS_7804141697219 $T=910250 268750 1 0 $X=908900 $Y=217750
X190 V_ptat_inv 22 cpolyc_CDNS_7804141697219 $T=910250 322100 1 0 $X=908900 $Y=271100
X191 V_ptat_inv 22 cpolyc_CDNS_7804141697219 $T=910250 375450 1 0 $X=908900 $Y=324450
X192 V_ptat_inv 22 cpolyc_CDNS_7804141697219 $T=910250 428800 1 0 $X=908900 $Y=377800
X193 V_ptat_inv 22 ICV_20 $T=690650 268750 1 0 $X=689300 $Y=217750
X194 V_ptat_inv 22 ICV_20 $T=690650 322100 1 0 $X=689300 $Y=271100
X195 V_ptat_inv 22 ICV_20 $T=690650 375450 1 0 $X=689300 $Y=324450
X196 V_ptat_inv 22 ICV_20 $T=690650 428800 1 0 $X=689300 $Y=377800
X197 V_ptat_inv 22 ICV_20 $T=800450 268750 1 0 $X=799100 $Y=217750
X198 V_ptat_inv 22 ICV_20 $T=800450 322100 1 0 $X=799100 $Y=271100
X199 V_ptat_inv 22 ICV_20 $T=800450 375450 1 0 $X=799100 $Y=324450
X200 V_ptat_inv 22 ICV_20 $T=800450 428800 1 0 $X=799100 $Y=377800
X201 31 32 rpolyhc_CDNS_780414169720 $T=410925 225325 0 270 $X=406275 $Y=216075
X202 30 31 rpolyhc_CDNS_780414169720 $T=410925 234575 0 270 $X=406275 $Y=225325
X203 22 30 rpolyhc_CDNS_780414169720 $T=427225 240575 0 90 $X=406275 $Y=234575
X204 32 33 rpolyhc_CDNS_780414169720 $T=430525 222075 1 90 $X=425875 $Y=216075
X205 22 1 rpolyhc_CDNS_780414169720 $T=430525 234575 0 270 $X=425875 $Y=225325
X206 34 V_ptat_inv rpolyhc_CDNS_780414169720 $T=446825 240575 0 90 $X=425875 $Y=234575
X207 33 36 rpolyhc_CDNS_780414169720 $T=450125 225325 0 270 $X=445475 $Y=216075
X208 36 35 rpolyhc_CDNS_780414169720 $T=466425 231325 0 90 $X=445475 $Y=225325
X209 35 34 rpolyhc_CDNS_780414169720 $T=466425 240575 0 90 $X=445475 $Y=234575
X210 GNDA GNDA GNDA ICV_23 $T=327250 267200 0 0 $X=327250 $Y=267200
X211 GNDA 21 21 ICV_23 $T=327250 285900 0 0 $X=327250 $Y=285900
X212 GNDA 21 21 ICV_23 $T=327250 304600 0 0 $X=327250 $Y=304600
X213 GNDA 21 21 ICV_23 $T=327250 323300 0 0 $X=327250 $Y=323300
X214 GNDA 21 4 ICV_23 $T=327250 342000 0 0 $X=327250 $Y=342000
X215 GNDA 21 21 ICV_23 $T=327250 360700 0 0 $X=327250 $Y=360700
X216 GNDA 21 21 ICV_23 $T=327250 379400 0 0 $X=327250 $Y=379400
X217 GNDA 21 21 ICV_23 $T=327250 398100 0 0 $X=327250 $Y=398100
X218 GNDA GNDA GNDA ICV_23 $T=327250 416800 0 0 $X=327250 $Y=416800
X219 GNDA VDDA cvar_CDNS_7804141697220 $T=299875 306150 0 0 $X=297600 $Y=304600
X220 GNDA VDDA cvar_CDNS_7804141697222 $T=293275 375450 0 0 $X=291000 $Y=373900
X221 28 23 rpolyhc_CDNS_780414169721 $T=239825 219600 0 90 $X=204575 $Y=211850
X222 23 25 rpolyhc_CDNS_780414169721 $T=210325 240350 1 90 $X=204575 $Y=232600
X223 20 24 rpolyhc_CDNS_780414169721 $T=239825 261100 0 90 $X=204575 $Y=253350
X224 24 1 rpolyhc_CDNS_780414169721 $T=210325 281850 1 90 $X=204575 $Y=274100
X225 17 27 rpolyhc_CDNS_780414169721 $T=245325 219600 1 90 $X=239575 $Y=211850
X226 21 17 rpolyhc_CDNS_780414169721 $T=274825 251600 1 270 $X=239575 $Y=232600
X227 21 17 rpolyhc_CDNS_780414169721 $T=274825 272350 1 270 $X=239575 $Y=253350
X228 25 26 rpolyhc_CDNS_780414169721 $T=245325 281850 1 90 $X=239575 $Y=274100
X229 4 28 rpolyhc_CDNS_780414169721 $T=309825 230850 1 270 $X=274575 $Y=211850
X230 27 29 rpolyhc_CDNS_780414169721 $T=280325 240350 1 90 $X=274575 $Y=232600
X231 29 20 rpolyhc_CDNS_780414169721 $T=309825 272350 1 270 $X=274575 $Y=253350
X232 26 1 rpolyhc_CDNS_780414169721 $T=280325 281850 1 90 $X=274575 $Y=274100
X243 GNDA VDDA cvar_CDNS_7804141697223 $T=279350 376350 0 90 $X=230200 $Y=374075
X244 GNDA 15 15 nmos4_CDNS_7804141697215 $T=202875 314150 0 90 $X=190925 $Y=313750
X245 GNDA 13 15 nmos4_CDNS_7804141697215 $T=202875 326950 0 90 $X=190925 $Y=326550
X246 GNDA 13 15 nmos4_CDNS_7804141697215 $T=215675 314150 0 90 $X=203725 $Y=313750
X247 GNDA 15 15 nmos4_CDNS_7804141697215 $T=215675 326950 0 90 $X=203725 $Y=326550
X261 9 11 10 4 17 ICV_27 $T=163175 230125 0 90 $X=158275 $Y=228925
X262 9 10 11 17 4 ICV_27 $T=163175 245875 0 90 $X=158275 $Y=244675
X335 9 11 10 4 17 ICV_28 $T=94375 230125 0 90 $X=89475 $Y=228925
X336 9 10 11 17 4 ICV_28 $T=94375 245875 0 90 $X=89475 $Y=244675
X337 9 11 10 4 17 ICV_28 $T=128775 230125 0 90 $X=123875 $Y=228925
X338 9 10 11 17 4 ICV_28 $T=128775 245875 0 90 $X=123875 $Y=244675
X354 VDDA ICV_30 $T=20775 294850 0 270 $X=19575 $Y=288650
X355 VDDA ICV_30 $T=20775 308950 0 270 $X=19575 $Y=302750
X356 VDDA ICV_30 $T=20775 323050 0 270 $X=19575 $Y=316850
X357 VDDA ICV_30 $T=20775 337150 0 270 $X=19575 $Y=330950
X358 VDDA ICV_30 $T=20775 351250 0 270 $X=19575 $Y=345050
X359 VDDA ICV_30 $T=20775 365350 0 270 $X=19575 $Y=359150
X360 VDDA ICV_30 $T=20775 379450 0 270 $X=19575 $Y=373250
X361 VDDA ICV_30 $T=20775 393550 0 270 $X=19575 $Y=387350
X362 VDDA ICV_30 $T=20775 407650 0 270 $X=19575 $Y=401450
X363 VDDA ICV_30 $T=20775 421750 0 270 $X=19575 $Y=415550
.ENDS
***************************************
.SUBCKT 8_Poten_PTAT VDDA CE RE Ib8 EN_100mV v1500 Calib_i_cur V_EC S<0> S<3> S<2> Calib_EN S<1> WE TIA_in Ib9 v1600 POT_OUT Ib10 VPI
+ GNDA
** N=23 EP=21 IP=26 FDC=1039
X0 VDDA CE RE EN_100mV v1500 V_EC S<0> S<3> S<2> Calib_EN S<1> WE Ib9 TIA_in v1600 POT_OUT Ib8 Calib_i_cur GNDA 8_CA_TIA_Front_calib $T=30500 25200 0 0 $X=37323 $Y=7448
X1 23 VDDA GNDA 20 VPI v1600 Ib10 7_PTAT_Layout $T=1073675 -166350 0 0 $X=1071175 $Y=37548
.ENDS
***************************************
