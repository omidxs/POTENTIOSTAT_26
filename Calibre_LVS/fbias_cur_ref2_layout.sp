* SPICE NETLIST
***************************************

.SUBCKT tsv80 TOP BOTTOM SUB
.ENDS
***************************************
.SUBCKT rx POS NEG
.ENDS
***************************************
.SUBCKT Q C B E S G
.ENDS
***************************************
.SUBCKT lddn D G S B
.ENDS
***************************************
.SUBCKT phd POS NEG P
.ENDS
***************************************
.SUBCKT sbd A C SUB
.ENDS
***************************************
.SUBCKT esddlv2 A C
.ENDS
***************************************
.SUBCKT esddlv A C SUB
.ENDS
***************************************
.SUBCKT lddp D G S B
.ENDS
***************************************
.SUBCKT probepad pad
.ENDS
***************************************
.SUBCKT L POS NEG SUB
.ENDS
***************************************
.SUBCKT L POS NEG MID SUB
.ENDS
***************************************
.SUBCKT hall A B C D S P1 P2
.ENDS
***************************************
.SUBCKT pmos4_CDNS_779828874973
** N=5 EP=0 IP=0 FDC=0
.ENDS
***************************************
.SUBCKT cvar_CDNS_779828874975 1 2 3
** N=3 EP=3 IP=0 FDC=2
M0 2 1 2 3 cvar w=0.00099 l=6.5e-07 cols=10 rows=15 $X=0 $Y=0 $D=62
D1 3 2 p_nwd AREA=2171.6 PJ=279.6 $X=-300 $Y=-300 $D=87
.ENDS
***************************************
.SUBCKT ICV_1 3 4 5
** N=6 EP=3 IP=10 FDC=1
M0 4 5 3 3 pmos4 L=3e-05 W=1e-05 AD=8.5e-12 AS=8.5e-12 PD=1.17e-05 PS=1.17e-05 NRD=0.0425 NRS=0.0425 $X=11250 $Y=850 $D=41
.ENDS
***************************************
.SUBCKT pmos4_CDNS_779828874972
** N=5 EP=0 IP=0 FDC=0
.ENDS
***************************************
.SUBCKT ICV_2 3 4 5 7
** N=7 EP=4 IP=10 FDC=1
M0 4 5 3 7 pmos4 L=2e-06 W=5e-06 AD=4.25e-12 AS=4.25e-12 PD=6.7e-06 PS=6.7e-06 NRD=0.085 NRS=0.085 $X=6250 $Y=850 $D=41
.ENDS
***************************************
.SUBCKT ICV_3 3 4 5 6 7
** N=8 EP=5 IP=12 FDC=3
M0 5 7 3 3 pmos4 L=3e-05 W=1e-05 AD=8.5e-12 AS=8.5e-12 PD=1.17e-05 PS=1.17e-05 NRD=0.0425 NRS=0.0425 $X=22500 $Y=850 $D=41
X1 3 4 7 ICV_1 $T=0 0 0 0 $X=-1200 $Y=-1200
X2 3 6 7 ICV_1 $T=22500 0 0 0 $X=21300 $Y=-1200
.ENDS
***************************************
.SUBCKT pmos4_CDNS_779828874971 1 2 3 5
** N=5 EP=4 IP=0 FDC=1
M0 2 3 1 5 pmos4 L=1e-06 W=5e-06 AD=4.25e-12 AS=4.25e-12 PD=6.7e-06 PS=6.7e-06 NRD=0.085 NRS=0.085 $X=0 $Y=850 $D=41
.ENDS
***************************************
.SUBCKT nmos4_CDNS_779828874976
** N=4 EP=0 IP=0 FDC=0
.ENDS
***************************************
.SUBCKT ICV_4
** N=7 EP=0 IP=8 FDC=0
.ENDS
***************************************
.SUBCKT ICV_5 3 4 5 9 10 12
** N=12 EP=6 IP=14 FDC=2
M0 4 9 3 12 nmos4 L=1e-06 W=2.85e-05 AD=2.4225e-11 AS=2.4225e-11 PD=3.02e-05 PS=3.02e-05 NRD=0.0149123 NRS=0.0149123 $X=0 $Y=4150 $D=37
M1 5 10 3 12 nmos4 L=1e-06 W=2.85e-05 AD=2.4225e-11 AS=2.4225e-11 PD=3.02e-05 PS=3.02e-05 NRD=0.0149123 NRS=0.0149123 $X=0 $Y=7450 $D=37
.ENDS
***************************************
.SUBCKT pmos4_CDNS_779828874977
** N=5 EP=0 IP=0 FDC=0
.ENDS
***************************************
.SUBCKT ICV_6
** N=7 EP=0 IP=10 FDC=0
.ENDS
***************************************
.SUBCKT nmos4_CDNS_779828874970
** N=4 EP=0 IP=0 FDC=0
.ENDS
***************************************
.SUBCKT fbias_cur_ref2_layout VDDA GNDA OUT1 OUT2 OUT3 OUT4 OUT5 OUT6 OUT7 OUT8 OUT9 OUT10 OUT11 BIAS VRES VBG
** N=34 EP=16 IP=303 FDC=109
R0 2 7 L=3.025e-05 W=8e-07 $[rpolyh] $X=75450 $Y=124575 $D=18
D1 GNDA VDDA p_nwd AREA=169.219 PJ=53.25 $X=8775 $Y=187975 $D=87
D2 GNDA VDDA p_nwd AREA=9463.68 PJ=531.2 $X=16950 $Y=216800 $D=87
D3 GNDA VDDA p_nwd AREA=3702.2 PJ=258.6 $X=8300 $Y=138325 $D=87
D4 GNDA GNDA p_nwd AREA=352.17 PJ=78.9 $X=70700 $Y=117875 $D=87
D5 GNDA VDDA p_nwd AREA=86.1 PJ=37.4 $X=98700 $Y=165375 $D=87
D6 GNDA VDDA p_nwd AREA=943.28 PJ=202.2 $X=113250 $Y=164225 $D=87
M7 BIAS BIAS BIAS GNDA nmos4 L=1e-05 W=5e-06 AD=4.25e-12 AS=4.25e-12 PD=6.7e-06 PS=6.7e-06 NRD=0.085 NRS=0.085 $X=19950 $Y=117675 $D=38
M8 GNDA GNDA GNDA GNDA nmos4 L=1e-06 W=2.85e-05 AD=2.4225e-11 AS=2.4225e-11 PD=3.02e-05 PS=3.02e-05 NRD=0.0149123 NRS=0.0149123 $X=29700 $Y=29125 $D=38
M9 GNDA GNDA GNDA GNDA nmos4 L=1e-06 W=2.85e-05 AD=2.4225e-11 AS=2.4225e-11 PD=3.02e-05 PS=3.02e-05 NRD=0.0149123 NRS=0.0149123 $X=29700 $Y=65275 $D=38
M10 BIAS BIAS BIAS GNDA nmos4 L=1e-05 W=5e-06 AD=4.25e-12 AS=4.25e-12 PD=6.7e-06 PS=6.7e-06 NRD=0.085 NRS=0.085 $X=57450 $Y=117675 $D=38
M11 GNDA GNDA GNDA GNDA nmos4 L=1e-06 W=2.85e-05 AD=2.4225e-11 AS=2.4225e-11 PD=3.02e-05 PS=3.02e-05 NRD=0.0149123 NRS=0.0149123 $X=79200 $Y=29125 $D=38
M12 GNDA GNDA GNDA GNDA nmos4 L=1e-06 W=2.85e-05 AD=2.4225e-11 AS=2.4225e-11 PD=3.02e-05 PS=3.02e-05 NRD=0.0149123 NRS=0.0149123 $X=79200 $Y=65275 $D=38
M13 GNDA BIAS 6 GNDA nmos4 L=1e-05 W=5e-06 AD=4.25e-12 AS=4.25e-12 PD=6.7e-06 PS=6.7e-06 NRD=0.085 NRS=0.085 $X=26200 $Y=117675 $D=37
M14 GNDA BIAS BIAS GNDA nmos4 L=1e-05 W=5e-06 AD=4.25e-12 AS=4.25e-12 PD=6.7e-06 PS=6.7e-06 NRD=0.085 NRS=0.085 $X=32450 $Y=117675 $D=37
M15 GNDA BIAS 1 GNDA nmos4 L=1e-05 W=5e-06 AD=4.25e-12 AS=4.25e-12 PD=6.7e-06 PS=6.7e-06 NRD=0.085 NRS=0.085 $X=38700 $Y=117675 $D=37
M16 2 VBG 6 GNDA nmos4 L=1e-06 W=2.85e-05 AD=2.4225e-11 AS=2.4225e-11 PD=3.02e-05 PS=3.02e-05 NRD=0.0149123 NRS=0.0149123 $X=39600 $Y=29125 $D=37
M17 3 VRES 6 GNDA nmos4 L=1e-06 W=2.85e-05 AD=2.4225e-11 AS=2.4225e-11 PD=3.02e-05 PS=3.02e-05 NRD=0.0149123 NRS=0.0149123 $X=39600 $Y=65275 $D=37
M18 3 VRES 6 GNDA nmos4 L=1e-06 W=2.85e-05 AD=2.4225e-11 AS=2.4225e-11 PD=3.02e-05 PS=3.02e-05 NRD=0.0149123 NRS=0.0149123 $X=42900 $Y=29125 $D=37
M19 2 VBG 6 GNDA nmos4 L=1e-06 W=2.85e-05 AD=2.4225e-11 AS=2.4225e-11 PD=3.02e-05 PS=3.02e-05 NRD=0.0149123 NRS=0.0149123 $X=42900 $Y=65275 $D=37
M20 GNDA BIAS 6 GNDA nmos4 L=1e-05 W=5e-06 AD=4.25e-12 AS=4.25e-12 PD=6.7e-06 PS=6.7e-06 NRD=0.085 NRS=0.085 $X=44950 $Y=117675 $D=37
M21 GNDA BIAS BIAS GNDA nmos4 L=1e-05 W=5e-06 AD=4.25e-12 AS=4.25e-12 PD=6.7e-06 PS=6.7e-06 NRD=0.085 NRS=0.085 $X=51200 $Y=117675 $D=37
M22 2 VBG 6 GNDA nmos4 L=1e-06 W=2.85e-05 AD=2.4225e-11 AS=2.4225e-11 PD=3.02e-05 PS=3.02e-05 NRD=0.0149123 NRS=0.0149123 $X=52800 $Y=29125 $D=37
M23 3 VRES 6 GNDA nmos4 L=1e-06 W=2.85e-05 AD=2.4225e-11 AS=2.4225e-11 PD=3.02e-05 PS=3.02e-05 NRD=0.0149123 NRS=0.0149123 $X=52800 $Y=65275 $D=37
M24 3 VRES 6 GNDA nmos4 L=1e-06 W=2.85e-05 AD=2.4225e-11 AS=2.4225e-11 PD=3.02e-05 PS=3.02e-05 NRD=0.0149123 NRS=0.0149123 $X=56100 $Y=29125 $D=37
M25 2 VBG 6 GNDA nmos4 L=1e-06 W=2.85e-05 AD=2.4225e-11 AS=2.4225e-11 PD=3.02e-05 PS=3.02e-05 NRD=0.0149123 NRS=0.0149123 $X=56100 $Y=65275 $D=37
M26 2 VBG 6 GNDA nmos4 L=1e-06 W=2.85e-05 AD=2.4225e-11 AS=2.4225e-11 PD=3.02e-05 PS=3.02e-05 NRD=0.0149123 NRS=0.0149123 $X=66000 $Y=29125 $D=37
M27 3 VRES 6 GNDA nmos4 L=1e-06 W=2.85e-05 AD=2.4225e-11 AS=2.4225e-11 PD=3.02e-05 PS=3.02e-05 NRD=0.0149123 NRS=0.0149123 $X=66000 $Y=65275 $D=37
M28 3 VRES 6 GNDA nmos4 L=1e-06 W=2.85e-05 AD=2.4225e-11 AS=2.4225e-11 PD=3.02e-05 PS=3.02e-05 NRD=0.0149123 NRS=0.0149123 $X=69300 $Y=29125 $D=37
M29 2 VBG 6 GNDA nmos4 L=1e-06 W=2.85e-05 AD=2.4225e-11 AS=2.4225e-11 PD=3.02e-05 PS=3.02e-05 NRD=0.0149123 NRS=0.0149123 $X=69300 $Y=65275 $D=37
M30 2 2 2 VDDA pmos4 L=3e-05 W=1e-05 AD=8.5e-12 AS=8.5e-12 PD=1.17e-05 PS=1.17e-05 NRD=0.0425 NRS=0.0425 $X=22300 $Y=223000 $D=42
M31 3 3 3 VDDA pmos4 L=5e-06 W=8.35e-06 AD=7.0975e-12 AS=7.0975e-12 PD=1.005e-05 PS=1.005e-05 NRD=0.0508982 NRS=0.0508982 $X=23500 $Y=149675 $D=42
M32 3 3 3 VDDA pmos4 L=5e-06 W=8.35e-06 AD=7.0975e-12 AS=7.0975e-12 PD=1.005e-05 PS=1.005e-05 NRD=0.0508982 NRS=0.0508982 $X=23500 $Y=161425 $D=42
M33 3 3 3 VDDA pmos4 L=5e-06 W=8.35e-06 AD=7.0975e-12 AS=7.0975e-12 PD=1.005e-05 PS=1.005e-05 NRD=0.0508982 NRS=0.0508982 $X=74600 $Y=149675 $D=42
M34 3 3 3 VDDA pmos4 L=5e-06 W=8.35e-06 AD=7.0975e-12 AS=7.0975e-12 PD=1.005e-05 PS=1.005e-05 NRD=0.0508982 NRS=0.0508982 $X=74600 $Y=161425 $D=42
M35 1 1 1 VDDA pmos4 L=2e-06 W=5e-06 AD=4.25e-12 AS=4.25e-12 PD=6.7e-06 PS=6.7e-06 NRD=0.085 NRS=0.085 $X=118600 $Y=168425 $D=42
M36 1 1 1 VDDA pmos4 L=2e-06 W=5e-06 AD=4.25e-12 AS=4.25e-12 PD=6.7e-06 PS=6.7e-06 NRD=0.085 NRS=0.085 $X=193600 $Y=168425 $D=42
M37 2 2 2 VDDA pmos4 L=3e-05 W=1e-05 AD=8.5e-12 AS=8.5e-12 PD=1.17e-05 PS=1.17e-05 NRD=0.0425 NRS=0.0425 $X=224800 $Y=223000 $D=42
M38 34 1 1 VDDA pmos4 L=2e-06 W=5e-06 AD=4.25e-12 AS=4.25e-12 PD=6.7e-06 PS=6.7e-06 NRD=0.085 NRS=0.085 $X=11525 $Y=191575 $D=41
M39 2 3 VDDA VDDA pmos4 L=5e-06 W=8.35e-06 AD=7.0975e-12 AS=7.0975e-12 PD=1.005e-05 PS=1.005e-05 NRD=0.0508982 NRS=0.0508982 $X=30800 $Y=149675 $D=41
M40 3 3 VDDA VDDA pmos4 L=5e-06 W=8.35e-06 AD=7.0975e-12 AS=7.0975e-12 PD=1.005e-05 PS=1.005e-05 NRD=0.0508982 NRS=0.0508982 $X=30800 $Y=161425 $D=41
M41 3 3 VDDA VDDA pmos4 L=5e-06 W=8.35e-06 AD=7.0975e-12 AS=7.0975e-12 PD=1.005e-05 PS=1.005e-05 NRD=0.0508982 NRS=0.0508982 $X=38100 $Y=149675 $D=41
M42 2 3 VDDA VDDA pmos4 L=5e-06 W=8.35e-06 AD=7.0975e-12 AS=7.0975e-12 PD=1.005e-05 PS=1.005e-05 NRD=0.0508982 NRS=0.0508982 $X=38100 $Y=161425 $D=41
M43 2 3 VDDA VDDA pmos4 L=5e-06 W=8.35e-06 AD=7.0975e-12 AS=7.0975e-12 PD=1.005e-05 PS=1.005e-05 NRD=0.0508982 NRS=0.0508982 $X=45400 $Y=149675 $D=41
M44 3 3 VDDA VDDA pmos4 L=5e-06 W=8.35e-06 AD=7.0975e-12 AS=7.0975e-12 PD=1.005e-05 PS=1.005e-05 NRD=0.0508982 NRS=0.0508982 $X=45400 $Y=161425 $D=41
M45 3 3 VDDA VDDA pmos4 L=5e-06 W=8.35e-06 AD=7.0975e-12 AS=7.0975e-12 PD=1.005e-05 PS=1.005e-05 NRD=0.0508982 NRS=0.0508982 $X=52700 $Y=149675 $D=41
M46 2 3 VDDA VDDA pmos4 L=5e-06 W=8.35e-06 AD=7.0975e-12 AS=7.0975e-12 PD=1.005e-05 PS=1.005e-05 NRD=0.0508982 NRS=0.0508982 $X=52700 $Y=161425 $D=41
M47 2 3 VDDA VDDA pmos4 L=5e-06 W=8.35e-06 AD=7.0975e-12 AS=7.0975e-12 PD=1.005e-05 PS=1.005e-05 NRD=0.0508982 NRS=0.0508982 $X=60000 $Y=149675 $D=41
M48 3 3 VDDA VDDA pmos4 L=5e-06 W=8.35e-06 AD=7.0975e-12 AS=7.0975e-12 PD=1.005e-05 PS=1.005e-05 NRD=0.0508982 NRS=0.0508982 $X=60000 $Y=161425 $D=41
M49 3 3 VDDA VDDA pmos4 L=5e-06 W=8.35e-06 AD=7.0975e-12 AS=7.0975e-12 PD=1.005e-05 PS=1.005e-05 NRD=0.0508982 NRS=0.0508982 $X=67300 $Y=149675 $D=41
M50 2 3 VDDA VDDA pmos4 L=5e-06 W=8.35e-06 AD=7.0975e-12 AS=7.0975e-12 PD=1.005e-05 PS=1.005e-05 NRD=0.0508982 NRS=0.0508982 $X=67300 $Y=161425 $D=41
M51 VDDA 2 8 VDDA pmos4 L=3e-05 W=1e-05 AD=8.5e-12 AS=8.5e-12 PD=1.17e-05 PS=1.17e-05 NRD=0.0425 NRS=0.0425 $X=67300 $Y=223000 $D=41
M52 VDDA 2 26 VDDA pmos4 L=3e-05 W=1e-05 AD=8.5e-12 AS=8.5e-12 PD=1.17e-05 PS=1.17e-05 NRD=0.0425 NRS=0.0425 $X=112300 $Y=223000 $D=41
M53 23 1 OUT2 VDDA pmos4 L=2e-06 W=5e-06 AD=4.25e-12 AS=4.25e-12 PD=6.7e-06 PS=6.7e-06 NRD=0.085 NRS=0.085 $X=131100 $Y=168425 $D=41
M54 25 1 OUT4 VDDA pmos4 L=2e-06 W=5e-06 AD=4.25e-12 AS=4.25e-12 PD=6.7e-06 PS=6.7e-06 NRD=0.085 NRS=0.085 $X=143600 $Y=168425 $D=41
M55 27 1 OUT6 VDDA pmos4 L=2e-06 W=5e-06 AD=4.25e-12 AS=4.25e-12 PD=6.7e-06 PS=6.7e-06 NRD=0.085 NRS=0.085 $X=156100 $Y=168425 $D=41
M56 VDDA 2 28 VDDA pmos4 L=3e-05 W=1e-05 AD=8.5e-12 AS=8.5e-12 PD=1.17e-05 PS=1.17e-05 NRD=0.0425 NRS=0.0425 $X=157300 $Y=223000 $D=41
M57 28 1 OUT8 VDDA pmos4 L=2e-06 W=5e-06 AD=4.25e-12 AS=4.25e-12 PD=6.7e-06 PS=6.7e-06 NRD=0.085 NRS=0.085 $X=168600 $Y=168425 $D=41
M58 30 1 OUT10 VDDA pmos4 L=2e-06 W=5e-06 AD=4.25e-12 AS=4.25e-12 PD=6.7e-06 PS=6.7e-06 NRD=0.085 NRS=0.085 $X=181100 $Y=168425 $D=41
M59 VDDA 2 8 VDDA pmos4 L=3e-05 W=1e-05 AD=8.5e-12 AS=8.5e-12 PD=1.17e-05 PS=1.17e-05 NRD=0.0425 NRS=0.0425 $X=202300 $Y=223000 $D=41
X61 7 VRES GNDA cvar_CDNS_779828874975 $T=120200 14800 1 180 $X=100375 $Y=13250
X62 7 VRES GNDA cvar_CDNS_779828874975 $T=143350 14800 1 180 $X=123525 $Y=13250
X63 7 VRES GNDA cvar_CDNS_779828874975 $T=166500 14800 1 180 $X=146675 $Y=13250
X64 7 VRES GNDA cvar_CDNS_779828874975 $T=189650 14800 1 180 $X=169825 $Y=13250
X65 7 VRES GNDA cvar_CDNS_779828874975 $T=212800 14800 1 180 $X=192975 $Y=13250
X66 7 VRES GNDA cvar_CDNS_779828874975 $T=235950 14800 1 180 $X=216125 $Y=13250
X67 VDDA 32 2 ICV_1 $T=202300 253850 1 0 $X=201100 $Y=220950
X70 22 OUT1 1 VDDA ICV_2 $T=118600 171275 1 0 $X=117400 $Y=166375
X71 24 OUT3 1 VDDA ICV_2 $T=131100 171275 1 0 $X=129900 $Y=166375
X72 26 OUT5 1 VDDA ICV_2 $T=143600 171275 1 0 $X=142400 $Y=166375
X73 13 OUT7 1 VDDA ICV_2 $T=156100 171275 1 0 $X=154900 $Y=166375
X74 29 OUT9 1 VDDA ICV_2 $T=168600 171275 1 0 $X=167400 $Y=166375
X75 32 OUT11 1 VDDA ICV_2 $T=181100 171275 1 0 $X=179900 $Y=166375
X76 VDDA 8 22 23 2 ICV_3 $T=22300 253850 1 0 $X=21100 $Y=220950
X77 VDDA 24 25 8 2 ICV_3 $T=67300 253850 1 0 $X=66100 $Y=220950
X78 VDDA 27 8 13 2 ICV_3 $T=112300 253850 1 0 $X=111100 $Y=220950
X79 VDDA 8 29 30 2 ICV_3 $T=157300 253850 1 0 $X=156100 $Y=220950
X80 VDDA 34 34 VDDA pmos4_CDNS_779828874971 $T=11525 199475 1 0 $X=10325 $Y=195575
X81 8 VRES 1 VDDA pmos4_CDNS_779828874971 $T=101450 170825 1 0 $X=100250 $Y=166925
X82 6 2 3 VBG VRES GNDA ICV_5 $T=28850 57625 0 270 $X=28600 $Y=28725
X83 6 3 2 VRES VBG GNDA ICV_5 $T=28850 93775 0 270 $X=28600 $Y=64875
X84 6 2 3 VBG VRES GNDA ICV_5 $T=42050 57625 0 270 $X=41800 $Y=28725
X85 6 3 2 VRES VBG GNDA ICV_5 $T=42050 93775 0 270 $X=41800 $Y=64875
X86 6 2 3 VBG VRES GNDA ICV_5 $T=55250 57625 0 270 $X=55000 $Y=28725
X87 6 3 2 VRES VBG GNDA ICV_5 $T=55250 93775 0 270 $X=55000 $Y=64875
X88 6 2 3 VBG VRES GNDA ICV_5 $T=68450 57625 0 270 $X=68200 $Y=28725
X89 6 3 2 VRES VBG GNDA ICV_5 $T=68450 93775 0 270 $X=68200 $Y=64875
.ENDS
***************************************
