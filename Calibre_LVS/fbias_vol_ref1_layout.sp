* SPICE NETLIST
***************************************

.SUBCKT tsv80 TOP BOTTOM SUB
.ENDS
***************************************
.SUBCKT rx POS NEG
.ENDS
***************************************
.SUBCKT Q C B E S G
.ENDS
***************************************
.SUBCKT lddn D G S B
.ENDS
***************************************
.SUBCKT phd POS NEG P
.ENDS
***************************************
.SUBCKT sbd A C SUB
.ENDS
***************************************
.SUBCKT esddlv2 A C
.ENDS
***************************************
.SUBCKT esddlv A C SUB
.ENDS
***************************************
.SUBCKT lddp D G S B
.ENDS
***************************************
.SUBCKT probepad pad
.ENDS
***************************************
.SUBCKT L POS NEG SUB
.ENDS
***************************************
.SUBCKT L POS NEG MID SUB
.ENDS
***************************************
.SUBCKT hall A B C D S P1 P2
.ENDS
***************************************
.SUBCKT cvar_CDNS_779828615452 1 2 3
** N=3 EP=3 IP=0 FDC=2
M0 2 1 2 3 cvar w=0.00099 l=6.5e-07 cols=10 rows=15 $X=0 $Y=0 $D=62
D1 3 2 p_nwd AREA=2171.6 PJ=279.6 $X=-300 $Y=-300 $D=87
.ENDS
***************************************
.SUBCKT PD_C_CDNS_7798286154529
** N=1 EP=0 IP=0 FDC=0
.ENDS
***************************************
.SUBCKT PD_C_CDNS_7798286154532
** N=1 EP=0 IP=0 FDC=0
.ENDS
***************************************
.SUBCKT nmos4_CDNS_779828615453
** N=4 EP=0 IP=0 FDC=0
.ENDS
***************************************
.SUBCKT ICV_1
** N=7 EP=0 IP=8 FDC=0
.ENDS
***************************************
.SUBCKT PD_C_CDNS_7798286154531
** N=1 EP=0 IP=0 FDC=0
.ENDS
***************************************
.SUBCKT rpolyhc_CDNS_779828615450 1 2
** N=3 EP=2 IP=0 FDC=1
R0 1 2 L=2.5e-05 W=8e-07 $[rpolyh] $X=-800 $Y=1550 $D=18
.ENDS
***************************************
.SUBCKT P1_C_CDNS_7798286154521
** N=3 EP=0 IP=0 FDC=0
.ENDS
***************************************
.SUBCKT ICV_2 1 2 3 6 7 9
** N=9 EP=6 IP=14 FDC=3
M0 2 6 1 9 nmos4 L=5e-06 W=3.3e-05 AD=2.805e-11 AS=2.805e-11 PD=3.47e-05 PS=3.47e-05 NRD=0.0128788 NRS=0.0128788 $X=0 $Y=-21050 $D=37
M1 3 7 1 9 nmos4 L=5e-06 W=3.3e-05 AD=2.805e-11 AS=2.805e-11 PD=3.47e-05 PS=3.47e-05 NRD=0.0128788 NRS=0.0128788 $X=0 $Y=-13750 $D=37
M2 2 6 1 9 nmos4 L=5e-06 W=3.3e-05 AD=2.805e-11 AS=2.805e-11 PD=3.47e-05 PS=3.47e-05 NRD=0.0128788 NRS=0.0128788 $X=0 $Y=-6450 $D=37
.ENDS
***************************************
.SUBCKT pmos4_CDNS_779828615455
** N=5 EP=0 IP=0 FDC=0
.ENDS
***************************************
.SUBCKT ICV_3
** N=7 EP=0 IP=10 FDC=0
.ENDS
***************************************
.SUBCKT ICV_4 3 4 5 8
** N=9 EP=4 IP=14 FDC=2
M0 4 8 3 3 pmos4 L=1e-05 W=5e-06 AD=4.25e-12 AS=4.25e-12 PD=6.7e-06 PS=6.7e-06 NRD=0.085 NRS=0.085 $X=6300 $Y=850 $D=41
M1 5 8 3 3 pmos4 L=1e-05 W=5e-06 AD=4.25e-12 AS=4.25e-12 PD=6.7e-06 PS=6.7e-06 NRD=0.085 NRS=0.085 $X=12600 $Y=850 $D=41
.ENDS
***************************************
.SUBCKT P1_C_CDNS_779828615451
** N=2 EP=0 IP=0 FDC=0
.ENDS
***************************************
.SUBCKT nmos4_CDNS_779828615454 1 2 3
** N=3 EP=3 IP=0 FDC=1
M0 2 3 1 1 nmos4 L=1e-05 W=5e-06 AD=4.25e-12 AS=4.25e-12 PD=6.7e-06 PS=6.7e-06 NRD=0.085 NRS=0.085 $X=0 $Y=850 $D=37
.ENDS
***************************************
.SUBCKT ICV_5 1 2 3 4 5 6
** N=6 EP=6 IP=18 FDC=8
M0 4 4 4 4 nmos4 L=5e-06 W=3.3e-05 AD=2.805e-11 AS=2.805e-11 PD=3.47e-05 PS=3.47e-05 NRD=0.0128788 NRS=0.0128788 $X=0 $Y=850 $D=38
M1 3 6 1 4 nmos4 L=5e-06 W=3.3e-05 AD=2.805e-11 AS=2.805e-11 PD=3.47e-05 PS=3.47e-05 NRD=0.0128788 NRS=0.0128788 $X=0 $Y=-28350 $D=37
X2 1 2 3 5 6 4 ICV_2 $T=0 -29200 0 0 $X=-400 $Y=-51350
X3 1 2 3 5 6 4 ICV_2 $T=0 0 0 0 $X=-400 $Y=-22150
.ENDS
***************************************
.SUBCKT ICV_6 1 2 3 4
** N=5 EP=4 IP=18 FDC=8
M0 1 1 1 2 pmos4 L=1e-05 W=5e-06 AD=4.25e-12 AS=4.25e-12 PD=6.7e-06 PS=6.7e-06 NRD=0.085 NRS=0.085 $X=0 $Y=850 $D=42
M1 3 1 2 2 pmos4 L=1e-05 W=5e-06 AD=4.25e-12 AS=4.25e-12 PD=6.7e-06 PS=6.7e-06 NRD=0.085 NRS=0.085 $X=18900 $Y=850 $D=41
M2 4 1 2 2 pmos4 L=1e-05 W=5e-06 AD=4.25e-12 AS=4.25e-12 PD=6.7e-06 PS=6.7e-06 NRD=0.085 NRS=0.085 $X=25200 $Y=850 $D=41
M3 3 1 2 2 pmos4 L=1e-05 W=5e-06 AD=4.25e-12 AS=4.25e-12 PD=6.7e-06 PS=6.7e-06 NRD=0.085 NRS=0.085 $X=44100 $Y=850 $D=41
X4 2 3 4 1 ICV_4 $T=0 0 0 0 $X=-1200 $Y=-1200
X5 2 3 4 1 ICV_4 $T=25200 0 0 0 $X=24000 $Y=-1200
.ENDS
***************************************
.SUBCKT fbias_vol_ref1_layout BIAS VDDA GNDA VBG V1600 V1500 V1000
** N=32 EP=7 IP=239 FDC=108
R0 1 13 L=8.995e-05 W=2e-06 $[rpolyh] $X=342050 $Y=248400 $D=18
D1 GNDA GNDA p_nwd AREA=3481.19 PJ=240 $X=275800 $Y=154500 $D=87
D2 GNDA VDDA p_nwd AREA=6035.8 PJ=323.2 $X=226125 $Y=216950 $D=87
D3 GNDA VDDA p_nwd AREA=508.68 PJ=96.2 $X=333800 $Y=206850 $D=87
D4 GNDA GNDA p_nwd AREA=638.775 PJ=101.1 $X=337400 $Y=244100 $D=87
M5 GNDA GNDA GNDA GNDA nmos4 L=5e-06 W=3.3e-05 AD=2.805e-11 AS=2.805e-11 PD=3.47e-05 PS=3.47e-05 NRD=0.0128788 NRS=0.0128788 $X=339750 $Y=60200 $D=38
M6 GNDA GNDA GNDA GNDA nmos4 L=5e-06 W=3.3e-05 AD=2.805e-11 AS=2.805e-11 PD=3.47e-05 PS=3.47e-05 NRD=0.0128788 NRS=0.0128788 $X=339750 $Y=99500 $D=38
M7 5 VBG 1 GNDA nmos4 L=5e-06 W=3.3e-05 AD=2.805e-11 AS=2.805e-11 PD=3.47e-05 PS=3.47e-05 NRD=0.0128788 NRS=0.0128788 $X=303250 $Y=60200 $D=37
M8 5 9 4 GNDA nmos4 L=5e-06 W=3.3e-05 AD=2.805e-11 AS=2.805e-11 PD=3.47e-05 PS=3.47e-05 NRD=0.0128788 NRS=0.0128788 $X=303250 $Y=99500 $D=37
M9 5 VBG 1 GNDA nmos4 L=5e-06 W=3.3e-05 AD=2.805e-11 AS=2.805e-11 PD=3.47e-05 PS=3.47e-05 NRD=0.0128788 NRS=0.0128788 $X=332450 $Y=60200 $D=37
M10 5 9 4 GNDA nmos4 L=5e-06 W=3.3e-05 AD=2.805e-11 AS=2.805e-11 PD=3.47e-05 PS=3.47e-05 NRD=0.0128788 NRS=0.0128788 $X=332450 $Y=99500 $D=37
M11 4 4 4 VDDA pmos4 L=1e-05 W=5e-06 AD=4.25e-12 AS=4.25e-12 PD=6.7e-06 PS=6.7e-06 NRD=0.085 NRS=0.085 $X=309775 $Y=232150 $D=42
M12 4 4 4 VDDA pmos4 L=1e-05 W=5e-06 AD=4.25e-12 AS=4.25e-12 PD=6.7e-06 PS=6.7e-06 NRD=0.085 NRS=0.085 $X=309775 $Y=250350 $D=42
M13 VDDA 4 1 VDDA pmos4 L=1e-05 W=5e-06 AD=4.25e-12 AS=4.25e-12 PD=6.7e-06 PS=6.7e-06 NRD=0.085 NRS=0.085 $X=290875 $Y=232150 $D=41
M14 4 4 VDDA VDDA pmos4 L=1e-05 W=5e-06 AD=4.25e-12 AS=4.25e-12 PD=6.7e-06 PS=6.7e-06 NRD=0.085 NRS=0.085 $X=290875 $Y=250350 $D=41
M15 VDDA 1 14 VDDA pmos4 L=2e-05 W=1e-05 AD=8.5e-12 AS=8.5e-12 PD=1.17e-05 PS=1.17e-05 NRD=0.0425 NRS=0.0425 $X=337150 $Y=213050 $D=41
X16 13 14 GNDA cvar_CDNS_779828615452 $T=372725 42075 0 270 $X=371175 $Y=22250
X17 13 14 GNDA cvar_CDNS_779828615452 $T=372725 65225 0 270 $X=371175 $Y=45400
X18 13 14 GNDA cvar_CDNS_779828615452 $T=372725 88375 0 270 $X=371175 $Y=68550
X19 13 14 GNDA cvar_CDNS_779828615452 $T=372725 111525 0 270 $X=371175 $Y=91700
X20 13 14 GNDA cvar_CDNS_779828615452 $T=372725 134675 0 270 $X=371175 $Y=114850
X21 13 14 GNDA cvar_CDNS_779828615452 $T=372725 157825 0 270 $X=371175 $Y=138000
X22 13 14 GNDA cvar_CDNS_779828615452 $T=372725 180975 0 270 $X=371175 $Y=161150
X23 13 14 GNDA cvar_CDNS_779828615452 $T=372725 204125 0 270 $X=371175 $Y=184300
X24 13 14 GNDA cvar_CDNS_779828615452 $T=372725 227275 0 270 $X=371175 $Y=207450
X25 13 14 GNDA cvar_CDNS_779828615452 $T=372725 250425 0 270 $X=371175 $Y=230600
X26 13 14 GNDA cvar_CDNS_779828615452 $T=372725 273575 0 270 $X=371175 $Y=253750
X63 GNDA 16 rpolyhc_CDNS_779828615450 $T=289000 162050 0 90 $X=277350 $Y=156050
X64 16 17 rpolyhc_CDNS_779828615450 $T=282000 172050 1 90 $X=277350 $Y=166050
X65 17 15 rpolyhc_CDNS_779828615450 $T=289000 182050 0 90 $X=277350 $Y=176050
X66 15 10 rpolyhc_CDNS_779828615450 $T=282000 196050 0 270 $X=277350 $Y=186050
X67 18 24 rpolyhc_CDNS_779828615450 $T=292300 166050 0 270 $X=287650 $Y=156050
X68 20 18 rpolyhc_CDNS_779828615450 $T=299300 176050 1 270 $X=287650 $Y=166050
X69 19 20 rpolyhc_CDNS_779828615450 $T=292300 186050 0 270 $X=287650 $Y=176050
X70 V1600 19 rpolyhc_CDNS_779828615450 $T=299300 196050 1 270 $X=287650 $Y=186050
X71 9 21 rpolyhc_CDNS_779828615450 $T=302600 162050 1 90 $X=297950 $Y=156050
X72 22 9 rpolyhc_CDNS_779828615450 $T=309600 176050 1 270 $X=297950 $Y=166050
X73 V1500 V1600 rpolyhc_CDNS_779828615450 $T=309600 182050 0 90 $X=297950 $Y=176050
X74 10 30 rpolyhc_CDNS_779828615450 $T=302600 192050 1 90 $X=297950 $Y=186050
X75 28 V1000 rpolyhc_CDNS_779828615450 $T=312900 162050 1 90 $X=308250 $Y=156050
X76 21 23 rpolyhc_CDNS_779828615450 $T=312900 172050 1 90 $X=308250 $Y=166050
X77 V1000 22 rpolyhc_CDNS_779828615450 $T=319900 186050 1 270 $X=308250 $Y=176050
X78 23 V1500 rpolyhc_CDNS_779828615450 $T=319900 192050 0 90 $X=308250 $Y=186050
X79 24 26 rpolyhc_CDNS_779828615450 $T=323200 162050 1 90 $X=318550 $Y=156050
X80 26 25 rpolyhc_CDNS_779828615450 $T=330200 172050 0 90 $X=318550 $Y=166050
X81 25 27 rpolyhc_CDNS_779828615450 $T=323200 182050 1 90 $X=318550 $Y=176050
X82 27 14 rpolyhc_CDNS_779828615450 $T=330200 192050 0 90 $X=318550 $Y=186050
X83 31 28 rpolyhc_CDNS_779828615450 $T=340500 166050 1 270 $X=328850 $Y=156050
X84 29 31 rpolyhc_CDNS_779828615450 $T=333500 176050 0 270 $X=328850 $Y=166050
X85 32 29 rpolyhc_CDNS_779828615450 $T=340500 186050 1 270 $X=328850 $Y=176050
X86 30 32 rpolyhc_CDNS_779828615450 $T=333500 196050 0 270 $X=328850 $Y=186050
X91 5 4 1 9 VBG GNDA ICV_2 $T=309100 60200 0 90 $X=302150 $Y=59800
X92 5 1 4 VBG 9 GNDA ICV_2 $T=309100 99500 0 90 $X=302150 $Y=99100
X93 VDDA 4 1 4 ICV_4 $T=290875 243000 1 0 $X=289675 $Y=230100
X94 VDDA 1 4 4 ICV_4 $T=290875 249500 0 0 $X=289675 $Y=248300
X97 GNDA 5 BIAS nmos4_CDNS_779828615454 $T=250400 163000 0 90 $X=238450 $Y=162600
X98 GNDA BIAS BIAS nmos4_CDNS_779828615454 $T=250400 170700 0 90 $X=238450 $Y=170300
X99 GNDA BIAS BIAS nmos4_CDNS_779828615454 $T=262700 163000 0 90 $X=250750 $Y=162600
X100 GNDA 5 BIAS nmos4_CDNS_779828615454 $T=262700 170700 0 90 $X=250750 $Y=170300
X101 5 4 1 GNDA 9 VBG ICV_5 $T=250700 60200 0 90 $X=243750 $Y=59800
X102 5 1 4 GNDA VBG 9 ICV_5 $T=250700 99500 0 90 $X=243750 $Y=99100
X103 4 VDDA 4 1 ICV_6 $T=240475 243000 1 0 $X=239275 $Y=230100
X104 4 VDDA 1 4 ICV_6 $T=240475 249500 0 0 $X=239275 $Y=248300
.ENDS
***************************************
