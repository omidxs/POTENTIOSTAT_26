ADE simulation setup
Run mode: Single Run, Sweeps and Corners
Tests:
  DC: FBIAS/fbias_vol_ref_tb/config, simulator spectre
    Variables: VBG = 1.2; VDD = 3.3; VDD_STEP = 0; VGB_STEP = 10m
    Outputs: VDC("/R1/PLUS"); VT("/V1600"); V1600; V1500
  DC_MC (off): FBIAS/fbias_vol_ref_tb/schematic, simulator spectre
    Variables: VBG = 1.2; VDD = 0; VDD_STEP = 3.3; VGB_STEP = 0
    Outputs: VDC("/R1/PLUS"); VT("/V1600"); V1600; V1500
Corners (all switched off):
  model folders: /opt/pdk/ams/410/spectre/c35
  every corner: /opt/pdk/ams/410/spectre/c35/processOption.scs, /opt/pdk/ams/410/spectre/c35/cmos53.scs[cmoswo cmoswp cmosws cmoswz], /opt/pdk/ams/410/spectre/c35/bip.scs[biptm], /opt/pdk/ams/410/spectre/c35/ind.scs[indtm], /opt/pdk/ams/410/spectre/c35/esddiode.scs[esddiodetm]
  CMOS (off): res.scs[restm], cap.scs[captm]
  CMOS_VDD (off): VDD=2.97 3.63; res.scs[restm], cap.scs[captm]
  CMOS_VDD_TEMP (off): temperature=-40 85; VDD=2.97 3.63; res.scs[restm], cap.scs[captm]
  CMOS_RES_CAP_VDD_TEMP: temperature=-40 85; VDD=2.97 3.63; res.scs[reswp resws], cap.scs[capwp capws]
  CMOS_RES_CAP_TEMP (off): temperature=-40 85; res.scs[reswp resws], cap.scs[capwp capws]
