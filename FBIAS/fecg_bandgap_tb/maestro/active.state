ADE simulation setup
Test ECG_IA_ecg_bandgap_tb_1: ECG_IA/ecg_bandgap_tb/schematic, simulator spectre
  Models: /opt/pdk/ams/410/spectre/c35/processOption.scs, /opt/pdk/ams/410/spectre/c35/cmos53.scs[cmostm], /opt/pdk/ams/410/spectre/c35/res.scs[restm], /opt/pdk/ams/410/spectre/c35/cap.scs[captm], /opt/pdk/ams/410/spectre/c35/bip.scs[biptm], /opt/pdk/ams/410/spectre/c35/ind.scs[indtm], /opt/pdk/ams/410/spectre/c35/esddiode.scs[esddiodetm]
  Variables: VDD = 3.3; VDD_PULSE = 0; VDD_RISE = 1u
  Temperature: 27
  Simulator options: reltol=100e-6 homotopy=all limit=delta additionalArgs=enable_pre_ver=yes ignorezerovar=yes
  Files: definitions /opt/pdk/ams/410/spectre/c35/soac/soac.scs
  Analysis dc: sweep VDD start=0 stop=3.3 step=20m (saves the operating point)
  Output VDC("/BG_REF")
  Signals: /BG_REF
Test DC: FECG/fecg_bandgap_tb/schematic, simulator spectre
  Models: /opt/pdk/ams/410/spectre/c35/processOption.scs, /opt/pdk/ams/410/spectre/c35/cmos53.scs[cmostm], /opt/pdk/ams/410/spectre/c35/res.scs[restm], /opt/pdk/ams/410/spectre/c35/cap.scs[captm], /opt/pdk/ams/410/spectre/c35/bip.scs[biptm], /opt/pdk/ams/410/spectre/c35/ind.scs[indtm], /opt/pdk/ams/410/spectre/c35/esddiode.scs[esddiodetm]
  Variables: VDD = 3.3; VDD_PULSE = 0; VDD_RISE = 1u
  Temperature: 27
  Simulator options: reltol=100e-6 homotopy=all limit=delta additionalArgs=enable_pre_ver=yes ignorezerovar=yes
  Files: definitions /opt/pdk/ams/410/spectre/c35/soac/soac.scs
  Analysis noise: start=0.01 stop=100M dec=30 p=/BG_REF
  Analysis dc: sweep VDD start=0 stop=3.3 step=20m (saves the operating point)
  Analysis xf: start=0.01 stop=100M dec=20 p=/BG_REF
  Output VDC("/BG_REF")
  Output v /BG_REF; dc (V) = v("/BG_REF" ?result "dc")
  Output Output_noise_Vrms = sqrt(totalNoise("noise" 0.01 100000000 nil))
  Output Output_noise_ECG_Vrms = sqrt(totalNoise("noise" 0.01 250 nil))
  Output PSRR = db(getData("/V0" ?result "xf"))
  Signals: /BG_REF
Test DC_MC: FECG/fecg_bandgap_tb/schematic, simulator spectre
  Models: /opt/pdk/ams/410/spectre/c35/processOption.scs, /opt/pdk/ams/410/spectre/c35/cmos53.scs[cmosmc], /opt/pdk/ams/410/spectre/c35/res.scs[resmc], /opt/pdk/ams/410/spectre/c35/cap.scs[capmc], /opt/pdk/ams/410/spectre/c35/bip.scs[bipmc], /opt/pdk/ams/410/spectre/c35/ind.scs[indmc], /opt/pdk/ams/410/spectre/c35/esddiode.scs[esddiodemc]
  Variables: VDD = 3.3; VDD_PULSE = 0; VDD_RISE = 1u
  Temperature: 27
  Simulator options: reltol=100e-6 homotopy=all limit=delta additionalArgs=enable_pre_ver=yes ignorezerovar=yes
  Files: definitions /opt/pdk/ams/410/spectre/c35/soac/soac.scs
  Analysis dc: sweep VDD start=0 stop=3.3 step=20m (saves the operating point)
  Analysis xf: start=0.01 stop=100M dec=20 p=/BG_REF
  Output VDC("/BG_REF")
  Output v /BG_REF; dc (V) = v("/BG_REF" ?result "dc")
  Output PSRR = db(getData("/V0" ?result "xf"))
  Signals: /BG_REF
Test DC_TEMP: FECG/fecg_bandgap_tb/schematic, simulator spectre
  Models: /opt/pdk/ams/410/spectre/c35/processOption.scs, /opt/pdk/ams/410/spectre/c35/cmos53.scs[cmostm], /opt/pdk/ams/410/spectre/c35/res.scs[restm], /opt/pdk/ams/410/spectre/c35/cap.scs[captm], /opt/pdk/ams/410/spectre/c35/bip.scs[biptm], /opt/pdk/ams/410/spectre/c35/ind.scs[indtm], /opt/pdk/ams/410/spectre/c35/esddiode.scs[esddiodetm]
  Variables: VDD = 3.3; VDD_PULSE = 0; VDD_RISE = 1u
  Temperature: 27
  Simulator options: reltol=100e-6 homotopy=all limit=delta additionalArgs=enable_pre_ver=yes ignorezerovar=yes
  Files: definitions /opt/pdk/ams/410/spectre/c35/soac/soac.scs
  Analysis dc: sweep temperature start=-40 stop=85 step=1 (saves the operating point)
  Output VDC("/BG_REF")
  Output v /BG_REF; dc (V) = v("/BG_REF" ?result "dc")
  Signals: /BG_REF
Test TRAN_VDD: FBIAS/fecg_bandgap_tb/config, simulator spectre
  Models: /opt/pdk/ams/410/spectre/c35/processOption.scs, /opt/pdk/ams/410/spectre/c35/cmos53.scs[cmostm], /opt/pdk/ams/410/spectre/c35/res.scs[restm], /opt/pdk/ams/410/spectre/c35/cap.scs[captm], /opt/pdk/ams/410/spectre/c35/bip.scs[biptm], /opt/pdk/ams/410/spectre/c35/ind.scs[indtm], /opt/pdk/ams/410/spectre/c35/esddiode.scs[esddiodetm]
  Variables: VDD = 3.3; VDD_PULSE = 20m; VDD_RISE = 1u
  Temperature: 27
  Simulator options: reltol=100e-6 homotopy=all limit=delta additionalArgs=enable_pre_ver=yes ignorezerovar=yes
  Files: definitions /opt/pdk/ams/410/spectre/c35/soac/soac.scs
  Analysis tran: stop=100u errpreset=conservative
  Output VT("/BG_REF") (unticked)
  Signals: /BG_REF
Test TRAN_VDD_MC: FBIAS/fecg_bandgap_tb/config, simulator spectre
  Models: /opt/pdk/ams/410/spectre/c35/processOption.scs, /opt/pdk/ams/410/spectre/c35/cmos53.scs[cmosmc], /opt/pdk/ams/410/spectre/c35/res.scs[resmc], /opt/pdk/ams/410/spectre/c35/cap.scs[capmc], /opt/pdk/ams/410/spectre/c35/bip.scs[bipmc], /opt/pdk/ams/410/spectre/c35/ind.scs[indmc], /opt/pdk/ams/410/spectre/c35/esddiode.scs[esddiodemc]
  Variables: VDD = 0; VDD_PULSE = 3.3; VDD_RISE = 1u
  Temperature: 27
  Simulator options: reltol=100e-6 homotopy=all limit=delta additionalArgs=enable_pre_ver=yes ignorezerovar=yes
  Files: definitions /opt/pdk/ams/410/spectre/c35/soac/soac.scs
  Analysis tran: stop=100u errpreset=conservative
  Output VT("/BG_REF") (unticked)
  Signals: /BG_REF
