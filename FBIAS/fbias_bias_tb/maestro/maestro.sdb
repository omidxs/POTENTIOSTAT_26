ADE simulation setup
Run mode: Single Run, Sweeps and Corners
Tests:
  DC: FBIAS/fbias_bias_tb/schematic, simulator spectre
    Variables: VDD = 3.3; VDD_PULSE = 0; VDD_TR = 1u
    Outputs: V1600; Vnoise_rms_100MHz; Vnoise_rms_200Hz; PSRR_1Hz; IBIAS
  DC_MC (off): FBIAS/fbias_bias_tb/schematic, simulator spectre
    Variables: VDD = 3.3; VDD_PULSE = 0; VDD_TR = 1u
    Outputs: V1600; Vnoise_rms_100MHz; Vnoise_rms_200Hz; PSRR_1Hz; IBIAS
  TRAN (off): FBIAS/fbias_bias_tb/schematic, simulator spectre
    Variables: VDD = 0; VDD_PULSE = 3.3; VDD_TR = 1m
    Outputs: /V1600; /VDD; /POR_L; /R1/PLUS; /VRES; Bias_BG; BG_V
  TRAN_MC (off): FBIAS/fbias_bias_tb/schematic, simulator spectre
    Variables: VDD = 0; VDD_PULSE = 3.3; VDD_TR = 1m
    Outputs: /V1600; /VDD; /POR_L; /R1/PLUS; /VRES; Bias_BG; BG_V
Corners (all switched off):
  model folders: /opt/pdk/ams/410/spectre/c35
  every corner: /opt/pdk/ams/410/spectre/c35/processOption.scs, /opt/pdk/ams/410/spectre/c35/cmos53.scs[cmoswo cmoswp cmosws cmoswz], /opt/pdk/ams/410/spectre/c35/ind.scs[indtm], /opt/pdk/ams/410/spectre/c35/esddiode.scs[esddiodetm]
  CMOS (off): res.scs[restm], cap.scs[captm], bip.scs[biptm]
  CMOS_VDD (off): VDD=2.97 3.63; res.scs[restm], cap.scs[captm], bip.scs[biptm]
  CMOS_VDD_TEMP (off): temperature=-40 85; VDD=2.97 3.63; res.scs[restm], cap.scs[captm], bip.scs[biptm]
  CMOS_RES_CAP_VDD_TEMP (off): temperature=-40 85; VDD=2.97 3.63; res.scs[reswp resws], cap.scs[capwp capws], bip.scs[biptm]
  CMOS_RES_CAP_TEMP (off): temperature=-40 85; res.scs[reswp resws], cap.scs[capwp capws], bip.scs[biptm]
  CMOS_RES_BIP_VDD_TEMP (off): temperature=-40 85; VDD=2.97 3.63; res.scs[reswp resws], cap.scs[captm], bip.scs[biphb biphs biplb]
  CMOS_RES_BIP_TEMP (off): temperature=-40 85; res.scs[reswp resws], cap.scs[captm], bip.scs[biphb biphs biplb]
  CMOS_RES_CAP_BIP_TEMP: temperature=-40 85; res.scs[reswp resws], cap.scs[capwp capws], bip.scs[biphb biphs biplb]
  CMOS_RES_CAP_BIP_VDD_TEMP (off): temperature=-40 85; VDD=2.97 3.63; res.scs[reswp resws], cap.scs[capwp capws], bip.scs[biphb biphs biplb]
