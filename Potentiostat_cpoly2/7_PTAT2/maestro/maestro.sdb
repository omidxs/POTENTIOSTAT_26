ADE simulation setup
Run mode: Single Run, Sweeps and Corners
Tests:
  Potentiostat_7_PTAT2_1: Potentiostat_cpoly2/7_PTAT2/schematic, simulator spectre
    Outputs: /V_ptat
Corners:
  model folders: /opt/pdk/ams/410/spectre/c35/soac
  C0: processOption.scs, cmos53.scs[cmoswo cmoswp cmosws cmoswz], res.scs[reswp resws]
