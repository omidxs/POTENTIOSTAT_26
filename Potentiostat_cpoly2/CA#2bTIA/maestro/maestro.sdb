ADE simulation setup
Run mode: Single Run, Sweeps and Corners
Tests:
  ac_DC: Potentiostat_cpoly2/CA+TIA/schematic7, simulator spectre
    Variables: R_ct = 1M; Vb = 1.7; vdd = 3.3; vddpuls = 0; vpuls = 0; vref = 1.65; vtran = 20m
    Outputs: /vogm; /CE; /RE
  Tran (off): Potentiostat_cpoly2/CA+TIA/schematic7, simulator spectre
    Variables: R_ct = 1M; Vb = 1.7; vdd = 3.3; vddpuls = 0; vpuls = 100m; vref = 1.65; vtran = 0
    Outputs: /Vin; /CE; /RE
