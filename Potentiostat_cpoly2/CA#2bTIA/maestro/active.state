ADE simulation setup
Test Potentiostat_CA+TIA_1: Potentiostat/CA+TIA/schematic7, simulator spectre
  Models: /opt/pdk/ams/410/spectre/c35/soac/processOption.scs, /opt/pdk/ams/410/spectre/c35/soac/cmos53.scs[cmostm], /opt/pdk/ams/410/spectre/c35/soac/res.scs[restm], /opt/pdk/ams/410/spectre/c35/soac/cap.scs[captm], /opt/pdk/ams/410/spectre/c35/soac/bip.scs[biptm], /opt/pdk/ams/410/spectre/c35/soac/ind.scs[indtm], /opt/pdk/ams/410/spectre/c35/soac/esddiode.scs[esddiodetm]
  Variables: R_ct = 1M; Vb = 1.7; vdd = 3.3; vddpuls = 0; vpuls = 0; vref = 1.65; vtran = 20m
  Temperature: 27
  Simulator options: reltol=100e-6 homotopy=all limit=delta additionalArgs=enable_pre_ver=yes ignorezerovar=yes
  Files: definitions /opt/pdk/ams/410/spectre/c35/soac/soac.scs
  Analysis dc: (saves the operating point)
  Analysis ac: start=1m stop=1G dec=25
  Analysis noise: start=1m stop=1G dec=30 p=/Vout iprobe=/V1
  Output rmsNoise(0.001 100000)
  Signals: /CE, /RE
Test ac_DC: Potentiostat_cpoly2/CA+TIA/schematic7, simulator spectre
  Models: /opt/pdk/ams/410/spectre/c35/soac/processOption.scs, /opt/pdk/ams/410/spectre/c35/soac/cmos53.scs[cmostm], /opt/pdk/ams/410/spectre/c35/soac/res.scs[restm], /opt/pdk/ams/410/spectre/c35/soac/cap.scs[captm], /opt/pdk/ams/410/spectre/c35/soac/bip.scs[biptm], /opt/pdk/ams/410/spectre/c35/soac/ind.scs[indtm], /opt/pdk/ams/410/spectre/c35/soac/esddiode.scs[esddiodetm]
  Variables: R_ct = 1M; Vb = 1.7; vdd = 3.3; vddpuls = 0; vpuls = 0; vref = 1.65; vtran = 20m
  Temperature: 27
  Simulator options: reltol=100e-6 homotopy=all limit=delta additionalArgs=enable_pre_ver=yes ignorezerovar=yes
  Files: definitions /opt/pdk/ams/410/spectre/c35/soac/soac.scs
  Analysis dc: (saves the operating point)
  Analysis ac: start=1m stop=1G dec=25
  Analysis noise: start=1m stop=1G dec=30 p=/Vout iprobe=/V1
  Output rmsNoise(0.001 100000)
  Output bandwidth(VF("/vogm") 3 "low")
  Signals: /vogm, /CE, /RE
Test Tran: Potentiostat_cpoly2/CA+TIA/schematic7, simulator spectre
  Models: /opt/pdk/ams/410/spectre/c35/soac/processOption.scs, /opt/pdk/ams/410/spectre/c35/soac/cmos53.scs[cmostm], /opt/pdk/ams/410/spectre/c35/soac/res.scs[restm], /opt/pdk/ams/410/spectre/c35/soac/cap.scs[captm], /opt/pdk/ams/410/spectre/c35/soac/bip.scs[biptm], /opt/pdk/ams/410/spectre/c35/soac/ind.scs[indtm], /opt/pdk/ams/410/spectre/c35/soac/esddiode.scs[esddiodetm]
  Variables: R_ct = 1M; Vb = 1.7; vdd = 3.3; vddpuls = 0; vpuls = 100m; vref = 1.65; vtran = 0
  Temperature: 27
  Simulator options: reltol=100e-6 homotopy=all limit=delta additionalArgs=enable_pre_ver=yes ignorezerovar=yes
  Files: definitions /opt/pdk/ams/410/spectre/c35/soac/soac.scs
  Analysis tran: stop=3 errpreset=conservative
  Analysis dc: (saves the operating point)
  Signals: /Vin, /CE, /RE
