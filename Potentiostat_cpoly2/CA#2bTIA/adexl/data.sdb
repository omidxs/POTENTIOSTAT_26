ADE simulation setup
Run mode: Single Run, Sweeps and Corners
Tests:
  Potentiostat_cpoly2:CA:1: Potentiostat_cpoly2/CA+TIA/schematic6, simulator spectre
  MC (off): Potentiostat_cpoly2/CA+TIA/schematic6, simulator spectre
  Linearity (off): Potentiostat_cpoly2/CA+TIA/schematic6, simulator spectre
Global variables:
  Cc = 6p (off)
  vdd = 3.3
  vpuls = 10m
  vtran = 0
  Cdl = 10u
  Rct = 500k
  Rs_ce = 1k
  Rs_re = 1k
  vref = 1.65
  Vb = 1.7
  vddpuls = 0
  I_EC = 300n (off)
  R_ct = 1M
Corners (all switched off):
  model folders: /opt/pdk/ams/410/spectre/c35/soac
  CMOS (off): processOption.scs, cmos53.scs[cmoswo cmoswp cmosws cmoswz], res.scs[reswp resws], cap.scs[capwp capws]
  CMOS_current (off): R_ct=mag((VAR( "Vb" )-VAR( "vref" ))/10n), mag((VAR( "Vb" )-VAR( "vref" ))/500n); processOption.scs, cmos53.scs[cmoswo cmoswp cmosws cmoswz], res.scs[reswp resws], cap.scs[capwp capws]
  CMOS_current_Temp (off): temperature=-40 85; R_ct=mag((VAR( "Vb" )-VAR( "vref" ))/10n), mag((VAR( "Vb" )-VAR( "vref" ))/500n); processOption.scs, cmos53.scs[cmoswo cmoswp cmosws cmoswz], res.scs[reswp resws], cap.scs[capwp capws]
  CMOS_current_Temp_VDD: temperature=-40 85; R_ct=mag((VAR( "Vb" )-VAR( "vref" ))/10n), mag((VAR( "Vb" )-VAR( "vref" ))/500n); vdd=2.97 3.63; processOption.scs, cmos53.scs[cmoswo cmoswp cmosws cmoswz], res.scs[reswp resws], cap.scs[capwp capws]
  Load (off): Rct=600k 400k; Rs_re=5k 10k 1k; Rs_ce=5k 10k 1k; Cdl=1u 1n 100n 1p; processOption.scs, cmos53.scs[cmostm], res.scs[restm], cap.scs[captm], bip.scs[biptm]
  Cell current (off): R_ct=mag((VAR( "Vb" )-VAR( "vref" ))/10n), mag((VAR( "Vb" )-VAR( "vref" ))/500n)
