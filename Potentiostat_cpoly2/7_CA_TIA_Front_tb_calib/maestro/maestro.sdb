ADE simulation setup
Run mode: Single Run, Sweeps and Corners
Tests:
  Potentiostat_7_CA_TIA_Front_tb_calib_1: Potentiostat_cpoly2/7_CA_TIA_Front_tb_calib/config, simulator spectre
    Variables: Idc = 0; Iin_TIA_AC = 0; Ipulse = 0; Vin_CA_AC = 1; vpuls = -50m; Vb = 1.7
    Outputs: /CE; /RE; /Vout; Bias error; Output noise; CA Error; rmsNoise(0.001 100000); PSRR; /VDDA; TIA_Error_Adjusted; Phase Margin; MUX leakage; MUX voltage drop; VDC("/I25/net8"); (VDC("/I25/net8") - VDC("/net1")); (VDC("/vref") - VDC("/net1")); ((VDC("/net1") - VDC("/Vout")) / IDC("/I25/IPRB0/PLUS")); Vout_noise/Rf; rmsNoise(0.01 100000)
  TIA_Gain_Linearity (off): Potentiostat_cpoly2/7_CA_TIA_Front_tb_calib/config, simulator spectre
    Variables: Idc = 0; Iin_TIA_AC = 1; Ipulse = 0; Vin_CA_AC = 0; vpuls = 0; Vb = 1.615
    Outputs: /Vout; deriv(VS("/Vout")); rmsNoise(0.001 100000)
  MC (off): Potentiostat_cpoly2/7_CA_TIA_Front_tb_calib/config, simulator spectre
    Variables: Idc = 0; Iin_TIA_AC = 0; Ipulse = 0; Vin_CA_AC = 1; vpuls = -50m; Vb = 1.7
    Outputs: /CE; /RE; /Vout; Bias error; Output noise; CA Error; rmsNoise(0.001 100000); PSRR; /VDDA; TIA_Error_Adjusted; Phase Margin; MUX leakage; MUX voltage drop; (VDC("/I25/net8") - VDC("/net1")); (VDC("/vref") - VDC("/net1")); Vout_noise/Rf
  PTAT (off): Potentiostat_cpoly2/7_CA_TIA_Front_tb_calib/schematic6, simulator spectre
    Variables: Idc = 0; Iin_TIA_AC = 0; Ipulse = 0; Vin_CA_AC = 0; vpuls = 0; Vb = 1.7
    Outputs: /V_ptat_inv; Sensitivity; Slope; PSRR
  PTAT_MC (off): Potentiostat_cpoly2/7_CA_TIA_Front_tb_calib/schematic6, simulator spectre
    Variables: Idc = 0; Iin_TIA_AC = 0; Ipulse = 0; Vin_CA_AC = 0; vpuls = 0; Vb = 1.7
    Outputs: /V_ptat_inv; Sensitivity; Slope; PSRR
Global variables:
  Cdl = 10n
  vdd = 3.3
  vtran = 0
  vref = 1.615
  Vb = 1.7 (off)
  vddpuls = 0
  R_ct = 500k
  Cdl_CE = 10n
  Rct_CE = 100k
  Rs_CE = 10k
  Rs_WE = 10k
  PTAT_EN = 1
  Calib_EN = 0
  S0 = 0
  S1 = 0
  S2 = 1
  S3 = 0
Corners (all switched off):
  model folders: /opt/pdk/ams/410/spectre/c35/soac
  CMOS_VDD_CAP_RES_BJT (off): vdd=2.97 3.63; processOption.scs, cmos53.scs[cmoswz cmosws cmoswp cmoswo], res.scs[reswp resws], cap.scs[capwp capws], bip.scs[biphb biphs biplb]
  CMOS_VDD_RES_Temp (off): temperature=-40 27 85; vdd=2.97 3.63; processOption.scs, cmos53.scs[cmoswz cmosws cmoswp cmoswo], res.scs[reswp resws], cap.scs[captm], bip.scs[biptm]
  CMOS (off): processOption.scs, cmos53.scs[cmoswo cmoswp cmosws cmoswz], res.scs[restm], cap.scs[captm], bip.scs[biptm]
  Temp (off): temperature=-40 -35 -30 -25 -20 -15 -10 -5 0 5 10 15 20 25 30 35 40 45 50 55 60 65 70 75 80 85; processOption.scs, cmos53.scs[cmostm], res.scs[restm], cap.scs[captm], bip.scs[biptm]
  CMOS_current (off): R_ct=mag((VAR( "Vb" )-VAR( "vref" ))/10n), mag((VAR( "Vb" )-VAR( "vref" ))/500n); processOption.scs, cmos53.scs[cmoswo cmoswp cmosws cmoswz], res.scs[restm], cap.scs[captm], bip.scs[biptm]
  CMOS_current_Temp_Res_Cap (off): temperature=-40 85; R_ct=mag((VAR( "Vb" )-VAR( "vref" ))/10n), mag((VAR( "Vb" )-VAR( "vref" ))/500n); processOption.scs, cmos53.scs[cmoswo cmoswp cmosws cmoswz], res.scs[reswp resws], cap.scs[capwp capws], bip.scs[biptm]
  CMOS_current_Temp_Res_Cap_VDD_BJT (off): temperature=-40 85; vdd=2.97 3.63; R_ct=mag((VAR( "Vb" )-VAR( "vref" ))/100n), mag((VAR( "Vb" )-VAR( "vref" ))/400n); processOption.scs, cmos53.scs[cmoswo cmoswp cmosws cmoswz], res.scs[reswp resws], cap.scs[capwp capws], bip.scs[biphb biphs biplb]
  CMOS_Temp_Res_Cap_BJT (off): processOption.scs, cmos53.scs[cmoswo cmoswp cmosws cmoswz], res.scs[reswp resws], cap.scs[capwp capws], bip.scs[biphb biphs biplb]
  CMOS_VDD_Res_Cap_Temp: temperature=-40 85; vdd=2.97 3.63; processOption.scs, cmos53.scs[cmoswo cmoswp cmosws cmoswz], res.scs[reswp resws], cap.scs[capwp capws], bip.scs[biptm]
  CMOS_VDD_Res_Cap_Temp_BJT (off): temperature=-40 85; vdd=2.97 3.63; processOption.scs, cmos53.scs[cmoswo cmoswp cmosws cmoswz], res.scs[reswp resws], cap.scs[capwp capws], bip.scs[biphb biphs biplb]
  CMOS_Temp_VDD (off): temperature=-40 85; vdd=2.97 3.63; R_ct=mag((VAR( "Vb" )-VAR( "vref" ))/500n); processOption.scs, cmos53.scs[cmoswo cmoswp cmosws cmoswz], res.scs[reswp resws], cap.scs[capwp capws], bip.scs[biptm]
  Load_Current for 1M (off): R_ct=mag((VAR( "Vb" )-VAR( "vref" ))/350n), mag((VAR( "Vb" )-VAR( "vref" ))/1u); Cdl=1u 1n 10n 100n; Rs_CE=1k 20k; Cdl_CE=10p 1n 1u; Rct_CE=10k; Rs_WE=1k 20k; Vb=1.765 1.715; S1=1; S2=0; S3=0; processOption.scs, cmos53.scs[cmostm], res.scs[restm], cap.scs[captm], bip.scs[biptm]
  Load_Current for 3M (off): R_ct=mag((VAR( "Vb" )-VAR( "vref" ))/100n), mag((VAR( "Vb" )-VAR( "vref" ))/350n); Cdl=1u 1n 10n 100n; Rs_CE=1k 20k; Cdl_CE=10p 1n 1u; Rct_CE=10k; Rs_WE=1k 20k; Vb=1.765 1.715; S1=0; S2=1; S3=0; processOption.scs, cmos53.scs[cmostm], res.scs[restm], cap.scs[captm], bip.scs[biptm]
  Load_Current for 10M (off): R_ct=mag((VAR( "Vb" )-VAR( "vref" ))/10n), mag((VAR( "Vb" )-VAR( "vref" ))/100n); Cdl=1u 1n 10n 100n; Rs_CE=1k 20k; Cdl_CE=10p 1n 1u; Rct_CE=10k; Rs_WE=1k 20k; Vb=1.765 1.715; S1=0; S2=0; S3=1; processOption.scs, cmos53.scs[cmostm], res.scs[restm], cap.scs[captm], bip.scs[biptm]
  Cell current (off): R_ct=mag((VAR( "Vb" )-VAR( "vref" ))/10n), mag((VAR( "Vb" )-VAR( "vref" ))/500n)
