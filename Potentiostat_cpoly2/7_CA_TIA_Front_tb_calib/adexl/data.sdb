ADE simulation setup
Run mode: Single Run, Sweeps and Corners
Tests:
  Potentiostat_cpoly2:CA:1: Potentiostat_cpoly2/7_CA_TIA_Front_tb_calib/config, simulator spectre
  TIA_Gain_linearity (off): Potentiostat_cpoly2/7_CA_TIA_Front_tb_calib/schematic6, simulator spectre
  MC (off): Potentiostat_cpoly2/7_CA_TIA_Front_tb_calib/schematic6, simulator spectre
  PTAT (off): Potentiostat_cpoly2/7_CA_TIA_Front_tb_calib/schematic6, simulator spectre
Global variables:
  vdd = 3.3
  vpuls = 0 (off)
  vtran = 0
  vref = 1.615
  Vb = 1.7
  vddpuls = 0
  R_ct = 1M
  Ib8 = 200n
  Ib9 = 200n
  Cdl = 10n
  Cdl_CE = 10n
  Rct_CE = 100k
  Rs_CE = 10k
  Rs_WE = 10k
  Iin_TIA_AC = 0 (off)
  Vin_CA_AC = 1 (off)
  Ipulse = 50n (off)
  Idc = 0
  PTAT_EN = 0
  Calib_EN = 0
Corners (all switched off):
  model folders: /opt/pdk/ams/410/spectre/c35/soac
  CMOS (off): processOption.scs, cmos53.scs[cmoswo cmoswp cmosws cmoswz], res.scs[reswp resws], cap.scs[capwp capws], bip.scs[biptm]
  CMOS_current (off): R_ct=mag((VAR( "Vb" )-VAR( "vref" ))/10n), mag((VAR( "Vb" )-VAR( "vref" ))/500n); processOption.scs, cmos53.scs[cmoswo cmoswp cmosws cmoswz], res.scs[reswp resws], cap.scs[capwp capws], bip.scs[biptm]
  CMOS_current_Temp (off): temperature=-40 85; R_ct=mag((VAR( "Vb" )-VAR( "vref" ))/10n), mag((VAR( "Vb" )-VAR( "vref" ))/500n); processOption.scs, cmos53.scs[cmoswo cmoswp cmosws cmoswz], res.scs[reswp resws], cap.scs[capwp capws], bip.scs[biptm]
  CMOS_current_Temp_VDD_BJT (off): temperature=-40 85; R_ct=mag((VAR( "Vb" )-VAR( "vref" ))/10n), mag((VAR( "Vb" )-VAR( "vref" ))/500n); vdd=2.97 3.63; processOption.scs, cmos53.scs[cmoswo cmoswp cmosws cmoswz], res.scs[reswp resws], cap.scs[capwp capws], bip.scs[biphb biphs biplb]
  CMOS_VDD_BJT: vdd=2.97 3.63; processOption.scs, cmos53.scs[cmoswo cmoswp cmosws cmoswz], res.scs[reswp resws], cap.scs[capwp capws], bip.scs[biphb biphs biplb]
  CMOS_current_Temp_BJT (off): temperature=-40 85; R_ct=mag((VAR( "Vb" )-VAR( "vref" ))/10n), mag((VAR( "Vb" )-VAR( "vref" ))/500n); processOption.scs, cmos53.scs[cmoswo cmoswp cmosws cmoswz], res.scs[reswp resws], cap.scs[capwp capws], bip.scs[biphb biphs biplb]
  CMOS_Temp_VDD (off): temperature=-40 85; R_ct=mag((VAR( "Vb" )-VAR( "vref" ))/500n); vdd=2.97 3.63; processOption.scs, cmos53.scs[cmoswo cmoswp cmosws cmoswz], res.scs[reswp resws], cap.scs[capwp capws], bip.scs[biptm]
  Load (off): R_ct=mag((VAR( "Vb" )-VAR( "vref" ))/10n), mag((VAR( "Vb" )-VAR( "vref" ))/500n); Cdl=1u 1n 10n 100n; Rs_CE=1k 20k; Cdl_CE=10p 1n 1u; Rct_CE=10k 1M; Rs_WE=1k 20k; Vb=1.633 1.65; processOption.scs, cmos53.scs[cmostm], res.scs[restm], cap.scs[captm], bip.scs[biptm]
  Cell current (off): R_ct=mag((VAR( "Vb" )-VAR( "vref" ))/10n), mag((VAR( "Vb" )-VAR( "vref" ))/500n)
