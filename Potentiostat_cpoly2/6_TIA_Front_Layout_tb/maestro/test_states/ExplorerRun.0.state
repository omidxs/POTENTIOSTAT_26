ADE simulation setup
Test Linearity_MC: Potentiostat/6_TIA_tb/schematic, simulator spectre
  Models: /opt/pdk/ams/410/spectre/c35/soac/processOption.scs, /opt/pdk/ams/410/spectre/c35/soac/cmos53.scs[cmosmc], /opt/pdk/ams/410/spectre/c35/soac/res.scs[resmc], /opt/pdk/ams/410/spectre/c35/soac/cap.scs[capmc], /opt/pdk/ams/410/spectre/c35/soac/bip.scs[bipmc], /opt/pdk/ams/410/spectre/c35/soac/ind.scs[indmc], /opt/pdk/ams/410/spectre/c35/soac/esddiode.scs[esddiodemc]
  Variables: Iin_dc = -1u; vddpulse = 0; Vb = 1.75; Itran = 100n; vdd = 3.3; Cdl = 10n; Ib9 = 200n; Iin_TIA_AC = 1; Ipulse = 0; R_ct = 1M; vref = 1.65
  Temperature: 27
  Simulator options: reltol=100e-6 homotopy=all limit=delta additionalArgs=enable_pre_ver=yes ignorezerovar=yes
  Files: definitions /opt/pdk/ams/410/spectre/c35/soac/soac.scs
  Analysis tran: stop=800m errpreset=conservative
  Analysis dc: sweep Iin_dc start=-5u stop=5u lin=500 (saves the operating point)
  Output deriv(VS("/Vout"))
  Output dB20(dft(VT("/Vout") 0 0.8 1024 "Rectangular" 1 "default" 1.0))
  Output HD2 = (value(dB20(dft(VT("/Vout") 0 0.8 1024 "Rectangular" 1 "default" 1.0)) 20) - value(dB20(dft(VT("/Vout") 0 0.8 1024 "Rectangular" 1 "default" 1.0)) 10))
  Signals: /Vout
