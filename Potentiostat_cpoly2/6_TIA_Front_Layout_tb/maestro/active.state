ADE simulation setup
Test Potentiostat_6_TIA_tb_1: Potentiostat_cpoly2/6_TIA_tb/schematic, simulator spectre
  Models: /opt/pdk/ams/410/spectre/c35/soac/processOption.scs, /opt/pdk/ams/410/spectre/c35/soac/cmos53.scs[cmostm], /opt/pdk/ams/410/spectre/c35/soac/res.scs[restm], /opt/pdk/ams/410/spectre/c35/soac/cap.scs[captm], /opt/pdk/ams/410/spectre/c35/soac/bip.scs[biptm], /opt/pdk/ams/410/spectre/c35/soac/ind.scs[indtm], /opt/pdk/ams/410/spectre/c35/soac/esddiode.scs[esddiodetm]
  Variables: Iin_dc = 0; vddpulse = 0; Vb = 1.75; Itran = 0; vdd = 3.3; Cdl = 10n; Ib9 = 200n; Iin_TIA_AC = 1; Ipulse = 100n; R_ct = 1M; vref = 1.65
  Temperature: 27
  Simulator options: reltol=100e-6 homotopy=all limit=delta additionalArgs=enable_pre_ver=yes ignorezerovar=yes
  Files: definitions /opt/pdk/ams/410/spectre/c35/soac/soac.scs
  Analysis pz: p=/Vout iprobe=/I26 freq=1
  Analysis tran: stop=800m errpreset=conservative
  Analysis noise: start=1m stop=1G dec=30 p=/Vout iprobe=/I26
  Analysis stb: start=1m stop=1G dec=30 probe=/IPRB2 stbProbeMode=single-ended
  Analysis dc: (saves the operating point)
  Analysis ac: start=1m stop=1G dec=30
  Analysis xf: start=1m stop=1G dec=30 p=/Vout
  Output v /Vout; ac mag(V) = vfreq('ac "/Vout")
  Output rmsNoise(0.001 100000)
  Output v /Vout; tran (V) = vtime('tran "/Vout")
  Output output noise; V / sqrt(Hz) = getData("out" ?result "noise")
  Output Loop Gain dB20 = db(mag(getData("loopGain" ?result "stb")))
  Output Loop Gain Phase = phaseDegUnwrapped(getData("loopGain" ?result "stb"))
  Output Poles = pzFrequencyAndRealFilter(getData("poles" ?result "pz") ?freqfilter 1000000.0)
  Output Zeros = pzFrequencyAndRealFilter(getData("zeros" ?result "pz") ?freqfilter 1000000.0)
  Output V/V /V1; xf dB20(V/V) = db(getData("/V1" ?result "xf"))
Test Linearity: Potentiostat_cpoly2/6_TIA_tb/schematic, simulator spectre
  Models: /opt/pdk/ams/410/spectre/c35/soac/processOption.scs, /opt/pdk/ams/410/spectre/c35/soac/cmos53.scs[cmostm], /opt/pdk/ams/410/spectre/c35/soac/res.scs[restm], /opt/pdk/ams/410/spectre/c35/soac/cap.scs[captm], /opt/pdk/ams/410/spectre/c35/soac/bip.scs[biptm], /opt/pdk/ams/410/spectre/c35/soac/ind.scs[indtm], /opt/pdk/ams/410/spectre/c35/soac/esddiode.scs[esddiodetm]
  Variables: Iin_dc = -1u; vddpulse = 0; Vb = 1.75; Itran = 100n; vdd = 3.3; Cdl = 10n; Ib9 = 200n; Iin_TIA_AC = 1; Ipulse = 0; R_ct = 1M; vref = 1.65
  Temperature: 27
  Simulator options: reltol=100e-6 homotopy=all limit=delta additionalArgs=enable_pre_ver=yes ignorezerovar=yes
  Files: definitions /opt/pdk/ams/410/spectre/c35/soac/soac.scs
  Analysis tran: stop=800m errpreset=conservative
  Analysis dc: sweep Iin_dc start=-5u stop=5u lin=500 (saves the operating point)
  Output deriv(VS("/Vout"))
  Output dB20(dft(VT("/Vout") 0 0.8 1024 "Rectangular" 1 "default" 1.0))
  Output HD2 = (value(dB20(dft(VT("/Vout") 0 0.8 1024 "Rectangular" 1 "default" 1.0)) 20) - value(dB20(dft(VT("/Vout") 0 0.8 1024 "Rectangular" 1 "default" 1.0)) 10))
  Signals: /Vout
Test MC: Potentiostat_cpoly2/6_TIA_tb/schematic, simulator spectre
  Models: /opt/pdk/ams/410/spectre/c35/soac/processOption.scs, /opt/pdk/ams/410/spectre/c35/soac/cmos53.scs[cmosmc], /opt/pdk/ams/410/spectre/c35/soac/res.scs[resmc], /opt/pdk/ams/410/spectre/c35/soac/cap.scs[capmc], /opt/pdk/ams/410/spectre/c35/soac/bip.scs[bipmc], /opt/pdk/ams/410/spectre/c35/soac/ind.scs[indmc], /opt/pdk/ams/410/spectre/c35/soac/esddiode.scs[esddiodemc]
  Variables: Iin_dc = 0; vddpulse = 0; Vb = 1.75; Itran = 0; vdd = 3.3; Cdl = 10n; Ib9 = 200n; Iin_TIA_AC = 1; Ipulse = 100n; R_ct = 1M; vref = 1.65
  Temperature: 27
  Simulator options: reltol=100e-6 homotopy=all limit=delta additionalArgs=enable_pre_ver=yes ignorezerovar=yes
  Files: definitions /opt/pdk/ams/410/spectre/c35/soac/soac.scs
  Analysis stb: start=1m stop=1G dec=30 probe=/IPRB2 stbProbeMode=single-ended
  Analysis pz: p=/Vout iprobe=/I26 freq=1
  Analysis tran: stop=800m errpreset=conservative
  Analysis noise: start=1m stop=1G dec=30 p=/Vout iprobe=/I26
  Analysis xf: start=1m stop=1G dec=30 p=/Vout
  Analysis dc: (saves the operating point)
  Analysis ac: start=1m stop=1G dec=30
  Output v /Vout; ac mag(V) = vfreq('ac "/Vout")
  Output rmsNoise(0.001 100000)
  Output v /Vout; tran (V) = vtime('tran "/Vout")
  Output output noise; V / sqrt(Hz) = getData("out" ?result "noise") (unticked)
  Output Loop Gain dB20 = db(mag(getData("loopGain" ?result "stb")))
  Output Loop Gain Phase = phaseDegUnwrapped(getData("loopGain" ?result "stb"))
  Output Poles = pzFrequencyAndRealFilter(getData("poles" ?result "pz") ?freqfilter 1000000.0)
  Output Zeros = pzFrequencyAndRealFilter(getData("zeros" ?result "pz") ?freqfilter 1000000.0)
  Output V/V /V1; xf dB20(V/V) = db(getData("/V1" ?result "xf"))
Test Linearity_MC: Potentiostat_cpoly2/6_TIA_tb/schematic, simulator spectre
  Models: /opt/pdk/ams/410/spectre/c35/soac/processOption.scs, /opt/pdk/ams/410/spectre/c35/soac/cmos53.scs[cmosmc], /opt/pdk/ams/410/spectre/c35/soac/res.scs[resmc], /opt/pdk/ams/410/spectre/c35/soac/cap.scs[capmc], /opt/pdk/ams/410/spectre/c35/soac/bip.scs[bipmc], /opt/pdk/ams/410/spectre/c35/soac/ind.scs[indmc], /opt/pdk/ams/410/spectre/c35/soac/esddiode.scs[esddiodemc]
  Variables: Iin_dc = -1u; vddpulse = 0; Vb = 1.75; Itran = 50n; vdd = 3.3; Cdl = 10n; Ib9 = 200n; Iin_TIA_AC = 1; Ipulse = 0; R_ct = 1M; vref = 1.65
  Temperature: 27
  Simulator options: reltol=100e-6 homotopy=all limit=delta additionalArgs=enable_pre_ver=yes ignorezerovar=yes
  Files: definitions /opt/pdk/ams/410/spectre/c35/soac/soac.scs
  Analysis tran: stop=800m errpreset=conservative
  Analysis dc: sweep Iin_dc start=-5u stop=5u lin=500 (saves the operating point)
  Output deriv(VS("/Vout"))
  Output dB20(dft(VT("/Vout") 0 0.8 1024 "Rectangular" 1 "default" 1.0))
  Output HD2 = (value(dB20(dft(VT("/Vout") 0 0.8 1024 "Rectangular" 1 "default" 1.0)) 20) - value(dB20(dft(VT("/Vout") 0 0.8 1024 "Rectangular" 1 "default" 1.0)) 10))
  Signals: /Vout
Run mode: Single Run, Sweeps and Corners
Corners:
  model folders: /opt/pdk/ams/410/spectre/c35/soac
  C0 (off): vdd=2.97 3.63; processOption.scs, cmos53.scs[cmoswo cmoswp cmosws cmoswz], res.scs[reswp resws], cap.scs[capwp capws], bip.scs[biptm], ind.scs[indtm], esddiode.scs[esddiodetm]
  C0_copy_0 (off): processOption.scs, cmos53.scs[cmoswo cmoswp cmosws cmoswz], res.scs[reswp resws], cap.scs[capwp capws], bip.scs[biptm], ind.scs[indtm], esddiode.scs[esddiodetm]
Disabled tests: Linearity, Linearity_1, Linearity_MC, MC
