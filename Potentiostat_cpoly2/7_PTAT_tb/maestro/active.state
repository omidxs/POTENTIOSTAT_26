ADE simulation setup
Test Potentiostat_7_my_bandgap_1_1: Potentiostat/7_PTAT/schematic, simulator spectre
  Models: /opt/pdk/ams/410/spectre/c35/soac/processOption.scs, /opt/pdk/ams/410/spectre/c35/soac/cmos53.scs[cmosmc], /opt/pdk/ams/410/spectre/c35/soac/res.scs[resmc], /opt/pdk/ams/410/spectre/c35/soac/cap.scs[capmc], /opt/pdk/ams/410/spectre/c35/soac/bip.scs[bipmc], /opt/pdk/ams/410/spectre/c35/soac/ind.scs[indmc], /opt/pdk/ams/410/spectre/c35/soac/esddiode.scs[esddiodemc]
  Temperature: 27
  Simulator options: reltol=100e-6 homotopy=all limit=delta additionalArgs=enable_pre_ver=yes ignorezerovar=yes
  Files: definitions /opt/pdk/ams/410/spectre/c35/soac/soac.scs
  Analysis noise: start=1m stop=1G dec=20 p=/Vo
  Analysis dc: sweep temperature start=-40 stop=85 step=1 (saves the operating point)
  Output PTAT_sensitiv = ((ymax(VS("/V_ptat")) - ymin(VS("/V_ptat"))) / 165)
  Output rmsNoise(0.001 100000)
  Output Sensor_sensitiv = ((ymax(VS("/Vo")) - ymin(VS("/Vo"))) / 165)
  Signals: /V_ptat, /Vo
Test MC: Potentiostat_cpoly2/7_PTAT_tb/schematic, simulator spectre
  Models: /opt/pdk/ams/410/spectre/c35/soac/processOption.scs, /opt/pdk/ams/410/spectre/c35/soac/cmos53.scs[cmosmc], /opt/pdk/ams/410/spectre/c35/soac/res.scs[resmc], /opt/pdk/ams/410/spectre/c35/soac/cap.scs[capmc], /opt/pdk/ams/410/spectre/c35/soac/bip.scs[bipmc], /opt/pdk/ams/410/spectre/c35/soac/ind.scs[indmc], /opt/pdk/ams/410/spectre/c35/soac/esddiode.scs[esddiodemc]
  Temperature: 27
  Simulator options: reltol=100e-6 homotopy=all limit=delta additionalArgs=enable_pre_ver=yes ignorezerovar=yes
  Files: definitions /opt/pdk/ams/410/spectre/c35/soac/soac.scs
  Analysis dc: sweep temperature start=-40 stop=85 step=1 (saves the operating point)
  Analysis noise: start=1m stop=1G dec=20 p=/V_ptat_inv
  Output rmsNoise(0.001 100000)
  Output Sensor_sensitiv = ((ymax(VS("/V_ptat_inv")) - ymin(VS("/V_ptat_inv"))) / 165)
  Signals: /V_ptat_inv
Test Potentiostat_7_my_bandgap_1: Potentiostat_cpoly2/7_PTAT_tb/schematic, simulator spectre
  Models: /opt/pdk/ams/410/spectre/c35/soac/processOption.scs, /opt/pdk/ams/410/spectre/c35/soac/cmos53.scs[cmostm], /opt/pdk/ams/410/spectre/c35/soac/res.scs[restm], /opt/pdk/ams/410/spectre/c35/soac/cap.scs[captm], /opt/pdk/ams/410/spectre/c35/soac/bip.scs[biptm], /opt/pdk/ams/410/spectre/c35/soac/ind.scs[indtm], /opt/pdk/ams/410/spectre/c35/soac/esddiode.scs[esddiodetm]
  Variables: vdd = 3.3
  Temperature: 27.0
  Simulator options: reltol=100e-6 homotopy=all limit=delta additionalArgs=enable_pre_ver=yes ignorezerovar=yes
  Files: definitions /opt/pdk/ams/410/spectre/c35/soac/soac.scs
  Analysis tran: stop=5 errpreset=conservative
  Output rmsNoise(0.001 100000)
  Output Sensor_sensitiv = ((ymax(VS("/V_ptat_inv")) - ymin(VS("/V_ptat_inv"))) / 165)
  Signals: /V_ptat_inv, /I14/V_ptat
Test PTAT: Potentiostat_cpoly2/7_PTAT_tb/schematic, simulator spectre
  Models: /opt/pdk/ams/410/spectre/c35/soac/processOption.scs, /opt/pdk/ams/410/spectre/c35/soac/cmos53.scs[cmostm], /opt/pdk/ams/410/spectre/c35/soac/res.scs[restm], /opt/pdk/ams/410/spectre/c35/soac/cap.scs[captm], /opt/pdk/ams/410/spectre/c35/soac/bip.scs[biptm], /opt/pdk/ams/410/spectre/c35/soac/ind.scs[indtm], /opt/pdk/ams/410/spectre/c35/soac/esddiode.scs[esddiodetm]
  Variables: vddpulse = 0; vdd = 3.3
  Temperature: 27.0
  Simulator options: reltol=100e-6 homotopy=all limit=delta additionalArgs=enable_pre_ver=yes ignorezerovar=yes
  Files: definitions /opt/pdk/ams/410/spectre/c35/soac/soac.scs
  Analysis noise: start=1m stop=1G dec=20 p=/V_ptat_inv
  Analysis stb: start=1m stop=1G dec=20 probe=/I14/IPRB0 stbProbeMode=single-ended
  Analysis dc: sweep temperature start=-40 stop=85 step=1 (saves the operating point)
  Analysis xf: start=1m stop=1G dec=20 p=/V_ptat_inv
  Output rmsNoise(0.001 100000)
  Output Sensor_sensitiv = ((ymax(VS("/V_ptat_inv")) - ymin(VS("/V_ptat_inv"))) / 165)
  Output v /VDDA; tran (V) = vtime('tran "/VDDA")
  Output V/V /V1; xf mag(V/V) = getData("/V1" ?result "xf")
  Signals: /V_ptat_inv, /I14/V_ptat
