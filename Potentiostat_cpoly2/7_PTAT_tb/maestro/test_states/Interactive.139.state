ADE simulation setup
Test PTAT: Potentiostat/7_PTAT_tb/schematic, simulator spectre
  Models: /opt/pdk/ams/410/spectre/c35/soac/processOption.scs, /opt/pdk/ams/410/spectre/c35/soac/cmos53.scs[cmostm], /opt/pdk/ams/410/spectre/c35/soac/res.scs[restm], /opt/pdk/ams/410/spectre/c35/soac/cap.scs[captm], /opt/pdk/ams/410/spectre/c35/soac/bip.scs[biptm], /opt/pdk/ams/410/spectre/c35/soac/ind.scs[indtm], /opt/pdk/ams/410/spectre/c35/soac/esddiode.scs[esddiodetm]
  Variables: vddpulse = 0; vdd = 3.3
  Temperature: 27.0
  Simulator options: reltol=100e-6 homotopy=all limit=delta additionalArgs=enable_pre_ver=yes ignorezerovar=yes
  Files: definitions /opt/pdk/ams/410/spectre/c35/soac/soac.scs
  Analysis noise: start=1m stop=1G dec=20 p=/V_ptat_inv
  Analysis stb: start=1m stop=1G dec=20 probe=/I14/IPRB0 stbProbeMode=single-ended
  Analysis dc: sweep temperature start=-40 stop=85 step=1 (saves the operating point)
  Analysis xf: start=1m stop=1G dec=20 p=/V_ptat_inv
  Output rmsNoise(0.001 100000)
  Output Sensor_sensitiv = ((ymax(VS("/V_ptat_inv")) - ymin(VS("/V_ptat_inv"))) / 165)
  Output v /VDDA; tran (V) = vtime('tran "/VDDA")
  Signals: /V_ptat_inv, /I14/V_ptat
Test MC: Potentiostat/7_PTAT_tb/schematic, simulator spectre
  Models: /opt/pdk/ams/410/spectre/c35/soac/processOption.scs, /opt/pdk/ams/410/spectre/c35/soac/cmos53.scs[cmosmc], /opt/pdk/ams/410/spectre/c35/soac/res.scs[resmc], /opt/pdk/ams/410/spectre/c35/soac/cap.scs[capmc], /opt/pdk/ams/410/spectre/c35/soac/bip.scs[bipmc], /opt/pdk/ams/410/spectre/c35/soac/ind.scs[indmc], /opt/pdk/ams/410/spectre/c35/soac/esddiode.scs[esddiodemc]
  Temperature: 27
  Simulator options: reltol=100e-6 homotopy=all limit=delta additionalArgs=enable_pre_ver=yes ignorezerovar=yes
  Files: definitions /opt/pdk/ams/410/spectre/c35/soac/soac.scs
  Analysis noise: start=1m stop=1G dec=20 p=/V_ptat_inv
  Analysis dc: sweep temperature start=-40 stop=85 step=1 (saves the operating point)
  Output rmsNoise(0.001 100000)
  Output Sensor_sensitiv = ((ymax(VS("/V_ptat_inv")) - ymin(VS("/V_ptat_inv"))) / 165)
  Signals: /V_ptat_inv
