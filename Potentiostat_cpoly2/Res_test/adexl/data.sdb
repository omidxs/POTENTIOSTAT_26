ADE simulation setup
Run mode: Monte Carlo Sampling
Tests:
  Potentiostat_cpoly2:Res_test:1: Potentiostat_cpoly2/Res_test/schematic, simulator spectre
  MC: Potentiostat_cpoly2/Res_test/schematic, simulator spectre
Global variables:
  vdc = 800m
Corners (all switched off):
  model folders: /opt/pdk/ams/410/spectre/c35/soac
  C1 (off): processOption.scs, cmos53.scs[cmoswo cmoswp cmosws cmoswz], res.scs[restm restmwn reswp resws], cap.scs[captm], bip.scs[biptm], ind.scs[indtm], esddiode.scs[esddiodetm]
Monte Carlo Sampling options: mcmethod=all, mcnumpoints=200, parasiticanalysis=0
