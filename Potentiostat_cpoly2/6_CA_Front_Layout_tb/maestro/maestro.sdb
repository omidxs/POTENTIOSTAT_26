ADE simulation setup
Run mode: Single Run, Sweeps and Corners
Tests:
  Potentiostat_6_CA_tb_1: Potentiostat_cpoly2/6_CA_Front_Layout_tb/config, simulator spectre
    Variables: Cdl = 10n; Cdl_CE = 10n; Ib8 = 200n; Iin_TIA_AC = 1; Ipulse = 0; R_ct = 1M; Rct_CE = 100k; Rs_CE = 10k; Rs_WE = 10k; Vb = 1.7; vdd = 3.3; vddpuls = 0; Vin_CA_AC = 0; vpuls = 100m; vref = 1.65; vtran = 0
    Outputs: "/RE"; /Vout; /RE
