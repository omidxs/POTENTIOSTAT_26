ADE simulation setup
Test Potentiostat_6_CA_tb_1: Potentiostat_cpoly2/6_CA_tb/schematic, simulator spectre
  Models: /opt/pdk/ams/410/spectre/c35/soac/processOption.scs, /opt/pdk/ams/410/spectre/c35/soac/cmos53.scs[cmostm], /opt/pdk/ams/410/spectre/c35/soac/res.scs[restm], /opt/pdk/ams/410/spectre/c35/soac/cap.scs[captm], /opt/pdk/ams/410/spectre/c35/soac/bip.scs[biptm], /opt/pdk/ams/410/spectre/c35/soac/ind.scs[indtm], /opt/pdk/ams/410/spectre/c35/soac/esddiode.scs[esddiodetm]
  Variables: Cdl = 10n; Cdl_CE = 10n; Ib8 = 200n; Iin_TIA_AC = 1; Ipulse = 0; R_ct = 1M; Rct_CE = 100k; Rs_CE = 10k; Rs_WE = 10k; Vb = 1.7; vdd = 3.3; vddpuls = 0; Vin_CA_AC = 0; vpuls = 100m; vref = 1.65; vtran = 0
  Temperature: 27
  Simulator options: reltol=100e-6 homotopy=all limit=delta additionalArgs=enable_pre_ver=yes ignorezerovar=yes
  Files: definitions /opt/pdk/ams/410/spectre/c35/soac/soac.scs
  Analysis pz: p=/Vout iprobe=/V1 freq=1
  Analysis tran: stop=800m errpreset=conservative
  Analysis noise: start=1m stop=1G p=/Vout iprobe=/V1
  Analysis stb: start=1m stop=1G dec=30 probe=/IPRB2 stbProbeMode=single-ended
  Analysis dc: (saves the operating point)
  Analysis ac: start=1m stop=1G dec=30
  Output rmsNoise(0.001 100000)
  Output Poles = pzFrequencyAndRealFilter(getData("poles" ?result "pz") ?freqfilter 100000.0)
  Output Zeros = pzFrequencyAndRealFilter(getData("zeros" ?result "pz") ?freqfilter 100000.0)
  Signals: /RE, /Vout
Run mode: Single Run, Sweeps and Corners
