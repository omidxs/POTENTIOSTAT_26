ADE simulation setup
Run mode: Single Run, Sweeps and Corners
Tests:
  Potentiostat_cpoly2:CA:1: Potentiostat_cpoly2/TIA/schematic6, simulator spectre
  MC (off): Potentiostat_cpoly2/CA+TIA/schematic5, simulator spectre
  Linearity: Potentiostat_cpoly2/TIA/schematic6, simulator spectre
Global variables:
  Cc = 2p
  vdd = 3.3
  vpuls = 100m (off)
  vtran = 0 (off)
  Cdl = 10u (off)
  Rct = 500k (off)
  Rs_ce = 1k (off)
  Rs_re = 1k (off)
  vref = 1.65
  Vb = 1.85 (off)
  vddpuls = 0
  I_EC = 300n (off)
  R_ct = mag((VAR( "Vb" )-VAR( "vref" ))/10n), mag((VAR( "Vb" )-VAR( "vref" ))/500n) (off)
  Idc = 0
Corners:
  model folders: /opt/pdk/ams/410/spectre/c35/soac
  every corner: /opt/pdk/ams/410/spectre/c35/soac/processOption.scs
  CMOS (off): cmos53.scs[cmoswo cmoswp cmosws cmoswz], res.scs[reswp resws], cap.scs[capwp capws]
  Load (off): Rct=600k 400k; Rs_re=5k 10k 1k; Rs_ce=5k 10k 1k; Cdl=1u 1n 100n 1p; cmos53.scs[cmostm], res.scs[restm], cap.scs[captm], bip.scs[biptm]
  CMOS_Temp (off): temperature=-40 85; cmos53.scs[cmoswo cmoswp cmosws cmoswz], res.scs[reswp resws], cap.scs[capwp capws]
  CMOS_Temp_Vdd (off): temperature=-40 85; vdd=2.97 3.63; cmos53.scs[cmoswo cmoswp cmosws cmoswz], res.scs[reswp resws], cap.scs[capwp capws]
